* Synopsys Nettran: RHEL64 N-2017.12-SP1-2.4087669 2018/03/09
* Created:  3/11/2019  16:32
* Options: -verilog Tec_Riscv_pads_phy.v -outType SPICE -outName Tec_Riscv_pads_phy.sp

.GLOBAL VSS

.SUBCKT baud_XTAL_CLK20000000_BAUD19200_CLK_DIV32_CW9 sys_clk sys_rst_l uart_clk
+ VSS VDD_1V8
XU11 n7 VSS VDD_1V8 clk_div[1] INHDLLX0
XU17 n7 VSS clk_div[2] clk_div[0] VDD_1V8 clk_div[3] n10 NO4I3HDLLX0
XU19 VSS clk_div[4] n10 VDD_1V8 n11 NA2HDLLX0
XU5 n5 VSS VDD_1V8 clk_div[2] INHDLLX0
XU4 n12 VSS VDD_1V8 clk_div[5] INHDLLX0
XU6 VSS VDD_1V8 clk_div[6] clk_div[7] n5 n2 clk_div[1] NA4I3HDLLX0
XU7 n4 VSS VDD_1V8 clk_div[0] INHDLLX0
XU21 VSS n13 n12 n11 VDD_1V8 NO2HDLLX0
XU25 n15 VSS VDD_1V8 clk_div[7] INHDLLX0
XU23 VSS clk_div[6] n13 VDD_1V8 n14 NA2HDLLX0
XU8 VSS VDD_1V8 n12 clk_div[8] n4 n3 n2 NA4I3HDLLX0
XU16 n8 VSS clk_div[0] clk_div[1] VDD_1V8 clk_div[2] NA3HDLLX0
XU15 n9 VSS VDD_1V8 clk_div[3] INHDLLX0
XU13 VSS clk_div[0] clk_div[1] VDD_1V8 n6 NA2HDLLX0
XU9 n17 VSS VDD_1V8 clk_div[3] n3 clk_div[4] NO3HDLLX0
XU26 VSS n16 n15 n14 VDD_1V8 NO2HDLLX0
XU10 VSS N14 clk_div[0] n17 VDD_1V8 NO2HDLLX0
XU12 VSS VDD_1V8 N15 n7 clk_div[1] clk_div[0] n4 AN22HDLLX0
XU14 N16 VSS VDD_1V8 n6 n5 clk_div[2] clk_div[1] clk_div[0] AN32HDLLX0
XU18 n8 VSS n10 n9 VDD_1V8 N17 AN21HDLLX0
XU20 clk_div[4] VDD_1V8 n10 VSS n11 N18 OA21HDLLX0
XU22 VSS VDD_1V8 N19 n12 n11 n17 n13 AN211HDLLX0
XU24 clk_div[6] VDD_1V8 n13 VSS n14 N20 OA21HDLLX0
XU27 n14 VSS n16 n15 VDD_1V8 N21 AN21HDLLX0
XU28 VSS VDD_1V8 N22 clk_div[8] n16 EO2HDLLX0
XU29 VSS VDD_1V8 n1 n17 uart_clk EO2HDLLX0
Xplace3 n18 VSS VDD_1V8 sys_rst_l INHDLLX0
Xclk_div_reg_8_ n18 sys_clk N22 clk_div[8] VSS VDD_1V8 DFRRQHDLLX0
Xclk_div_reg_7_ n18 sys_clk N21 clk_div[7] VSS VDD_1V8 DFRRQHDLLX0
Xclk_div_reg_6_ n18 sys_clk N20 clk_div[6] VSS VDD_1V8 DFRRQHDLLX0
Xclk_div_reg_5_ n18 sys_clk N19 clk_div[5] VSS VDD_1V8 DFRRQHDLLX0
Xclk_div_reg_4_ n18 sys_clk N18 clk_div[4] VSS VDD_1V8 DFRRQHDLLX0
Xclk_div_reg_3_ n18 sys_clk N17 clk_div[3] VSS VDD_1V8 DFRRQHDLLX0
Xclk_div_reg_2_ n18 sys_clk N16 clk_div[2] VSS VDD_1V8 DFRRQHDLLX0
Xclk_div_reg_1_ n18 sys_clk N15 clk_div[1] VSS VDD_1V8 DFRRQHDLLX0
Xuart_clk_reg n18 sys_clk n1 uart_clk VSS VDD_1V8 DFRRQHDLLX0
Xclk_div_reg_0_ n18 sys_clk N14 clk_div[0] VSS VDD_1V8 DFRRQHDLLX0
.ENDS

.SUBCKT detector_flanco sys_clk sys_rst_l uart_clk flag_sincr VSS VDD_1V8
XU3 VSS VDD_1V8 flag_sincr flag_detector[1] flag_detector[0] NO2I1HDLLX0
Xflag_detector_reg_0_ sys_rst_l sys_clk flag_detector[1] flag_detector[0] VSS VDD_1V8 DFRRQHDLLX0
Xflag_detector_reg_1_ sys_rst_l sys_clk uart_clk flag_detector[1] VSS VDD_1V8 DFRRQHDLLX0
.ENDS

.SUBCKT dff_async_rsta_63 data clk reset q VSS VDD_1V8
Xq_reg reset clk data q VSS VDD_1V8 DFRRQHDLLX0
.ENDS

.SUBCKT dff_async_rsta_62 data clk reset q VSS VDD_1V8
Xq_reg reset clk data q VSS VDD_1V8 DFRRQHDLLX0
.ENDS

.SUBCKT dff_async_rsta_61 data clk reset q VSS VDD_1V8
Xq_reg reset clk data q VSS VDD_1V8 DFRRQHDLLX0
.ENDS

.SUBCKT dff_async_rsta_60 data clk reset q VSS VDD_1V8
Xq_reg reset clk data q VSS VDD_1V8 DFRRQHDLLX0
.ENDS

.SUBCKT dff_async_rsta_59 data clk reset q VSS VDD_1V8
Xq_reg reset clk data q VSS VDD_1V8 DFRRQHDLLX0
.ENDS

.SUBCKT dff_async_rsta_58 data clk reset q VSS VDD_1V8
Xq_reg reset clk data q VSS VDD_1V8 DFRRQHDLLX0
.ENDS

.SUBCKT dff_async_rsta_57 data clk reset q VSS VDD_1V8
Xq_reg reset clk data q VSS VDD_1V8 DFRRQHDLLX0
.ENDS

.SUBCKT dff_async_rsta_56 data clk reset q VSS VDD_1V8
Xq_reg reset clk data q VSS VDD_1V8 DFRRQHDLLX0
.ENDS

.SUBCKT dff_async_rsta_55 data clk reset q VSS VDD_1V8
Xq_reg reset clk data q VSS VDD_1V8 DFRRQHDLLX0
.ENDS

.SUBCKT dff_async_rsta_54 data clk reset q VSS VDD_1V8
Xq_reg reset clk data q VSS VDD_1V8 DFRRQHDLLX0
.ENDS

.SUBCKT dff_async_rsta_53 data clk reset q VSS VDD_1V8
Xq_reg reset clk data q VSS VDD_1V8 DFRRQHDLLX0
.ENDS

.SUBCKT dff_async_rsta_52 data clk reset q VSS VDD_1V8
Xq_reg reset clk data q VSS VDD_1V8 DFRRQHDLLX0
.ENDS

.SUBCKT dff_async_rsta_51 data clk reset q VSS VDD_1V8
Xq_reg reset clk data q VSS VDD_1V8 DFRRQHDLLX0
.ENDS

.SUBCKT dff_async_rsta_50 data clk reset q VSS VDD_1V8
Xq_reg reset clk data q VSS VDD_1V8 DFRRQHDLLX0
.ENDS

.SUBCKT dff_async_rsta_49 data clk reset q VSS VDD_1V8
Xq_reg reset clk data q VSS VDD_1V8 DFRRQHDLLX0
.ENDS

.SUBCKT dff_async_rsta_48 data clk reset q VSS VDD_1V8
Xq_reg reset clk data q VSS VDD_1V8 DFRRQHDLLX0
.ENDS

.SUBCKT dff_async_rsta_47 data clk reset q VSS VDD_1V8
Xq_reg reset clk data q VSS VDD_1V8 DFRRQHDLLX0
.ENDS

.SUBCKT dff_async_rsta_46 data clk reset q VSS VDD_1V8
Xq_reg reset clk data q VSS VDD_1V8 DFRRQHDLLX0
.ENDS

.SUBCKT dff_async_rsta_45 data clk reset q VSS VDD_1V8
Xq_reg reset clk data q VSS VDD_1V8 DFRRQHDLLX0
.ENDS

.SUBCKT dff_async_rsta_44 data clk reset q VSS VDD_1V8
Xq_reg reset clk data q VSS VDD_1V8 DFRRQHDLLX0
.ENDS

.SUBCKT dff_async_rsta_43 data clk reset q VSS VDD_1V8
Xq_reg reset clk data q VSS VDD_1V8 DFRRQHDLLX0
.ENDS

.SUBCKT dff_async_rsta_42 data clk reset q VSS VDD_1V8
Xq_reg reset clk data q VSS VDD_1V8 DFRRQHDLLX0
.ENDS

.SUBCKT dff_async_rsta_41 data clk reset q VSS VDD_1V8
Xq_reg reset clk data q VSS VDD_1V8 DFRRQHDLLX0
.ENDS

.SUBCKT dff_async_rsta_40 data clk reset q VSS VDD_1V8
Xq_reg reset clk data q VSS VDD_1V8 DFRRQHDLLX0
.ENDS

.SUBCKT dff_async_rsta_39 data clk reset q VSS VDD_1V8
Xq_reg reset clk data q VSS VDD_1V8 DFRRQHDLLX0
.ENDS

.SUBCKT dff_async_rsta_38 data clk reset q VSS VDD_1V8
Xq_reg reset clk data q VSS VDD_1V8 DFRRQHDLLX0
.ENDS

.SUBCKT dff_async_rsta_37 data clk reset q VSS VDD_1V8
Xq_reg reset clk data q VSS VDD_1V8 DFRRQHDLLX0
.ENDS

.SUBCKT dff_async_rsta_36 data clk reset q VSS VDD_1V8
Xq_reg reset clk data q VSS VDD_1V8 DFRRQHDLLX0
.ENDS

.SUBCKT dff_async_rsta_35 data clk reset q VSS VDD_1V8
Xq_reg reset clk data q VSS VDD_1V8 DFRRQHDLLX0
.ENDS

.SUBCKT dff_async_rsta_34 data clk reset q VSS VDD_1V8
Xq_reg reset clk data q VSS VDD_1V8 DFRRQHDLLX0
.ENDS

.SUBCKT dff_async_rsta_33 data clk reset q VSS VDD_1V8
Xq_reg reset clk data q VSS VDD_1V8 DFRRQHDLLX0
.ENDS

.SUBCKT dff_async_rsta_32 data clk reset q VSS VDD_1V8
Xq_reg reset clk data q VSS VDD_1V8 DFRRQHDLLX0
.ENDS

.SUBCKT dff_async_rsta_31 data clk reset q VSS VDD_1V8
Xq_reg reset clk data q VSS VDD_1V8 DFRRQHDLLX0
.ENDS

.SUBCKT dff_async_rsta_30 data clk reset q VSS VDD_1V8
Xq_reg reset clk data q VSS VDD_1V8 DFRRQHDLLX0
.ENDS

.SUBCKT dff_async_rsta_29 data clk reset q VSS VDD_1V8
Xq_reg reset clk data q VSS VDD_1V8 DFRRQHDLLX0
.ENDS

.SUBCKT dff_async_rsta_28 data clk reset q VSS VDD_1V8
Xq_reg reset clk data q VSS VDD_1V8 DFRRQHDLLX0
.ENDS

.SUBCKT dff_async_rsta_27 data clk reset q VSS VDD_1V8
Xq_reg reset clk data q VSS VDD_1V8 DFRRQHDLLX0
.ENDS

.SUBCKT dff_async_rsta_26 data clk reset q VSS VDD_1V8
Xq_reg reset clk data q VSS VDD_1V8 DFRRQHDLLX0
.ENDS

.SUBCKT dff_async_rsta_25 data clk reset q VSS VDD_1V8
Xq_reg reset clk data q VSS VDD_1V8 DFRRQHDLLX0
.ENDS

.SUBCKT dff_async_rsta_24 data clk reset q VSS VDD_1V8
Xq_reg reset clk data q VSS VDD_1V8 DFRRQHDLLX0
.ENDS

.SUBCKT dff_async_rsta_23 data clk reset q VSS VDD_1V8
Xq_reg reset clk data q VSS VDD_1V8 DFRRQHDLLX0
.ENDS

.SUBCKT dff_async_rsta_22 data clk reset q VSS VDD_1V8
Xq_reg reset clk data q VSS VDD_1V8 DFRRQHDLLX0
.ENDS

.SUBCKT dff_async_rsta_21 data clk reset q VSS VDD_1V8
Xq_reg reset clk data q VSS VDD_1V8 DFRRQHDLLX0
.ENDS

.SUBCKT dff_async_rsta_20 data clk reset q VSS VDD_1V8
Xq_reg reset clk data q VSS VDD_1V8 DFRRQHDLLX0
.ENDS

.SUBCKT dff_async_rsta_19 data clk reset q VSS VDD_1V8
Xq_reg reset clk data q VSS VDD_1V8 DFRRQHDLLX0
.ENDS

.SUBCKT dff_async_rsta_18 data clk reset q VSS VDD_1V8
Xq_reg reset clk data q VSS VDD_1V8 DFRRQHDLLX0
.ENDS

.SUBCKT dff_async_rsta_17 data clk reset q VSS VDD_1V8
Xq_reg reset clk data q VSS VDD_1V8 DFRRQHDLLX0
.ENDS

.SUBCKT dff_async_rsta_16 data clk reset q VSS VDD_1V8
Xq_reg reset clk data q VSS VDD_1V8 DFRRQHDLLX0
.ENDS

.SUBCKT dff_async_rsta_15 data clk reset q VSS VDD_1V8
Xq_reg reset clk data q VSS VDD_1V8 DFRRQHDLLX0
.ENDS

.SUBCKT dff_async_rsta_14 data clk reset q VSS VDD_1V8
Xq_reg reset clk data q VSS VDD_1V8 DFRRQHDLLX0
.ENDS

.SUBCKT dff_async_rsta_13 data clk reset q VSS VDD_1V8
Xq_reg reset clk data q VSS VDD_1V8 DFRRQHDLLX0
.ENDS

.SUBCKT dff_async_rsta_12 data clk reset q VSS VDD_1V8
Xq_reg reset clk data q VSS VDD_1V8 DFRRQHDLLX0
.ENDS

.SUBCKT dff_async_rsta_11 data clk reset q VSS VDD_1V8
Xq_reg reset clk data q VSS VDD_1V8 DFRRQHDLLX0
.ENDS

.SUBCKT dff_async_rsta_10 data clk reset q VSS VDD_1V8
Xq_reg reset clk data q VSS VDD_1V8 DFRRQHDLLX0
.ENDS

.SUBCKT dff_async_rsta_9 data clk reset q VSS VDD_1V8
Xq_reg reset clk data q VSS VDD_1V8 DFRRQHDLLX0
.ENDS

.SUBCKT dff_async_rsta_8 data clk reset q VSS VDD_1V8
Xq_reg reset clk data q VSS VDD_1V8 DFRRQHDLLX0
.ENDS

.SUBCKT dff_async_rsta_7 data clk reset q VSS VDD_1V8
Xq_reg reset clk data q VSS VDD_1V8 DFRRQHDLLX0
.ENDS

.SUBCKT dff_async_rsta_6 data clk reset q VSS VDD_1V8
Xq_reg reset clk data q VSS VDD_1V8 DFRRQHDLLX0
.ENDS

.SUBCKT dff_async_rsta_5 data clk reset q VSS VDD_1V8
Xq_reg reset clk data q VSS VDD_1V8 DFRRQHDLLX0
.ENDS

.SUBCKT dff_async_rsta_4 data clk reset q VSS VDD_1V8
Xq_reg reset clk data q VSS VDD_1V8 DFRRQHDLLX0
.ENDS

.SUBCKT dff_async_rsta_3 data clk reset q VSS VDD_1V8
Xq_reg reset clk data q VSS VDD_1V8 DFRRQHDLLX0
.ENDS

.SUBCKT dff_async_rsta_2 data clk reset q VSS VDD_1V8
Xq_reg reset clk data q VSS VDD_1V8 DFRRQHDLLX0
.ENDS

.SUBCKT dff_async_rsta_1 data clk reset q VSS VDD_1V8
Xq_reg reset clk data q VSS VDD_1V8 DFRRQHDLLX0
.ENDS

.SUBCKT dff_async_rsta_0 data clk reset q VSS VDD_1V8
Xq_reg reset clk data q VSS VDD_1V8 DFRRQHDLLX0
.ENDS

.SUBCKT log_ftu_pos_array8_data_fifo64_byte_out8 flag_sincr sys_clk xmit_done pndng
+ sys_rst_l D_reg[63] D_reg[62] D_reg[61] D_reg[60] D_reg[59] D_reg[58] D_reg[57]
+ D_reg[56] D_reg[55] D_reg[54] D_reg[53] D_reg[52] D_reg[51] D_reg[50] D_reg[49]
+ D_reg[48] D_reg[47] D_reg[46] D_reg[45] D_reg[44] D_reg[43] D_reg[42] D_reg[41]
+ D_reg[40] D_reg[39] D_reg[38] D_reg[37] D_reg[36] D_reg[35] D_reg[34] D_reg[33]
+ D_reg[32] D_reg[31] D_reg[30] D_reg[29] D_reg[28] D_reg[27] D_reg[26] D_reg[25]
+ D_reg[24] D_reg[23] D_reg[22] D_reg[21] D_reg[20] D_reg[19] D_reg[18] D_reg[17]
+ D_reg[16] D_reg[15] D_reg[14] D_reg[13] D_reg[12] D_reg[11] D_reg[10] D_reg[9]
+ D_reg[8] D_reg[7] D_reg[6] D_reg[5] D_reg[4] D_reg[3] D_reg[2] D_reg[1] D_reg[0]
+ Dout[7] Dout[6] Dout[5] Dout[4] Dout[3] Dout[2] Dout[1] Dout[0] xmit pop VSS VDD_1V8
+ IN0 IN1
XU12 n54 VSS cont_byte[0] cont_byte[1] VDD_1V8 cont_byte[2] NA3HDLLX0
XU38 VSS n59 cont_byte[1] n57 VDD_1V8 NO2HDLLX0
Xplace6 n85 VSS VDD_1V8 n54 INHDLLX0
XU41 VSS n59 cont_byte[2] VDD_1V8 n47 AND2HDLLX0
XU39 VSS n59 n62 VDD_1V8 n45 AND2HDLLX0
XU36 n43 VSS VDD_1V8 cont_byte[0] n58 cont_byte[2] NO3HDLLX0
XU35 n44 VSS VDD_1V8 cont_byte[0] cont_byte[1] cont_byte[2] NO3HDLLX0
XU33 n42 VSS VDD_1V8 cont_byte[1] n62 cont_byte[0] NO3HDLLX0
XU32 n41 VSS VDD_1V8 n62 n58 cont_byte[0] NO3HDLLX0
XU15 n46 VSS VDD_1V8 n58 cont_byte[2] n57 NO3HDLLX0
XU69 VSS VDD_1V8 n40 D_reg[54] n42 D_reg[38] n41 AN22HDLLX0
XU6 n81 VSS VDD_1V8 state[1] INHDLLX0
XU9 n84 VSS VDD_1V8 state[2] INHDLLX0
XU77 VSS VDD_1V8 n49 D_reg[47] D_reg[63] n85 n47 AN22HDLLX0
XU76 VSS VDD_1V8 n50 n45 D_reg[31] n46 D_reg[15] AN22HDLLX0
XU75 VSS VDD_1V8 n51 n43 D_reg[7] n44 D_reg[23] AN22HDLLX0
XU74 VSS VDD_1V8 n52 D_reg[55] n42 D_reg[39] n41 AN22HDLLX0
XU72 VSS VDD_1V8 n37 D_reg[46] D_reg[62] n85 n47 AN22HDLLX0
XU71 VSS VDD_1V8 n38 n45 D_reg[30] n46 D_reg[14] AN22HDLLX0
XU70 VSS VDD_1V8 n39 n43 D_reg[6] n44 D_reg[22] AN22HDLLX0
XU66 VSS VDD_1V8 n34 n45 D_reg[29] n46 D_reg[13] AN22HDLLX0
XU78 n50 n49 VSS VDD_1V8 n51 Dout[7] n52 NA4HDLLX0
XU73 n38 n37 VSS VDD_1V8 n39 Dout[6] n40 NA4HDLLX0
XU67 VSS VDD_1V8 n33 D_reg[45] D_reg[61] n85 n47 AN22HDLLX0
XU65 VSS VDD_1V8 n35 n43 D_reg[5] n44 D_reg[21] AN22HDLLX0
XU7 VSS state[2] n81 VDD_1V8 n12 NA2HDLLX0
XU8 n86 VSS VDD_1V8 state[0] INHDLLX0
XU60 VSS VDD_1V8 n31 n43 D_reg[4] n44 D_reg[20] AN22HDLLX0
XU62 VSS VDD_1V8 n29 D_reg[44] D_reg[60] n85 n47 AN22HDLLX0
XU29 n77 VSS state[0] n84 VDD_1V8 state[1] NA3HDLLX0
XU59 VSS VDD_1V8 n32 D_reg[52] n42 D_reg[36] n41 AN22HDLLX0
XU61 VSS VDD_1V8 n30 n45 D_reg[28] n46 D_reg[12] AN22HDLLX0
XU64 VSS VDD_1V8 n36 D_reg[53] n42 D_reg[37] n41 AN22HDLLX0
XU16 n73 VSS VDD_1V8 four_eight INHDLLX0
XU30 VSS xmit VDD_1V8 n77 n12 n86 ON21HDLLX0
XU34 VSS VDD_1V8 n16 D_reg[32] n41 D_reg[48] n42 AN22HDLLX0
XU37 VSS VDD_1V8 n15 n43 D_reg[0] n44 D_reg[16] AN22HDLLX0
XU40 VSS VDD_1V8 n14 n45 D_reg[24] n46 D_reg[8] AN22HDLLX0
XU42 VSS VDD_1V8 n13 D_reg[40] D_reg[56] n85 n47 AN22HDLLX0
XU44 VSS VDD_1V8 n20 D_reg[49] n42 D_reg[33] n41 AN22HDLLX0
XU45 VSS VDD_1V8 n19 n43 D_reg[1] n44 D_reg[17] AN22HDLLX0
XU46 VSS VDD_1V8 n18 n45 D_reg[25] n46 D_reg[9] AN22HDLLX0
XU47 VSS VDD_1V8 n17 D_reg[41] D_reg[57] n85 n47 AN22HDLLX0
XU49 VSS VDD_1V8 n24 D_reg[50] n42 D_reg[34] n41 AN22HDLLX0
XU50 VSS VDD_1V8 n23 n43 D_reg[2] n44 D_reg[18] AN22HDLLX0
XU51 VSS VDD_1V8 n22 n45 D_reg[26] n46 D_reg[10] AN22HDLLX0
XU52 VSS VDD_1V8 n21 D_reg[42] D_reg[58] n85 n47 AN22HDLLX0
XU54 VSS VDD_1V8 n28 D_reg[35] n41 D_reg[51] n42 AN22HDLLX0
XU55 VSS VDD_1V8 n27 n43 D_reg[3] n44 D_reg[19] AN22HDLLX0
XU56 VSS VDD_1V8 n26 n45 D_reg[27] n46 D_reg[11] AN22HDLLX0
XU57 VSS VDD_1V8 n25 D_reg[43] D_reg[59] n85 n47 AN22HDLLX0
XU63 n30 n29 VSS VDD_1V8 n31 Dout[4] n32 NA4HDLLX0
XU68 n34 n33 VSS VDD_1V8 n35 Dout[5] n36 NA4HDLLX0
XU11 n12 n86 VSS VDD_1V8 n80 xmit_done NO3I2HDLLX0
XU58 n26 n25 VSS VDD_1V8 n27 Dout[3] n28 NA4HDLLX0
XU53 n22 n21 VSS VDD_1V8 n23 Dout[2] n24 NA4HDLLX0
XU48 n18 n17 VSS VDD_1V8 n19 Dout[1] n20 NA4HDLLX0
XU43 n14 n13 VSS VDD_1V8 n15 Dout[0] n16 NA4HDLLX0
XU17 VSS n79 VDD_1V8 n73 n85 n46 MU2HDLLX0
XU10 VSS n7 VDD_1V8 n84 pndng state[1] ON21HDLLX0
XU18 VSS VDD_1V8 n53 n80 n79 NO2I1HDLLX0
XU87 VSS D_reg[50] n64 D_reg[52] D_reg[49] D_reg[35] VDD_1V8 OR4HDLLX0
XU92 VSS D_reg[55] n68 D_reg[54] D_reg[46] D_reg[51] VDD_1V8 OR4HDLLX0
XU80 VSS n55 n57 n58 VDD_1V8 NO2HDLLX0
XU19 n9 n7 n86 VSS VDD_1V8 n12 n53 AN31HDLLX0
XU85 n67 VSS VDD_1V8 D_reg[40] D_reg[34] D_reg[42] NO3HDLLX0
XU88 n65 VSS VDD_1V8 D_reg[36] n64 D_reg[43] NO3HDLLX0
XU90 n71 VSS VDD_1V8 D_reg[32] D_reg[33] D_reg[48] NO3HDLLX0
XU91 VSS n70 D_reg[38] D_reg[53] VDD_1V8 NO2HDLLX0
XU24 n78 VSS VDD_1V8 state[2] n86 state[1] NO3HDLLX0
XU27 n83 VSS VDD_1V8 state[0] n81 state[2] NO3HDLLX0
XU93 n69 VSS VDD_1V8 D_reg[39] n68 D_reg[45] NO3HDLLX0
XU86 VSS n66 D_reg[47] D_reg[44] VDD_1V8 NO2HDLLX0
XU89 D_reg[41] VSS n66 n65 VDD_1V8 n67 n75 NO4I3HDLLX0
XU83 VSS VDD_1V8 n61 cont_byte[1] IN0 n59 n57 AN22HDLLX0
XU81 n56 VSS VDD_1V8 cont_byte[2] n54 n54 IN0 n55 AN32HDLLX0
XU79 n87 VSS VDD_1V8 n53 INHDLLX0
XU25 VSS n60 p_state_0_ VDD_1V8 n11 NA2HDLLX0
XU22 n10 VSS IN0 n57 VDD_1V8 n53 NA3HDLLX0
XU21 VSS n63 n9 flag_sincr VDD_1V8 NO2HDLLX0
XU101 n88 n86 n84 VSS VDD_1V8 pndng n83 AN31HDLLX0
XU99 VSS VDD_1V8 n82 n80 n79 n83 n78 AN211HDLLX0
XU97 VSS n76 VDD_1V8 state[2] n81 flag_sincr ON21HDLLX0
XU95 n72 VSS VDD_1V8 n83 INHDLLX0
XU94 D_reg[37] VSS n70 n69 VDD_1V8 n71 n74 NO4I3HDLLX0
XU96 n4 VSS VDD_1V8 n73 n72 n83 n74 n75 AN32HDLLX0
XU98 VSS n5 VDD_1V8 n76 n77 flag_sincr ON21HDLLX0
XU100 VSS VDD_1V8 n6 n81 n82 IN0 flag_sincr AN22HDLLX0
XU102 n8 VSS VDD_1V8 n86 flag_sincr IN0 n87 n88 AN32HDLLX0
XU23 VSS n3 VDD_1V8 n10 n63 n57 ON21HDLLX0
XU28 VSS p_next_state_1_ VDD_1V8 p_state_0_ n11 n60 n83 ON31HDLLX0
XU82 n1 VSS VDD_1V8 n87 n56 n62 n63 ON22HDLLX0
XU84 n2 VSS VDD_1V8 n61 n87 n58 n63 ON22HDLLX0
Xplace5 n62 VSS VDD_1V8 cont_byte[2] INHDLLX0
Xplace4 n58 VSS VDD_1V8 cont_byte[1] INHDLLX0
Xplace3 n57 VSS VDD_1V8 cont_byte[0] INHDLLX0
Xp_state_reg_0_ sys_rst_l sys_clk IN1 p_state_0_ VSS VDD_1V8 DFRRQHDLLX0
Xfour_eight_reg sys_rst_l sys_clk n4 four_eight VSS VDD_1V8 DFRRQHDLLX0
Xstate_reg_2_ sys_rst_l sys_clk n5 state[2] VSS VDD_1V8 DFRRQHDLLX0
Xstate_reg_1_ sys_rst_l sys_clk n6 state[1] VSS VDD_1V8 DFRRQHDLLX0
Xstate_reg_0_ sys_rst_l sys_clk n8 state[0] VSS VDD_1V8 DFRRQHDLLX0
XU4 p_state_0_ n60 VSS VDD_1V8 pop pop_en NO3I2HDLLX1
Xp_state_reg_1_ sys_rst_l sys_clk p_next_state_1_ SYNOPSYS_UNCONNECTED_87 n60 VSS
+ VDD_1V8 DFRRHDLLX0
Xpop_en_reg VSS sys_clk N38 pop_en VDD_1V8 DFRQHDLLX0
Xcont_byte_reg_2_ sys_rst_l sys_clk n1 cont_byte[2] VSS VDD_1V8 DFRRQHDLLX0
Xcont_byte_reg_1_ sys_rst_l sys_clk n2 cont_byte[1] VSS VDD_1V8 DFRRQHDLLX0
Xcont_byte_reg_0_ sys_rst_l sys_clk n3 cont_byte[0] VSS VDD_1V8 DFRRQHDLLX0
XU26 VSS N38 sys_rst_l n11 VDD_1V8 n78 AND3HDLLX0
.ENDS

.SUBCKT u_xmit_WORD_LEN8 sys_clk flag_sincr sys_rst_l xmitH xmit_dataH[7] xmit_dataH[6]
+ xmit_dataH[5] xmit_dataH[4] xmit_dataH[3] xmit_dataH[2] xmit_dataH[1] xmit_dataH[0]
+ uart_xmitH xmit_doneH VSS VDD_1V8 IN0 IN1
XU44 VSS n79 xmit_ShiftRegH[0] VDD_1V8 n34 uart_xmitH NA22HDLLX0
XU9 n47 VSS bitCell_cntrH[0] bitCell_cntrH[1] VDD_1V8 bitCell_cntrH[2] NA3HDLLX0
XU8 n55 VSS VDD_1V8 bitCell_cntrH[3] INHDLLX0
XU20 n64 VSS VDD_1V8 bitCell_cntrH[0] INHDLLX0
XU19 VSS n18 bitCell_cntrH[4] n55 VDD_1V8 NO2HDLLX0
XU15 n69 VSS VDD_1V8 state[2] INHDLLX0
XU10 n50 VSS VDD_1V8 n55 n47 bitCell_cntrH[4] NO3HDLLX0
XU7 n85 VSS VDD_1V8 state[0] INHDLLX0
XU11 VSS state[2] n50 VDD_1V8 n82 NA2HDLLX0
XU18 bitCountH[0] VSS bitCountH[3] n60 VDD_1V8 n56 n66 NO4I3HDLLX0
XU21 bitCell_cntrH[1] n64 VSS VDD_1V8 n18 n67 bitCell_cntrH[2] NA4HDLLX0
XU16 VSS state[1] n69 VDD_1V8 n39 NA2HDLLX0
XU6 VSS n48 state[0] state[2] VDD_1V8 NO2HDLLX0
XU12 VSS n35 n85 n82 VDD_1V8 NO2HDLLX0
XU17 VSS n65 state[0] n39 VDD_1V8 NO2HDLLX0
XU22 VSS n83 n66 n67 VDD_1V8 NO2HDLLX0
XU23 n85 n69 VSS VDD_1V8 n77 n50 NO3I2HDLLX0
XU95 VSS VDD_1V8 n91 xmit_dataH[7] xmit_dataH[6] EO2HDLLX0
XU14 VSS n27 VDD_1V8 n87 n35 n48 ON21HDLLX0
XU24 VSS VDD_1V8 n20 n77 n83 n65 n87 AN22HDLLX0
XU68 n49 VSS VDD_1V8 n48 INHDLLX0
XU96 VSS xmit_dataH[4] n91 n92 VDD_1V8 xmit_dataH[5] EN3HDLLX0
XU25 n27 VSS flag_sincr n20 VDD_1V8 n21 AN21HDLLX0
XU49 n88 VSS xmitH n87 VDD_1V8 n48 NA3HDLLX0
XU67 VSS n86 state[1] n50 VDD_1V8 NO2HDLLX0
XU55 VSS n44 flag_sincr n88 VDD_1V8 NO2HDLLX0
XU51 VSS n72 n85 n39 VDD_1V8 NO2HDLLX0
XU26 VSS bitCountH[0] n21 VDD_1V8 n24 NA2HDLLX0
XU97 VSS xmit_dataH[0] n92 n94 VDD_1V8 xmit_dataH[1] EN3HDLLX0
XU94 VSS VDD_1V8 n95 xmit_dataH[3] xmit_dataH[2] EO2HDLLX0
XU93 VSS IN0 xmitH VDD_1V8 n97 NA2HDLLX0
XU69 VSS VDD_1V8 n59 n86 n67 n65 n49 AN22HDLLX0
XU41 VSS n33 state[1] state[0] VDD_1V8 NO2HDLLX0
XU42 n68 VSS n87 n85 VDD_1V8 state[2] NA3HDLLX0
XU63 n43 VSS VDD_1V8 n44 INHDLLX0
XU53 VSS IN0 n72 VDD_1V8 n45 NA2HDLLX0
XU50 n40 VSS VDD_1V8 n88 INHDLLX0
XU45 n36 VSS VDD_1V8 xmitH INHDLLX0
XU40 n79 VSS VDD_1V8 n39 INHDLLX0
XU32 n22 VSS VDD_1V8 n21 INHDLLX0
XU27 VSS VDD_1V8 n28 n60 n24 OR2HDLLX0
XU98 n94 VSS n97 n95 VDD_1V8 n93 AN21HDLLX0
XU89 VSS n83 state[1] VDD_1V8 n82 n84 NA22HDLLX0
XU84 n78 VSS n67 VDD_1V8 n66 NA2I1HDLLX0
XU77 n62 VSS VDD_1V8 bitCell_cntrH[1] INHDLLX0
XU71 VSS n63 n59 flag_sincr VDD_1V8 NO2HDLLX0
XU66 n52 VSS VDD_1V8 n47 INHDLLX0
XU43 n34 VSS VDD_1V8 BitP n68 n33 state[2] ON22HDLLX0
XU64 VSS VDD_1V8 n46 xmit_ShiftRegH[7] xmit_dataH[7] n44 n43 AN22HDLLX0
XU54 n41 VSS VDD_1V8 n45 INHDLLX0
XU52 VSS n42 VDD_1V8 IN0 n72 n40 ON21HDLLX0
XU47 n37 VSS VDD_1V8 xmit_doneH INHDLLX0
XU46 n38 VSS VDD_1V8 n35 n87 n87 n36 n48 AN32HDLLX0
XU38 n29 VSS VDD_1V8 bitCountH[3] INHDLLX0
XU37 VSS n56 n28 VDD_1V8 n30 n27 NA3I2HDLLX0
XU35 VSS n60 n27 VDD_1V8 n25 NA2HDLLX0
XU33 n102 VSS n22 n27 VDD_1V8 n26 AN21HDLLX0
XU29 VSS n56 n27 VDD_1V8 n32 NA2HDLLX0
XU28 VSS n31 VDD_1V8 n28 n27 flag_sincr ON21HDLLX0
XU99 VSS n96 VDD_1V8 n93 n94 n95 ON21HDLLX0
XU91 VSS n89 VDD_1V8 state[0] flag_sincr n86 ON21HDLLX0
XU90 VSS VDD_1V8 n90 n85 state[2] state[1] n84 AN22HDLLX0
XU87 VSS VDD_1V8 n81 n79 n78 n77 n72 AN211HDLLX0
XU85 VSS n70 n86 flag_sincr VDD_1V8 NO2HDLLX0
XU83 n71 VSS VDD_1V8 n65 INHDLLX0
XU80 VSS n61 VDD_1V8 IN0 n59 bitCell_cntrH[0] ON21HDLLX0
XU78 VSS VDD_1V8 n62 n64 n63 n57 bitCell_cntrH[2] NA4I3HDLLX0
XU76 n58 VSS VDD_1V8 n59 IN0 IN0 bitCell_cntrH[1] bitCell_cntrH[0] AN32HDLLX0
XU74 n53 VSS n63 n55 VDD_1V8 n52 NA3HDLLX0
XU73 n52 VDD_1V8 n59 VSS IN0 n54 OA21HDLLX0
XU70 n51 VSS VDD_1V8 n59 IN0 IN0 n52 bitCell_cntrH[3] AN32HDLLX0
XU75 VSS n11 VDD_1V8 n53 n54 n55 ON21HDLLX0
XU79 VSS n58 bitCell_cntrH[2] VDD_1V8 n57 n12 NA22HDLLX0
XU81 VSS VDD_1V8 n13 n62 n63 n61 bitCell_cntrH[0] bitCell_cntrH[1] AO32HDLLX0
XU86 VSS n71 n69 VDD_1V8 n78 n70 n68 n15 flag_sincr ON321HDLLX0
XU88 VSS VDD_1V8 n16 n87 n81 IN0 flag_sincr AN22HDLLX0
XU92 n17 VSS VDD_1V8 flag_sincr n89 n89 n88 n90 AN32HDLLX0
XU100 VSS BitP n97 VDD_1V8 n96 n19 NA22HDLLX0
XU30 n74 VSS VDD_1V8 n28 n32 n31 n56 ON22HDLLX0
XU34 n22 VSS n26 n102 VDD_1V8 n76 AN21HDLLX0
XU36 n75 VSS VDD_1V8 n25 n24 n26 n60 ON22HDLLX0
XU39 n73 VSS VDD_1V8 n30 n29 bitCountH[3] n31 n32 AN32HDLLX0
XU48 VSS VDD_1V8 n1 n37 n38 IN0 flag_sincr AN22HDLLX0
XU56 VSS n2 xmit_ShiftRegH[0] n44 n41 xmit_dataH[0] VDD_1V8 n42 xmit_ShiftRegH[1] AO222HDLLX0
XU57 VSS n3 xmit_ShiftRegH[1] n44 xmit_ShiftRegH[2] xmit_dataH[1] VDD_1V8 n42 n41 AO222HDLLX0
XU58 VSS n4 xmit_ShiftRegH[2] n44 xmit_ShiftRegH[3] xmit_dataH[2] VDD_1V8 n42 n41 AO222HDLLX0
XU59 VSS n5 xmit_ShiftRegH[3] n44 xmit_ShiftRegH[4] xmit_dataH[3] VDD_1V8 n42 n41 AO222HDLLX0
XU60 VSS n6 xmit_ShiftRegH[4] n44 xmit_ShiftRegH[5] xmit_dataH[4] VDD_1V8 n42 n41 AO222HDLLX0
XU61 VSS n7 xmit_ShiftRegH[5] n44 xmit_ShiftRegH[6] xmit_dataH[5] VDD_1V8 n42 n41 AO222HDLLX0
XU62 VSS n8 xmit_ShiftRegH[6] n44 xmit_ShiftRegH[7] xmit_dataH[6] VDD_1V8 n42 n41 AO222HDLLX0
XU65 VSS n46 n45 VDD_1V8 n9 NA2HDLLX0
Xplace3 n87 VSS VDD_1V8 state[1] INHDLLX0
XbitCountH_reg_1_ IN1 sys_clk n75 SYNOPSYS_UNCONNECTED_85 n60 VSS VDD_1V8 DFRRHDLLX0
XbitCountH_reg_2_ IN1 sys_clk n74 SYNOPSYS_UNCONNECTED_86 n56 VSS VDD_1V8 DFRRHDLLX0
XbitCountH_reg_0_ IN1 sys_clk n76 bitCountH[0] n102 VSS VDD_1V8 DFRRHDLLX0
Xxmit_doneH_reg sys_rst_l sys_clk n1 xmit_doneH VSS VDD_1V8 DFRRQHDLLX0
Xxmit_ShiftRegH_reg_0_ IN1 sys_clk n2 xmit_ShiftRegH[0] VSS VDD_1V8 DFRRQHDLLX0
Xxmit_ShiftRegH_reg_1_ IN1 sys_clk n3 xmit_ShiftRegH[1] VSS VDD_1V8 DFRRQHDLLX0
Xxmit_ShiftRegH_reg_2_ sys_rst_l sys_clk n4 xmit_ShiftRegH[2] VSS VDD_1V8 DFRRQHDLLX0
Xxmit_ShiftRegH_reg_3_ sys_rst_l sys_clk n5 xmit_ShiftRegH[3] VSS VDD_1V8 DFRRQHDLLX0
Xxmit_ShiftRegH_reg_4_ sys_rst_l sys_clk n6 xmit_ShiftRegH[4] VSS VDD_1V8 DFRRQHDLLX0
Xxmit_ShiftRegH_reg_5_ sys_rst_l sys_clk n7 xmit_ShiftRegH[5] VSS VDD_1V8 DFRRQHDLLX0
Xxmit_ShiftRegH_reg_6_ sys_rst_l sys_clk n8 xmit_ShiftRegH[6] VSS VDD_1V8 DFRRQHDLLX0
Xxmit_ShiftRegH_reg_7_ IN1 sys_clk n9 xmit_ShiftRegH[7] VSS VDD_1V8 DFRRQHDLLX0
XbitCell_cntrH_reg_4_ IN1 sys_clk n10 bitCell_cntrH[4] VSS VDD_1V8 DFRRQHDLLX0
XbitCell_cntrH_reg_3_ IN1 sys_clk n11 bitCell_cntrH[3] VSS VDD_1V8 DFRRQHDLLX0
XbitCell_cntrH_reg_2_ IN1 sys_clk n12 bitCell_cntrH[2] VSS VDD_1V8 DFRRQHDLLX0
XbitCell_cntrH_reg_1_ IN1 sys_clk n13 bitCell_cntrH[1] VSS VDD_1V8 DFRRQHDLLX0
XbitCell_cntrH_reg_0_ IN1 sys_clk n14 bitCell_cntrH[0] VSS VDD_1V8 DFRRQHDLLX0
Xstate_reg_2_ IN1 sys_clk n15 state[2] VSS VDD_1V8 DFRRQHDLLX0
Xstate_reg_1_ IN1 sys_clk n16 state[1] VSS VDD_1V8 DFRRQHDLLX0
XbitCountH_reg_3_ IN1 sys_clk n73 bitCountH[3] VSS VDD_1V8 DFRRQHDLLX0
Xstate_reg_0_ IN1 sys_clk n17 state[0] VSS VDD_1V8 DFRRQHDLLX0
XBitP_reg IN1 sys_clk n19 BitP VSS VDD_1V8 DFRRQHDLLX0
XU82 VSS VDD_1V8 flag_sincr n63 bitCell_cntrH[0] n64 n14 OA22HDLLX1
XU72 bitCell_cntrH[4] VSS VDD_1V8 n50 n51 n63 n10 AO22HDLLX1
.ENDS

.SUBCKT u_rec_WORD_LEN_PLUS19 sys_rst_l sys_clk flag_sincr uart_dataH rec_dataH[7]
+ rec_dataH[6] rec_dataH[5] rec_dataH[4] rec_dataH[3] rec_dataH[2] rec_dataH[1]
+ rec_dataH[0] rec_readyH VSS VDD_1V8 IN0 IN1 IN2 IN3 IN4 IN5 IN6 IN7
XU7 n46 VSS VDD_1V8 bitCell_cntrH[2] INHDLLX0
XU8 VSS VDD_1V8 n44 bitCell_cntrH[3] n46 OR2HDLLX0
XU36 n53 VSS VDD_1V8 bitCell_cntrH[0] INHDLLX0
XU10 n1 VSS VDD_1V8 rec_datH INHDLLX0
XU9 n62 VSS VDD_1V8 bitCell_cntrH[1] n44 bitCell_cntrH[0] NO3HDLLX0
XU11 n1 VSS state[1] n62 VDD_1V8 n2 AN21HDLLX0
XU37 bitCell_cntrH[1] n53 VSS VDD_1V8 bitCell_cntrH[3] n69 bitCell_cntrH[2] NA4HDLLX0
XU5 VSS n73 state[2] state[1] VDD_1V8 NO2HDLLX0
XU12 n31 VSS VDD_1V8 n2 n80 state[2] NO3HDLLX0
XU38 n39 VSS VDD_1V8 n69 INHDLLX0
XU54 VSS n39 state[0] state[1] n62 VDD_1V8 n79 n80 n41 ON33HDLLX0
XU55 n63 VSS n39 n79 VDD_1V8 state[2] NA3HDLLX0
XU13 n21 n80 n73 VSS VDD_1V8 rec_datH n31 AN31HDLLX0
XU15 n40 VSS state[0] n79 VDD_1V8 state[2] NA3HDLLX0
XU17 n40 VSS flag_sincr n21 VDD_1V8 n23 AN21HDLLX0
XU21 n27 VSS VDD_1V8 n31 INHDLLX0
XU39 recd_bitCntrH[2] VSS recd_bitCntrH[0] n83 VDD_1V8 recd_bitCntrH[3] n70 NO4I3HDLLX0
XU56 n40 VSS state[2] n41 n63 VDD_1V8 n42 ON211HDLLX0
XU41 n59 VSS VDD_1V8 state[2] INHDLLX0
XU40 VSS n39 n70 VDD_1V8 n58 NA2HDLLX0
XU22 n27 VDD_1V8 recd_bitCntrH[0] VSS n23 n26 OA21HDLLX0
XU19 n24 VSS VDD_1V8 recd_bitCntrH[0] INHDLLX0
XU18 VSS n31 IN0 VDD_1V8 n60 NA2HDLLX0
XU57 n49 VSS VDD_1V8 n42 INHDLLX0
XU42 VSS state[1] n59 VDD_1V8 n68 NA2HDLLX0
XU58 n51 VSS IN0 n49 VDD_1V8 bitCell_cntrH[0] NA3HDLLX0
XU60 n45 VSS VDD_1V8 n42 IN0 IN0 bitCell_cntrH[0] bitCell_cntrH[1] AN32HDLLX0
XU75 VSS VDD_1V8 n72 rec_datH n62 state[0] n80 AN22HDLLX0
XU76 VSS n71 VDD_1V8 n68 n63 n69 n70 ON31HDLLX0
XU43 VSS VDD_1V8 n37 n80 n58 flag_sincr n68 AN211HDLLX0
XU27 VSS n30 VDD_1V8 n26 n27 recd_bitCntrH[1] ON21HDLLX0
XU23 VSS n28 n24 n60 VDD_1V8 NO2HDLLX0
XU70 n54 VSS VDD_1V8 n58 INHDLLX0
XU69 VSS n55 flag_sincr n68 VDD_1V8 NO2HDLLX0
XU34 n35 VSS VDD_1V8 rec_readyH INHDLLX0
XU32 n32 VSS VDD_1V8 n30 recd_bitCntrH[3] recd_bitCntrH[3] n82 n31 AN32HDLLX0
XU29 VSS recd_bitCntrH[1] n28 VDD_1V8 n33 NA2HDLLX0
XU28 n29 VSS VDD_1V8 n30 INHDLLX0
XU24 n25 VSS VDD_1V8 n28 INHDLLX0
XU77 VSS VDD_1V8 n75 n80 n72 n73 n71 AN22HDLLX0
XU73 n61 VSS VDD_1V8 flag_sincr state[1] state[1] n58 n59 AN32HDLLX0
XU71 VSS VDD_1V8 n57 n55 n79 state[2] n54 AN22HDLLX0
XU66 n50 VSS VDD_1V8 bitCell_cntrH[1] INHDLLX0
XU65 n53 VSS flag_sincr n49 VDD_1V8 n52 AN21HDLLX0
XU63 n48 VSS VDD_1V8 n45 INHDLLX0
XU61 n43 VSS VDD_1V8 n45 bitCell_cntrH[3] bitCell_cntrH[3] n46 n49 AN32HDLLX0
XU59 n47 VSS n51 VDD_1V8 bitCell_cntrH[1] NA2I1HDLLX0
XU62 VSS n13 VDD_1V8 n43 n44 n47 ON21HDLLX0
XU64 VSS VDD_1V8 n14 n47 n48 bitCell_cntrH[2] n46 AN22HDLLX0
XU67 VSS VDD_1V8 n15 n51 n52 bitCell_cntrH[1] n50 AN22HDLLX0
XU68 flag_sincr VSS n52 n53 VDD_1V8 n16 AN21HDLLX0
XU72 n17 VSS VDD_1V8 IN0 n59 n57 state[0] ON22HDLLX0
XU74 VSS n61 n60 VDD_1V8 n18 NA2HDLLX0
XU78 VSS VDD_1V8 n19 n80 n75 IN0 flag_sincr AN22HDLLX0
XU80 VSS n22 VDD_1V8 flag_sincr uart_dataH rec_datSyncH MU2HDLLX0
XU20 VSS VDD_1V8 n67 n60 n23 recd_bitCntrH[0] n24 AN22HDLLX0
XU26 VSS VDD_1V8 n66 n25 n26 recd_bitCntrH[1] n83 AN22HDLLX0
XU31 VSS VDD_1V8 n65 n33 n29 recd_bitCntrH[2] n82 AN22HDLLX0
XU33 VSS n64 VDD_1V8 n33 n32 n82 recd_bitCntrH[3] ON31HDLLX0
XU35 VSS VDD_1V8 n3 n35 n40 IN0 flag_sincr AN22HDLLX0
Xplace5 n85 VSS VDD_1V8 n37 INHDLLX0
Xplace4 n80 VSS VDD_1V8 state[0] INHDLLX0
Xplace3 n79 VSS VDD_1V8 state[1] INHDLLX0
Xrecd_bitCntrH_reg_1_ sys_rst_l sys_clk n66 recd_bitCntrH[1] n83 VSS VDD_1V8 DFRRHDLLX0
Xrecd_bitCntrH_reg_2_ sys_rst_l sys_clk n65 recd_bitCntrH[2] n82 VSS VDD_1V8 DFRRHDLLX0
Xrec_datH_reg VSS VDD_1V8 rec_datH sys_rst_l sys_clk n20 DFRSQHDLLX0
Xrec_datSyncH_reg VSS VDD_1V8 rec_datSyncH sys_rst_l sys_clk n22 DFRSQHDLLX0
Xrec_readyH_reg sys_rst_l sys_clk n3 rec_readyH VSS VDD_1V8 DFRRQHDLLX0
Xpar_dataH_reg_0_ sys_rst_l sys_clk n4 rec_dataH[0] VSS VDD_1V8 DFRRQHDLLX0
Xpar_dataH_reg_1_ sys_rst_l sys_clk n5 rec_dataH[1] VSS VDD_1V8 DFRRQHDLLX0
Xpar_dataH_reg_2_ sys_rst_l sys_clk n6 rec_dataH[2] VSS VDD_1V8 DFRRQHDLLX0
Xpar_dataH_reg_3_ sys_rst_l sys_clk n7 rec_dataH[3] VSS VDD_1V8 DFRRQHDLLX0
Xpar_dataH_reg_4_ sys_rst_l sys_clk n8 rec_dataH[4] VSS VDD_1V8 DFRRQHDLLX0
Xpar_dataH_reg_5_ sys_rst_l sys_clk n9 rec_dataH[5] VSS VDD_1V8 DFRRQHDLLX0
Xpar_dataH_reg_6_ sys_rst_l sys_clk n10 rec_dataH[6] VSS VDD_1V8 DFRRQHDLLX0
Xpar_dataH_reg_7_ sys_rst_l sys_clk n11 rec_dataH[7] VSS VDD_1V8 DFRRQHDLLX0
Xpar_dataH_reg_8_ sys_rst_l sys_clk n12 par_dataH_8_ VSS VDD_1V8 DFRRQHDLLX0
Xrecd_bitCntrH_reg_0_ sys_rst_l sys_clk n67 recd_bitCntrH[0] VSS VDD_1V8 DFRRQHDLLX0
XbitCell_cntrH_reg_3_ sys_rst_l sys_clk n13 bitCell_cntrH[3] VSS VDD_1V8 DFRRQHDLLX0
XbitCell_cntrH_reg_2_ sys_rst_l sys_clk n14 bitCell_cntrH[2] VSS VDD_1V8 DFRRQHDLLX0
XbitCell_cntrH_reg_1_ sys_rst_l sys_clk n15 bitCell_cntrH[1] VSS VDD_1V8 DFRRQHDLLX0
XbitCell_cntrH_reg_0_ sys_rst_l sys_clk n16 bitCell_cntrH[0] VSS VDD_1V8 DFRRQHDLLX0
Xstate_reg_2_ sys_rst_l sys_clk n17 state[2] VSS VDD_1V8 DFRRQHDLLX0
Xstate_reg_1_ sys_rst_l sys_clk n18 state[1] VSS VDD_1V8 DFRRQHDLLX0
Xrecd_bitCntrH_reg_3_ sys_rst_l sys_clk n64 recd_bitCntrH[3] VSS VDD_1V8 DFRRQHDLLX0
Xstate_reg_0_ sys_rst_l sys_clk n19 state[0] VSS VDD_1V8 DFRRQHDLLX0
XU79 VSS VDD_1V8 rec_datSyncH rec_datH IN0 flag_sincr n20 OA22HDLLX0
XU53 VSS VDD_1V8 rec_datH par_dataH_8_ n37 n85 n12 OA22HDLLX0
XU52 VSS VDD_1V8 par_dataH_8_ IN1 n37 n85 n11 OA22HDLLX0
XU51 VSS VDD_1V8 IN1 IN2 n37 n85 n10 OA22HDLLX0
XU50 VSS VDD_1V8 IN2 IN3 n37 n85 n9 OA22HDLLX0
XU49 VSS VDD_1V8 IN3 IN4 n37 n85 n8 OA22HDLLX0
XU48 VSS VDD_1V8 IN4 IN5 n37 n85 n7 OA22HDLLX0
XU47 VSS VDD_1V8 IN5 IN6 n37 n85 n6 OA22HDLLX0
XU46 VSS VDD_1V8 IN6 IN7 n37 n85 n5 OA22HDLLX0
XU45 VSS VDD_1V8 IN7 rec_dataH[0] n37 n85 n4 OA22HDLLX0
.ENDS

.SUBCKT log_utf_pos_array8 flag_sincr sys_clk rec_ready sys_rst_l push rst enable_reg[7]
+ enable_reg[6] enable_reg[5] enable_reg[4] enable_reg[3] enable_reg[2] enable_reg[1]
+ enable_reg[0] VSS VDD_1V8 IN0
Xenable_reg_reg_3_ sys_clk n40 enable_reg[3] VSS n25 VDD_1V8 DFRHDLLX0
XU6 n26 VSS VDD_1V8 cont_byte[2] INHDLLX0
XU9 n23 VSS VDD_1V8 n29 n34 n26 NO3HDLLX0
XU4 n10 VSS VDD_1V8 state[1] INHDLLX0
XU15 VSS state[0] n23 VDD_1V8 n9 NA2HDLLX0
XU23 p_state_0_ n35 VSS VDD_1V8 push push_en NO3I2HDLLX0
XU16 n32 VSS n10 n9 VDD_1V8 rec_ready NA3HDLLX0
XU5 VSS n30 state[0] n10 VDD_1V8 NO2HDLLX0
XU20 n12 VSS VDD_1V8 n30 INHDLLX0
XU17 n28 VSS VDD_1V8 n32 INHDLLX0
XU3 VSS flag_sincr rec_ready VDD_1V8 n19 NA2HDLLX0
XU21 VSS n12 flag_sincr VDD_1V8 n33 NA2HDLLX0
XU33 VSS n15 cont_byte[2] n19 VDD_1V8 NO2HDLLX0
XU18 n24 VSS cont_byte[0] n28 VDD_1V8 cont_byte[1] NA3HDLLX0
XU39 n20 n34 cont_byte[2] VSS VDD_1V8 cont_byte[1] enable_reg[6] AN31HDLLX0
XU36 n18 VSS VDD_1V8 n26 n19 cont_byte[1] NO3HDLLX0
XU34 VSS cont_byte[0] n15 VDD_1V8 n16 NA2HDLLX0
XU30 n13 VSS VDD_1V8 cont_byte[1] n19 cont_byte[2] NO3HDLLX0
XU28 n14 VSS VDD_1V8 cont_byte[0] n19 cont_byte[2] NO3HDLLX0
XU25 n11 VSS n9 VDD_1V8 n45 NA2I1HDLLX0
XU19 n8 VSS VDD_1V8 cont_byte[1] n24 n24 n28 cont_byte[0] AN32HDLLX0
XU14 rst VSS VDD_1V8 state[0] rec_ready state[1] NO3HDLLX0
XU46 VSS VDD_1V8 n34 n30 n34 flag_sincr n28 n31 OA32HDLLX0
XU44 n23 VSS VDD_1V8 n33 n28 n27 AO21HDLLX0
XU42 VSS VDD_1V8 n22 state[0] state[1] n35 p_state_0_ AN211HDLLX0
XU43 p_state_0_ VSS VDD_1V8 n22 n35 p_next_state_1_ AO21HDLLX0
XU45 VSS VDD_1V8 n24 n1 n26 n27 n27 n26 flag_sincr AN222HDLLX0
XU47 VSS n4 VDD_1V8 n32 n31 n33 cont_byte[0] ON31HDLLX0
XU12 VSS n6 VDD_1V8 n7 n19 state[0] ON21HDLLX0
XU22 n2 VSS VDD_1V8 n8 n33 n29 flag_sincr ON22HDLLX0
XU27 VSS VDD_1V8 N29 n35 p_state_0_ IN0 n12 AN211HDLLX0
XU35 n40 VSS VDD_1V8 n29 n16 n19 n25 ON22HDLLX0
XU40 VSS n37 n20 n19 VDD_1V8 NO2HDLLX0
XU41 n23 VDD_1V8 enable_reg[7] VSS n45 n36 OA21HDLLX0
Xplace5 n45 VSS VDD_1V8 n19 INHDLLX0
Xplace4 n34 VSS VDD_1V8 cont_byte[0] INHDLLX0
Xplace3 n29 VSS VDD_1V8 cont_byte[1] INHDLLX0
XU38 cont_byte[0] VSS VDD_1V8 n45 n18 enable_reg[5] n38 AO22HDLLX1
XU37 enable_reg[4] VSS VDD_1V8 n18 n45 n34 n39 AO22HDLLX1
XU32 cont_byte[1] VSS VDD_1V8 n45 n14 enable_reg[2] n41 AO22HDLLX1
XU31 cont_byte[0] VSS VDD_1V8 n45 n13 enable_reg[1] n42 AO22HDLLX1
XU29 enable_reg[0] VSS VDD_1V8 n14 n45 n29 n43 AO22HDLLX1
XU11 VSS VDD_1V8 n7 state[0] n30 flag_sincr n5 AN22HDLLX0
Xp_state_reg_1_ sys_rst_l sys_clk p_next_state_1_ SYNOPSYS_UNCONNECTED_84 n35 VSS
+ VDD_1V8 DFRRHDLLX0
Xpush_en_reg VSS sys_clk N29 push_en VDD_1V8 DFRQHDLLX0
Xenable_reg_reg_6_ VSS sys_clk n37 enable_reg[6] VDD_1V8 DFRQHDLLX0
Xenable_reg_reg_2_ VSS sys_clk n41 enable_reg[2] VDD_1V8 DFRQHDLLX0
Xenable_reg_reg_1_ VSS sys_clk n42 enable_reg[1] VDD_1V8 DFRQHDLLX0
Xenable_reg_reg_5_ VSS sys_clk n38 enable_reg[5] VDD_1V8 DFRQHDLLX0
Xenable_reg_reg_0_ VSS sys_clk n43 enable_reg[0] VDD_1V8 DFRQHDLLX0
Xenable_reg_reg_4_ VSS sys_clk n39 enable_reg[4] VDD_1V8 DFRQHDLLX0
Xenable_reg_reg_7_ VSS sys_clk n36 enable_reg[7] VDD_1V8 DFRQHDLLX0
Xp_state_reg_0_ sys_rst_l sys_clk push p_state_0_ VSS VDD_1V8 DFRRQHDLLX0
Xcont_byte_reg_2_ sys_rst_l sys_clk n1 cont_byte[2] VSS VDD_1V8 DFRRQHDLLX0
Xcont_byte_reg_1_ sys_rst_l sys_clk n2 cont_byte[1] VSS VDD_1V8 DFRRQHDLLX0
Xstate_reg_1_ sys_rst_l sys_clk n3 state[1] VSS VDD_1V8 DFRRQHDLLX0
Xcont_byte_reg_0_ sys_rst_l sys_clk n4 cont_byte[0] VSS VDD_1V8 DFRRQHDLLX0
Xstate_reg_0_ sys_rst_l sys_clk n6 state[0] VSS VDD_1V8 DFRRQHDLLX0
XU26 n3 VSS VDD_1V8 n11 n10 state[1] state[0] flag_sincr AN32HDLLX0
XU10 n5 VSS VDD_1V8 state[1] flag_sincr flag_sincr n23 rec_ready AN32HDLLX0
.ENDS

.SUBCKT dff_async_rst_ena_63 data clk enable reset q VSS VDD_1V8
XU3 VSS n2 VDD_1V8 enable q data MU2HDLLX0
Xq_reg reset clk n2 q VSS VDD_1V8 DFRRQHDLLX0
.ENDS

.SUBCKT dff_async_rst_ena_62 data clk enable reset q VSS VDD_1V8
XU3 VSS n3 VDD_1V8 enable q data MU2HDLLX0
Xq_reg reset clk n3 q VSS VDD_1V8 DFRRQHDLLX0
.ENDS

.SUBCKT dff_async_rst_ena_61 data clk enable reset q VSS VDD_1V8
XU3 VSS n3 VDD_1V8 enable q data MU2HDLLX0
Xq_reg reset clk n3 q VSS VDD_1V8 DFRRQHDLLX0
.ENDS

.SUBCKT dff_async_rst_ena_60 data clk enable reset q VSS VDD_1V8
XU3 VSS n3 VDD_1V8 enable q data MU2HDLLX0
Xq_reg reset clk n3 q VSS VDD_1V8 DFRRQHDLLX0
.ENDS

.SUBCKT dff_async_rst_ena_59 data clk enable reset q VSS VDD_1V8
XU3 VSS n3 VDD_1V8 enable q data MU2HDLLX0
Xq_reg reset clk n3 q VSS VDD_1V8 DFRRQHDLLX0
.ENDS

.SUBCKT dff_async_rst_ena_58 data clk enable reset q VSS VDD_1V8
XU3 VSS n3 VDD_1V8 enable q data MU2HDLLX0
Xq_reg reset clk n3 q VSS VDD_1V8 DFRRQHDLLX0
.ENDS

.SUBCKT dff_async_rst_ena_57 data clk enable reset q VSS VDD_1V8
XU3 VSS n3 VDD_1V8 enable q data MU2HDLLX0
Xq_reg reset clk n3 q VSS VDD_1V8 DFRRQHDLLX0
.ENDS

.SUBCKT dff_async_rst_ena_56 data clk enable reset q VSS VDD_1V8
XU3 VSS n3 VDD_1V8 enable q data MU2HDLLX0
Xq_reg reset clk n3 q VSS VDD_1V8 DFRRQHDLLX0
.ENDS

.SUBCKT dff_async_rst_ena_55 data clk enable reset q VSS VDD_1V8
XU3 VSS n3 VDD_1V8 enable q data MU2HDLLX0
Xq_reg reset clk n3 q VSS VDD_1V8 DFRRQHDLLX0
.ENDS

.SUBCKT dff_async_rst_ena_54 data clk enable reset q VSS VDD_1V8
XU3 VSS n3 VDD_1V8 enable q data MU2HDLLX0
Xq_reg reset clk n3 q VSS VDD_1V8 DFRRQHDLLX0
.ENDS

.SUBCKT dff_async_rst_ena_53 data clk enable reset q VSS VDD_1V8
XU3 VSS n3 VDD_1V8 enable q data MU2HDLLX0
Xq_reg reset clk n3 q VSS VDD_1V8 DFRRQHDLLX0
.ENDS

.SUBCKT dff_async_rst_ena_52 data clk enable reset q VSS VDD_1V8
XU3 VSS n3 VDD_1V8 enable q data MU2HDLLX0
Xq_reg reset clk n3 q VSS VDD_1V8 DFRRQHDLLX0
.ENDS

.SUBCKT dff_async_rst_ena_51 data clk enable reset q VSS VDD_1V8
XU3 VSS n3 VDD_1V8 enable q data MU2HDLLX0
Xq_reg reset clk n3 q VSS VDD_1V8 DFRRQHDLLX0
.ENDS

.SUBCKT dff_async_rst_ena_50 data clk enable reset q VSS VDD_1V8
XU3 VSS n3 VDD_1V8 enable q data MU2HDLLX0
Xq_reg reset clk n3 q VSS VDD_1V8 DFRRQHDLLX0
.ENDS

.SUBCKT dff_async_rst_ena_49 data clk enable reset q VSS VDD_1V8
XU3 VSS n3 VDD_1V8 enable q data MU2HDLLX0
Xq_reg reset clk n3 q VSS VDD_1V8 DFRRQHDLLX0
.ENDS

.SUBCKT dff_async_rst_ena_48 data clk enable reset q VSS VDD_1V8
XU3 VSS n3 VDD_1V8 enable q data MU2HDLLX0
Xq_reg reset clk n3 q VSS VDD_1V8 DFRRQHDLLX0
.ENDS

.SUBCKT dff_async_rst_ena_47 data clk enable reset q VSS VDD_1V8
XU3 VSS n3 VDD_1V8 enable q data MU2HDLLX0
Xq_reg reset clk n3 q VSS VDD_1V8 DFRRQHDLLX0
.ENDS

.SUBCKT dff_async_rst_ena_46 data clk enable reset q VSS VDD_1V8
XU3 VSS n3 VDD_1V8 enable q data MU2HDLLX0
Xq_reg reset clk n3 q VSS VDD_1V8 DFRRQHDLLX0
.ENDS

.SUBCKT dff_async_rst_ena_45 data clk enable reset q VSS VDD_1V8
XU3 VSS n3 VDD_1V8 enable q data MU2HDLLX0
Xq_reg reset clk n3 q VSS VDD_1V8 DFRRQHDLLX0
.ENDS

.SUBCKT dff_async_rst_ena_44 data clk enable reset q VSS VDD_1V8
XU3 VSS n3 VDD_1V8 enable q data MU2HDLLX0
Xq_reg reset clk n3 q VSS VDD_1V8 DFRRQHDLLX0
.ENDS

.SUBCKT dff_async_rst_ena_43 data clk enable reset q VSS VDD_1V8
XU3 VSS n3 VDD_1V8 enable q data MU2HDLLX0
Xq_reg reset clk n3 q VSS VDD_1V8 DFRRQHDLLX0
.ENDS

.SUBCKT dff_async_rst_ena_42 data clk enable reset q VSS VDD_1V8
XU3 VSS n3 VDD_1V8 enable q data MU2HDLLX0
Xq_reg reset clk n3 q VSS VDD_1V8 DFRRQHDLLX0
.ENDS

.SUBCKT dff_async_rst_ena_41 data clk enable reset q VSS VDD_1V8
XU3 VSS n3 VDD_1V8 enable q data MU2HDLLX0
Xq_reg reset clk n3 q VSS VDD_1V8 DFRRQHDLLX0
.ENDS

.SUBCKT dff_async_rst_ena_40 data clk enable reset q VSS VDD_1V8
XU3 VSS n3 VDD_1V8 enable q data MU2HDLLX0
Xq_reg reset clk n3 q VSS VDD_1V8 DFRRQHDLLX0
.ENDS

.SUBCKT dff_async_rst_ena_39 data clk enable reset q VSS VDD_1V8
XU3 VSS n3 VDD_1V8 enable q data MU2HDLLX0
Xq_reg reset clk n3 q VSS VDD_1V8 DFRRQHDLLX0
.ENDS

.SUBCKT dff_async_rst_ena_38 data clk enable reset q VSS VDD_1V8
XU3 VSS n3 VDD_1V8 enable q data MU2HDLLX0
Xq_reg reset clk n3 q VSS VDD_1V8 DFRRQHDLLX0
.ENDS

.SUBCKT dff_async_rst_ena_37 data clk enable reset q VSS VDD_1V8
XU3 VSS n3 VDD_1V8 enable q data MU2HDLLX0
Xq_reg reset clk n3 q VSS VDD_1V8 DFRRQHDLLX0
.ENDS

.SUBCKT dff_async_rst_ena_36 data clk enable reset q VSS VDD_1V8
XU3 VSS n3 VDD_1V8 enable q data MU2HDLLX0
Xq_reg reset clk n3 q VSS VDD_1V8 DFRRQHDLLX0
.ENDS

.SUBCKT dff_async_rst_ena_35 data clk enable reset q VSS VDD_1V8
XU3 VSS n3 VDD_1V8 enable q data MU2HDLLX0
Xq_reg reset clk n3 q VSS VDD_1V8 DFRRQHDLLX0
.ENDS

.SUBCKT dff_async_rst_ena_34 data clk enable reset q VSS VDD_1V8
XU3 VSS n3 VDD_1V8 enable q data MU2HDLLX0
Xq_reg reset clk n3 q VSS VDD_1V8 DFRRQHDLLX0
.ENDS

.SUBCKT dff_async_rst_ena_33 data clk enable reset q VSS VDD_1V8
XU3 VSS n3 VDD_1V8 enable q data MU2HDLLX0
Xq_reg reset clk n3 q VSS VDD_1V8 DFRRQHDLLX0
.ENDS

.SUBCKT dff_async_rst_ena_32 data clk enable reset q VSS VDD_1V8
XU3 VSS n3 VDD_1V8 enable q data MU2HDLLX0
Xq_reg reset clk n3 q VSS VDD_1V8 DFRRQHDLLX0
.ENDS

.SUBCKT dff_async_rst_ena_31 data clk enable reset q VSS VDD_1V8
XU3 VSS n3 VDD_1V8 enable q data MU2HDLLX0
Xq_reg reset clk n3 q VSS VDD_1V8 DFRRQHDLLX0
.ENDS

.SUBCKT dff_async_rst_ena_30 data clk enable reset q VSS VDD_1V8
XU3 VSS n3 VDD_1V8 enable q data MU2HDLLX0
Xq_reg reset clk n3 q VSS VDD_1V8 DFRRQHDLLX0
.ENDS

.SUBCKT dff_async_rst_ena_29 data clk enable reset q VSS VDD_1V8
XU3 VSS n3 VDD_1V8 enable q data MU2HDLLX0
Xq_reg reset clk n3 q VSS VDD_1V8 DFRRQHDLLX0
.ENDS

.SUBCKT dff_async_rst_ena_28 data clk enable reset q VSS VDD_1V8
XU3 VSS n3 VDD_1V8 enable q data MU2HDLLX0
Xq_reg reset clk n3 q VSS VDD_1V8 DFRRQHDLLX0
.ENDS

.SUBCKT dff_async_rst_ena_27 data clk enable reset q VSS VDD_1V8
XU3 VSS n3 VDD_1V8 enable q data MU2HDLLX0
Xq_reg reset clk n3 q VSS VDD_1V8 DFRRQHDLLX0
.ENDS

.SUBCKT dff_async_rst_ena_26 data clk enable reset q VSS VDD_1V8
XU3 VSS n3 VDD_1V8 enable q data MU2HDLLX0
Xq_reg reset clk n3 q VSS VDD_1V8 DFRRQHDLLX0
.ENDS

.SUBCKT dff_async_rst_ena_25 data clk enable reset q VSS VDD_1V8
XU3 VSS n3 VDD_1V8 enable q data MU2HDLLX0
Xq_reg reset clk n3 q VSS VDD_1V8 DFRRQHDLLX0
.ENDS

.SUBCKT dff_async_rst_ena_24 data clk enable reset q VSS VDD_1V8
XU3 VSS n3 VDD_1V8 enable q data MU2HDLLX0
Xq_reg reset clk n3 q VSS VDD_1V8 DFRRQHDLLX0
.ENDS

.SUBCKT dff_async_rst_ena_23 data clk enable reset q VSS VDD_1V8
XU3 VSS n3 VDD_1V8 enable q data MU2HDLLX0
Xq_reg reset clk n3 q VSS VDD_1V8 DFRRQHDLLX0
.ENDS

.SUBCKT dff_async_rst_ena_22 data clk enable reset q VSS VDD_1V8
XU3 VSS n3 VDD_1V8 enable q data MU2HDLLX0
Xq_reg reset clk n3 q VSS VDD_1V8 DFRRQHDLLX0
.ENDS

.SUBCKT dff_async_rst_ena_21 data clk enable reset q VSS VDD_1V8
XU3 VSS n3 VDD_1V8 enable q data MU2HDLLX0
Xq_reg reset clk n3 q VSS VDD_1V8 DFRRQHDLLX0
.ENDS

.SUBCKT dff_async_rst_ena_20 data clk enable reset q VSS VDD_1V8
XU3 VSS n3 VDD_1V8 enable q data MU2HDLLX0
Xq_reg reset clk n3 q VSS VDD_1V8 DFRRQHDLLX0
.ENDS

.SUBCKT dff_async_rst_ena_19 data clk enable reset q VSS VDD_1V8
XU3 VSS n3 VDD_1V8 enable q data MU2HDLLX0
Xq_reg reset clk n3 q VSS VDD_1V8 DFRRQHDLLX0
.ENDS

.SUBCKT dff_async_rst_ena_18 data clk enable reset q VSS VDD_1V8
XU3 VSS n3 VDD_1V8 enable q data MU2HDLLX0
Xq_reg reset clk n3 q VSS VDD_1V8 DFRRQHDLLX0
.ENDS

.SUBCKT dff_async_rst_ena_17 data clk enable reset q VSS VDD_1V8
XU3 VSS n3 VDD_1V8 enable q data MU2HDLLX0
Xq_reg reset clk n3 q VSS VDD_1V8 DFRRQHDLLX0
.ENDS

.SUBCKT dff_async_rst_ena_16 data clk enable reset q VSS VDD_1V8
XU3 VSS n3 VDD_1V8 enable q data MU2HDLLX0
Xq_reg reset clk n3 q VSS VDD_1V8 DFRRQHDLLX0
.ENDS

.SUBCKT dff_async_rst_ena_15 data clk enable reset q VSS VDD_1V8
XU3 VSS n3 VDD_1V8 enable q data MU2HDLLX0
Xq_reg reset clk n3 q VSS VDD_1V8 DFRRQHDLLX0
.ENDS

.SUBCKT dff_async_rst_ena_14 data clk enable reset q VSS VDD_1V8
XU3 VSS n3 VDD_1V8 enable q data MU2HDLLX0
Xq_reg reset clk n3 q VSS VDD_1V8 DFRRQHDLLX0
.ENDS

.SUBCKT dff_async_rst_ena_13 data clk enable reset q VSS VDD_1V8
XU3 VSS n3 VDD_1V8 enable q data MU2HDLLX0
Xq_reg reset clk n3 q VSS VDD_1V8 DFRRQHDLLX0
.ENDS

.SUBCKT dff_async_rst_ena_12 data clk enable reset q VSS VDD_1V8
XU3 VSS n3 VDD_1V8 enable q data MU2HDLLX0
Xq_reg reset clk n3 q VSS VDD_1V8 DFRRQHDLLX0
.ENDS

.SUBCKT dff_async_rst_ena_11 data clk enable reset q VSS VDD_1V8
XU3 VSS n3 VDD_1V8 enable q data MU2HDLLX0
Xq_reg reset clk n3 q VSS VDD_1V8 DFRRQHDLLX0
.ENDS

.SUBCKT dff_async_rst_ena_10 data clk enable reset q VSS VDD_1V8
XU3 VSS n3 VDD_1V8 enable q data MU2HDLLX0
Xq_reg reset clk n3 q VSS VDD_1V8 DFRRQHDLLX0
.ENDS

.SUBCKT dff_async_rst_ena_9 data clk enable reset q VSS VDD_1V8
XU3 VSS n3 VDD_1V8 enable q data MU2HDLLX0
Xq_reg reset clk n3 q VSS VDD_1V8 DFRRQHDLLX0
.ENDS

.SUBCKT dff_async_rst_ena_8 data clk enable reset q VSS VDD_1V8
XU3 VSS n3 VDD_1V8 enable q data MU2HDLLX0
Xq_reg reset clk n3 q VSS VDD_1V8 DFRRQHDLLX0
.ENDS

.SUBCKT dff_async_rst_ena_7 data clk enable reset q VSS VDD_1V8
XU3 VSS n3 VDD_1V8 enable q data MU2HDLLX0
Xq_reg reset clk n3 q VSS VDD_1V8 DFRRQHDLLX0
.ENDS

.SUBCKT dff_async_rst_ena_6 data clk enable reset q VSS VDD_1V8
XU3 VSS n3 VDD_1V8 enable q data MU2HDLLX0
Xq_reg reset clk n3 q VSS VDD_1V8 DFRRQHDLLX0
.ENDS

.SUBCKT dff_async_rst_ena_5 data clk enable reset q VSS VDD_1V8
XU3 VSS n3 VDD_1V8 enable q data MU2HDLLX0
Xq_reg reset clk n3 q VSS VDD_1V8 DFRRQHDLLX0
.ENDS

.SUBCKT dff_async_rst_ena_4 data clk enable reset q VSS VDD_1V8
XU3 VSS n3 VDD_1V8 enable q data MU2HDLLX0
Xq_reg reset clk n3 q VSS VDD_1V8 DFRRQHDLLX0
.ENDS

.SUBCKT dff_async_rst_ena_3 data clk enable reset q VSS VDD_1V8
XU3 VSS n3 VDD_1V8 enable q data MU2HDLLX0
Xq_reg reset clk n3 q VSS VDD_1V8 DFRRQHDLLX0
.ENDS

.SUBCKT dff_async_rst_ena_2 data clk enable reset q VSS VDD_1V8
XU3 VSS n3 VDD_1V8 enable q data MU2HDLLX0
Xq_reg reset clk n3 q VSS VDD_1V8 DFRRQHDLLX0
.ENDS

.SUBCKT dff_async_rst_ena_1 data clk enable reset q VSS VDD_1V8
XU3 VSS n3 VDD_1V8 enable q data MU2HDLLX0
Xq_reg reset clk n3 q VSS VDD_1V8 DFRRQHDLLX0
.ENDS

.SUBCKT dff_async_rst_ena_0 data clk enable reset q VSS VDD_1V8
XU3 VSS n3 VDD_1V8 enable q data MU2HDLLX0
Xq_reg reset clk n3 q VSS VDD_1V8 DFRRQHDLLX0
.ENDS

.SUBCKT spi CLK reset MISO data_config[15] data_config[14] data_config[13] data_config[12]
+ data_config[11] data_config[10] data_config[9] data_config[8] data_config[7] data_config[6]
+ data_config[5] data_config[4] data_config[3] data_config[2] data_config[1] data_config[0]
+ config_enable data_send[63] data_send[62] data_send[61] data_send[60] data_send[59]
+ data_send[58] data_send[57] data_send[56] data_send[55] data_send[54] data_send[53]
+ data_send[52] data_send[51] data_send[50] data_send[49] data_send[48] data_send[47]
+ data_send[46] data_send[45] data_send[44] data_send[43] data_send[42] data_send[41]
+ data_send[40] data_send[39] data_send[38] data_send[37] data_send[36] data_send[35]
+ data_send[34] data_send[33] data_send[32] data_send[31] data_send[30] data_send[29]
+ data_send[28] data_send[27] data_send[26] data_send[25] data_send[24] data_send[23]
+ data_send[22] data_send[21] data_send[20] data_send[19] data_send[18] data_send[17]
+ data_send[16] data_send[15] data_send[14] data_send[13] data_send[12] data_send[11]
+ data_send[10] data_send[9] data_send[8] data_send[7] data_send[6] data_send[5]
+ data_send[4] data_send[3] data_send[2] data_send[1] data_send[0] send_data data_read[31]
+ data_read[30] data_read[29] data_read[28] data_read[27] data_read[26] data_read[25]
+ data_read[24] data_read[23] data_read[22] data_read[21] data_read[20] data_read[19]
+ data_read[18] data_read[17] data_read[16] data_read[15] data_read[14] data_read[13]
+ data_read[12] data_read[11] data_read[10] data_read[9] data_read[8] data_read[7]
+ data_read[6] data_read[5] data_read[4] data_read[3] data_read[2] data_read[1]
+ data_read[0] MOSI CS SCK end_send VSS VDD_1V8 IN0 IN1 IN2 IN3 IN4 IN5 IN6 IN7
+ CLK_cts_1 CLK_cts_3 CLK_cts_4 CLK_cts_5
Xstate0_reg VSS VDD_1V8 state0 IN3 CLK_cts_5 n280 DFFSQHDLLX0
XU33 n41 VSS VDD_1V8 n347 conf[11] conf[13] n348 ON22HDLLX0
XU34 n42 VSS conf[13] VDD_1V8 n348 conf[11] n41 n347 AN221HDLLX0
XU35 VSS n43 VDD_1V8 n42 n346 conf[14] ON21HDLLX0
XU29 VSS bits_count[1] bits_count[7] VDD_1V8 n57 n345 NA3I2HDLLX0
XU36 VSS VDD_1V8 n44 conf[14] n346 bits_count[0] n43 AN211HDLLX0
XU55 n346 n347 VSS VDD_1V8 n343 n58 n348 NA4HDLLX0
XU56 VSS n59 VDD_1V8 n57 flag_edge_detector[0] n58 bits_count[4] ON31HDLLX0
XU37 VSS n45 VDD_1V8 n44 n344 conf[12] ON21HDLLX0
XU300 n232 VSS VDD_1V8 state0 INHDLLX0
Xplace3 VSS VDD_1V8 n128 n258 BUHDLLX0
XU304 n310 VSS flag_edge_detector[0] VDD_1V8 flag_edge_detector[1] NA2I1HDLLX0
XU335 n292 VSS VDD_1V8 counter_CS[4] INHDLLX0
XU336 n295 VSS counter_CS[0] counter_CS[1] VDD_1V8 counter_CS[2] NA3HDLLX0
XU41 n296 VSS VDD_1V8 counter_CS[3] INHDLLX0
XU38 VSS VDD_1V8 n231 conf[12] n344 n57 n45 AN211HDLLX0
XU306 n247 VSS bits_count[2] bits_count[0] VDD_1V8 bits_count[1] NA3HDLLX0
XU310 VSS n310 n232 VDD_1V8 n235 NA2HDLLX0
XU333 conf[0] n342 VSS VDD_1V8 state[1] n306 state[0] NA4HDLLX0
XU337 n260 VSS VDD_1V8 n292 n295 n296 NO3HDLLX0
XU72 VSS counter_clk[0] counter_clk[1] VDD_1V8 n66 NA2HDLLX0
XU305 n251 VSS VDD_1V8 state0 n310 n231 NO3HDLLX0
Xplace4 VSS VDD_1V8 n175 n128 BUHDLLX0
Xplace8 VSS VDD_1V8 n188 conf[2] BUHDLLX0
Xplace11 VSS VDD_1V8 n211 n60 BUHDLLX0
XU19 VSS n225 VDD_1V8 conf[0] state[1] state[0] ON21HDLLX0
XU84 n70 VSS VDD_1V8 counter_clk[4] INHDLLX0
XU82 counter_clk[1] counter_clk[3] VSS VDD_1V8 counter_clk[0] n69 counter_clk[2] NA4HDLLX0
XU44 n303 VSS VDD_1V8 counter_CS[1] INHDLLX0
XU42 n300 VSS VDD_1V8 counter_CS[2] INHDLLX0
XU58 VSS n175 n211 VDD_1V8 n219 NA2HDLLX0
XU22 n222 VSS VDD_1V8 state[0] INHDLLX0
XU20 VSS n298 n342 n225 VDD_1V8 NO2HDLLX0
XU73 VSS n65 counter_clk[2] n66 VDD_1V8 NO2HDLLX0
Xplace5 n176 VSS VDD_1V8 n175 INHDLLX0
Xplace9 n208 VSS VDD_1V8 n188 INHDLLX0
Xplace10 n210 VSS VDD_1V8 n306 INHDLLX0
XU307 n240 VSS VDD_1V8 n347 n247 n344 NO3HDLLX0
XU311 n250 VSS VDD_1V8 n235 INHDLLX0
XU339 n288 VSS VDD_1V8 n260 INHDLLX0
XU85 VSS n71 n70 n69 VDD_1V8 NO2HDLLX0
XU312 n250 n237 VSS VDD_1V8 n242 n240 NO22HDLLX0
XU340 n288 VSS n298 n210 VDD_1V8 n291 AN21HDLLX0
XU89 n73 VSS VDD_1V8 counter_clk[6] INHDLLX0
XU87 VSS counter_clk[5] n71 VDD_1V8 n72 NA2HDLLX0
XU40 VSS VDD_1V8 counter_CS[6] counter_CS[5] counter_CS[4] n47 counter_CS[7] NA4I3HDLLX0
XU95 VSS n207 n188 n219 VDD_1V8 NO2HDLLX0
XU45 n341 n303 VSS VDD_1V8 n300 n46 n296 NA4HDLLX0
XU47 n226 VSS VDD_1V8 n222 n183 state[2] NO3HDLLX0
XU61 VSS n149 n211 n176 VDD_1V8 NO2HDLLX0
XU65 VSS n156 n208 n219 VDD_1V8 NO2HDLLX0
XU74 VSS VDD_1V8 counter_clk[6] counter_clk[3] n65 n64 counter_clk[5] NA4I3HDLLX0
Xplace6 n179 VSS VDD_1V8 n128 INHDLLX0
XU332 n285 VSS VDD_1V8 counter_CS[6] INHDLLX0
XU313 VSS n236 VDD_1V8 n242 n237 bits_count[5] ON21HDLLX0
Xplace13 VSS VDD_1V8 n215 n149 BUHDLLX0
Xplace14 VSS VDD_1V8 n216 n149 BUHDLLX0
Xplace15 VSS VDD_1V8 n218 n156 BUHDLLX0
Xplace16 VSS VDD_1V8 n221 n156 BUHDLLX0
XU75 VSS n230 VDD_1V8 n64 clk_enable counter_clk[7] counter_clk[4] ON31HDLLX0
Xplace17 VSS VDD_1V8 n228 n207 BUHDLLX0
Xplace18 VSS VDD_1V8 n234 n207 BUHDLLX0
XU48 VSS n226 conf[0] VDD_1V8 n223 NA2HDLLX0
XU46 VSS n224 n47 n46 VDD_1V8 NO2HDLLX0
XU63 VSS VDD_1V8 n76 data_send[0] n175 NO2I1HDLLX0
XU341 VSS n284 VDD_1V8 n291 n306 counter_CS[5] ON21HDLLX0
XU346 n290 VSS VDD_1V8 counter_CS[5] INHDLLX0
XU90 VSS n75 n73 n72 VDD_1V8 NO2HDLLX0
XU21 n307 VSS VDD_1V8 n298 INHDLLX0
XU163 VSS VDD_1V8 n118 n216 tx_shiftreg[21] n234 tx_shiftreg[20] AN22HDLLX0
XU81 VSS n68 counter_clk[1] counter_clk[0] VDD_1V8 counter_clk[2] AND3HDLLX0
XU240 VSS VDD_1V8 n172 data_send[44] n218 tx_shiftreg[43] n176 AN22HDLLX0
XU102 VSS VDD_1V8 n79 tx_shiftreg[1] tx_shiftreg[2] n234 n216 AN22HDLLX0
XU94 VSS VDD_1V8 n78 n76 tx_shiftreg[62] n218 n208 AN22HDLLX0
XU268 VSS VDD_1V8 n195 n215 tx_shiftreg[54] n228 tx_shiftreg[53] AN22HDLLX0
XU100 VSS VDD_1V8 n80 data_send[1] n221 tx_shiftreg[0] n179 AN22HDLLX0
XU175 VSS VDD_1V8 n130 data_send[24] n221 tx_shiftreg[23] n179 AN22HDLLX0
XU241 VSS VDD_1V8 n171 n215 tx_shiftreg[45] n228 tx_shiftreg[44] AN22HDLLX0
XU166 VSS VDD_1V8 n121 n216 tx_shiftreg[22] n234 tx_shiftreg[21] AN22HDLLX0
XU165 VSS VDD_1V8 n122 data_send[21] n221 tx_shiftreg[20] n179 AN22HDLLX0
XU265 VSS VDD_1V8 n193 n215 tx_shiftreg[53] n228 tx_shiftreg[52] AN22HDLLX0
XU159 VSS VDD_1V8 n117 data_send[19] n221 tx_shiftreg[18] n179 AN22HDLLX0
XU271 VSS VDD_1V8 n197 n215 tx_shiftreg[55] n228 tx_shiftreg[54] AN22HDLLX0
XU157 VSS VDD_1V8 n114 n216 tx_shiftreg[19] n234 tx_shiftreg[18] AN22HDLLX0
XU92 VSS n74 counter_clk[7] n75 VDD_1V8 NO2HDLLX0
XU273 VSS VDD_1V8 n200 data_send[55] n218 tx_shiftreg[54] n176 AN22HDLLX0
XU105 VSS VDD_1V8 n81 n216 tx_shiftreg[3] n234 tx_shiftreg[2] AN22HDLLX0
XU160 VSS VDD_1V8 n116 n216 tx_shiftreg[20] n234 tx_shiftreg[19] AN22HDLLX0
XU270 VSS VDD_1V8 n198 data_send[54] n218 tx_shiftreg[53] n176 AN22HDLLX0
XU104 VSS VDD_1V8 n82 data_send[2] tx_shiftreg[1] n221 n179 AN22HDLLX0
XU162 VSS VDD_1V8 n119 data_send[20] n221 tx_shiftreg[19] n179 AN22HDLLX0
XU108 VSS VDD_1V8 n84 data_send[3] n221 tx_shiftreg[2] n179 AN22HDLLX0
XU156 VSS VDD_1V8 n115 data_send[18] n221 tx_shiftreg[17] n179 AN22HDLLX0
XU79 counter_clk[2] VSS n65 n66 VDD_1V8 n67 AN21HDLLX0
XU154 VSS VDD_1V8 n112 n216 tx_shiftreg[18] n234 tx_shiftreg[17] AN22HDLLX0
XU109 VSS VDD_1V8 n83 n216 tx_shiftreg[4] n234 tx_shiftreg[3] AN22HDLLX0
XU267 VSS VDD_1V8 n196 data_send[53] n218 tx_shiftreg[52] n176 AN22HDLLX0
XU111 VSS VDD_1V8 n86 data_send[4] n221 tx_shiftreg[3] n179 AN22HDLLX0
XU98 VSS VDD_1V8 n77 n215 tx_shiftreg[1] n228 IN0 AN22HDLLX0
XU264 VSS VDD_1V8 n194 data_send[52] n218 tx_shiftreg[51] n176 AN22HDLLX0
XU243 VSS VDD_1V8 n174 data_send[45] n218 tx_shiftreg[44] n176 AN22HDLLX0
XU244 VSS VDD_1V8 n173 n215 tx_shiftreg[46] n228 tx_shiftreg[45] AN22HDLLX0
XU262 VSS VDD_1V8 n191 n215 tx_shiftreg[52] n228 tx_shiftreg[51] AN22HDLLX0
XU112 VSS VDD_1V8 n85 n216 tx_shiftreg[5] n234 tx_shiftreg[4] AN22HDLLX0
XU153 VSS VDD_1V8 n113 data_send[17] n221 tx_shiftreg[16] n179 AN22HDLLX0
XU151 VSS VDD_1V8 n110 n216 tx_shiftreg[17] n234 tx_shiftreg[16] AN22HDLLX0
XU114 VSS VDD_1V8 n88 data_send[5] n221 tx_shiftreg[4] n179 AN22HDLLX0
XU246 VSS VDD_1V8 n178 data_send[46] n218 tx_shiftreg[45] n176 AN22HDLLX0
XU247 VSS VDD_1V8 n177 n215 tx_shiftreg[47] n228 tx_shiftreg[46] AN22HDLLX0
XU150 VSS VDD_1V8 n111 data_send[16] n221 tx_shiftreg[15] n179 AN22HDLLX0
XU115 VSS VDD_1V8 n87 n216 tx_shiftreg[6] n234 tx_shiftreg[5] AN22HDLLX0
XU261 VSS VDD_1V8 n192 data_send[51] n218 tx_shiftreg[50] n176 AN22HDLLX0
XU117 VSS VDD_1V8 n90 data_send[6] n221 tx_shiftreg[5] n179 AN22HDLLX0
XU118 VSS VDD_1V8 n89 n216 tx_shiftreg[7] n234 tx_shiftreg[6] AN22HDLLX0
XU120 VSS VDD_1V8 n92 data_send[7] n221 tx_shiftreg[6] n179 AN22HDLLX0
XU249 VSS VDD_1V8 n182 data_send[47] n218 tx_shiftreg[46] n176 AN22HDLLX0
XU121 VSS VDD_1V8 n91 n216 tx_shiftreg[8] n234 tx_shiftreg[7] AN22HDLLX0
XU250 VSS VDD_1V8 n181 n215 tx_shiftreg[48] n228 tx_shiftreg[47] AN22HDLLX0
XU123 VSS VDD_1V8 n94 data_send[8] n221 tx_shiftreg[7] n179 AN22HDLLX0
XU124 VSS VDD_1V8 n93 n216 tx_shiftreg[9] n234 tx_shiftreg[8] AN22HDLLX0
XU259 VSS VDD_1V8 n189 n215 tx_shiftreg[51] n228 tx_shiftreg[50] AN22HDLLX0
XU258 VSS VDD_1V8 n190 data_send[50] n218 tx_shiftreg[49] n176 AN22HDLLX0
XU126 VSS VDD_1V8 n96 data_send[9] n221 tx_shiftreg[8] n179 AN22HDLLX0
XU128 VSS VDD_1V8 n95 n216 tx_shiftreg[10] n234 tx_shiftreg[9] AN22HDLLX0
XU130 VSS VDD_1V8 n98 data_send[10] n221 tx_shiftreg[9] n179 AN22HDLLX0
XU148 VSS VDD_1V8 n108 n216 tx_shiftreg[16] n234 tx_shiftreg[15] AN22HDLLX0
XU131 VSS VDD_1V8 n97 n216 tx_shiftreg[11] n234 tx_shiftreg[10] AN22HDLLX0
XU147 VSS VDD_1V8 n109 data_send[15] n221 tx_shiftreg[14] n179 AN22HDLLX0
XU145 VSS VDD_1V8 n106 n216 tx_shiftreg[15] n234 tx_shiftreg[14] AN22HDLLX0
XU144 VSS VDD_1V8 n107 data_send[14] n221 tx_shiftreg[13] n179 AN22HDLLX0
XU252 VSS VDD_1V8 n185 data_send[48] n218 tx_shiftreg[47] n176 AN22HDLLX0
XU253 VSS VDD_1V8 n184 n215 tx_shiftreg[49] n228 tx_shiftreg[48] AN22HDLLX0
XU23 n52 VSS n342 n222 VDD_1V8 conf[0] NA3HDLLX0
XU39 VSS VDD_1V8 n53 send_data n231 state[1] n183 AN22HDLLX0
XU134 VSS VDD_1V8 n100 data_send[11] n221 tx_shiftreg[10] n179 AN22HDLLX0
XU168 VSS VDD_1V8 n124 data_send[22] n221 tx_shiftreg[21] n179 AN22HDLLX0
XU170 VSS VDD_1V8 n123 n216 tx_shiftreg[23] n234 tx_shiftreg[22] AN22HDLLX0
XU142 VSS VDD_1V8 n104 n216 tx_shiftreg[14] n234 tx_shiftreg[13] AN22HDLLX0
XU25 VSS send_data n183 VDD_1V8 n40 NA2HDLLX0
XU172 VSS VDD_1V8 n126 data_send[23] n221 tx_shiftreg[22] n179 AN22HDLLX0
XU135 VSS VDD_1V8 n99 n216 tx_shiftreg[12] n234 tx_shiftreg[11] AN22HDLLX0
XU173 VSS VDD_1V8 n125 n216 tx_shiftreg[24] n234 tx_shiftreg[23] AN22HDLLX0
XU137 VSS VDD_1V8 n102 data_send[12] n221 tx_shiftreg[11] n179 AN22HDLLX0
XU141 VSS VDD_1V8 n105 data_send[13] n221 tx_shiftreg[12] n179 AN22HDLLX0
XU255 VSS VDD_1V8 n187 data_send[49] n218 tx_shiftreg[48] n176 AN22HDLLX0
XU256 VSS VDD_1V8 n186 n215 tx_shiftreg[50] n228 tx_shiftreg[49] AN22HDLLX0
XU139 VSS VDD_1V8 n101 n216 tx_shiftreg[13] n234 tx_shiftreg[12] AN22HDLLX0
XU50 VSS VDD_1V8 state[0] n183 n222 state[1] n231 n56 OA32HDLLX0
XU237 VSS VDD_1V8 n170 data_send[43] n218 tx_shiftreg[42] n176 AN22HDLLX0
XU235 VSS VDD_1V8 n167 n215 tx_shiftreg[43] n228 tx_shiftreg[42] AN22HDLLX0
XU234 VSS VDD_1V8 n168 data_send[42] n218 tx_shiftreg[41] n176 AN22HDLLX0
XU232 VSS VDD_1V8 n165 n215 tx_shiftreg[42] n228 tx_shiftreg[41] AN22HDLLX0
XU231 VSS VDD_1V8 n166 data_send[41] n218 tx_shiftreg[40] n176 AN22HDLLX0
XU229 VSS VDD_1V8 n163 n215 tx_shiftreg[41] n228 tx_shiftreg[40] AN22HDLLX0
XU228 VSS VDD_1V8 n164 data_send[40] n218 tx_shiftreg[39] n176 AN22HDLLX0
XU226 VSS VDD_1V8 n161 n215 tx_shiftreg[40] n228 tx_shiftreg[39] AN22HDLLX0
XU225 VSS VDD_1V8 n162 data_send[39] n218 tx_shiftreg[38] n176 AN22HDLLX0
XU223 VSS VDD_1V8 n159 n215 tx_shiftreg[39] n228 tx_shiftreg[38] AN22HDLLX0
XU222 VSS VDD_1V8 n160 data_send[38] n218 tx_shiftreg[37] n176 AN22HDLLX0
XU220 VSS VDD_1V8 n157 n215 tx_shiftreg[38] n228 tx_shiftreg[37] AN22HDLLX0
XU219 VSS VDD_1V8 n158 data_send[37] n218 tx_shiftreg[36] n176 AN22HDLLX0
XU216 VSS VDD_1V8 n154 n215 tx_shiftreg[37] n228 tx_shiftreg[36] AN22HDLLX0
XU214 VSS VDD_1V8 n155 data_send[36] n218 tx_shiftreg[35] n176 AN22HDLLX0
XU212 VSS VDD_1V8 n152 n215 tx_shiftreg[36] n228 tx_shiftreg[35] AN22HDLLX0
XU211 VSS VDD_1V8 n153 data_send[35] n218 tx_shiftreg[34] n176 AN22HDLLX0
XU209 VSS VDD_1V8 n150 n215 tx_shiftreg[35] n228 tx_shiftreg[34] AN22HDLLX0
XU207 VSS VDD_1V8 n151 data_send[34] n218 tx_shiftreg[33] n176 AN22HDLLX0
XU205 VSS VDD_1V8 n147 n215 tx_shiftreg[34] n228 tx_shiftreg[33] AN22HDLLX0
XU204 VSS VDD_1V8 n148 data_send[33] n218 tx_shiftreg[32] n176 AN22HDLLX0
XU202 VSS VDD_1V8 n145 n216 tx_shiftreg[33] n234 tx_shiftreg[32] AN22HDLLX0
XU201 VSS VDD_1V8 n146 data_send[32] n221 tx_shiftreg[31] n176 AN22HDLLX0
XU199 VSS VDD_1V8 n143 n216 tx_shiftreg[32] n234 tx_shiftreg[31] AN22HDLLX0
XU198 VSS VDD_1V8 n144 data_send[31] n221 tx_shiftreg[30] n179 AN22HDLLX0
XU196 VSS VDD_1V8 n141 n216 tx_shiftreg[31] n234 tx_shiftreg[30] AN22HDLLX0
XU195 VSS VDD_1V8 n142 data_send[30] n221 tx_shiftreg[29] n179 AN22HDLLX0
XU193 VSS VDD_1V8 n139 n216 tx_shiftreg[30] n234 tx_shiftreg[29] AN22HDLLX0
XU192 VSS VDD_1V8 n140 data_send[29] n221 tx_shiftreg[28] n179 AN22HDLLX0
XU190 VSS VDD_1V8 n137 n216 tx_shiftreg[29] n234 tx_shiftreg[28] AN22HDLLX0
XU189 VSS VDD_1V8 n138 data_send[28] n221 tx_shiftreg[27] n179 AN22HDLLX0
XU187 VSS VDD_1V8 n135 n216 tx_shiftreg[28] n234 tx_shiftreg[27] AN22HDLLX0
XU186 VSS VDD_1V8 n136 data_send[27] n221 tx_shiftreg[26] n179 AN22HDLLX0
XU184 VSS VDD_1V8 n133 n216 tx_shiftreg[27] n234 tx_shiftreg[26] AN22HDLLX0
XU183 VSS VDD_1V8 n134 data_send[26] n221 tx_shiftreg[25] n179 AN22HDLLX0
XU181 VSS VDD_1V8 n131 n216 tx_shiftreg[26] n234 tx_shiftreg[25] AN22HDLLX0
XU179 VSS VDD_1V8 n132 data_send[25] n221 tx_shiftreg[24] n179 AN22HDLLX0
XU176 VSS VDD_1V8 n129 n216 tx_shiftreg[25] n234 tx_shiftreg[24] AN22HDLLX0
XU356 n301 VSS counter_CS[0] counter_CS[1] VDD_1V8 n210 NA3HDLLX0
XU355 VSS n210 n303 VDD_1V8 n302 NA2HDLLX0
XU354 n341 VSS n298 n210 VDD_1V8 n304 AN21HDLLX0
XU238 VSS VDD_1V8 n169 n215 tx_shiftreg[44] n228 tx_shiftreg[43] AN22HDLLX0
XU351 VSS n295 n306 VDD_1V8 n293 counter_CS[3] NA3I2HDLLX0
XU350 VSS n210 n296 VDD_1V8 n294 NA2HDLLX0
XU349 n295 VSS n298 n210 VDD_1V8 n297 AN21HDLLX0
XU347 VSS n210 n290 VDD_1V8 n289 NA2HDLLX0
XU344 n287 VSS VDD_1V8 n284 INHDLLX0
XU342 n261 VSS VDD_1V8 n284 counter_CS[7] counter_CS[7] n285 n210 AN32HDLLX0
XU338 n286 VSS counter_CS[5] n260 VDD_1V8 n210 NA3HDLLX0
XU329 n253 VSS bits_count[0] n251 VDD_1V8 bits_count[1] NA3HDLLX0
XU328 VSS n251 n340 VDD_1V8 n254 NA2HDLLX0
XU326 n343 VSS n250 n251 VDD_1V8 n257 AN21HDLLX0
XU323 VSS n247 n347 VDD_1V8 n245 n251 NA3I2HDLLX0
XU322 VSS n251 n347 VDD_1V8 n246 NA2HDLLX0
XU321 n247 VSS n250 n251 VDD_1V8 n249 AN21HDLLX0
XU319 n241 VSS n240 n348 VDD_1V8 n251 NA3HDLLX0
XU317 n239 VSS VDD_1V8 n236 INHDLLX0
XU314 n233 VSS VDD_1V8 n236 bits_count[7] bits_count[7] n346 n251 AN32HDLLX0
XU308 n238 VSS n251 n240 VDD_1V8 bits_count[5] NA3HDLLX0
XU302 n229 VSS VDD_1V8 SCK INHDLLX0
XU299 VSS VDD_1V8 n227 state[1] n231 n226 n225 AN211HDLLX0
XU297 VSS VDD_1V8 N336 n224 n223 NO2I1HDLLX0
XU295 VSS conf[0] n342 VDD_1V8 n220 NA2HDLLX0
XU293 tx_shiftreg[63] VSS n228 n215 VDD_1V8 n217 AN21HDLLX0
XU289 VSS VDD_1V8 n212 n215 tx_shiftreg[62] n228 tx_shiftreg[61] AN22HDLLX0
XU288 VSS VDD_1V8 n213 data_send[61] n218 tx_shiftreg[60] n176 AN22HDLLX0
XU283 VSS VDD_1V8 n205 n215 tx_shiftreg[59] n228 tx_shiftreg[58] AN22HDLLX0
XU282 VSS VDD_1V8 n206 data_send[58] n218 tx_shiftreg[57] n176 AN22HDLLX0
XU280 VSS VDD_1V8 n203 n215 tx_shiftreg[58] n228 tx_shiftreg[57] AN22HDLLX0
XU279 VSS VDD_1V8 n204 data_send[57] n218 tx_shiftreg[56] n176 AN22HDLLX0
XU277 VSS VDD_1V8 n201 n215 tx_shiftreg[57] n228 tx_shiftreg[56] AN22HDLLX0
XU276 VSS VDD_1V8 n202 data_send[56] n218 tx_shiftreg[55] n176 AN22HDLLX0
XU274 VSS VDD_1V8 n199 n215 tx_shiftreg[56] n228 tx_shiftreg[55] AN22HDLLX0
XU395 VSS config_enable data_config[0] VDD_1V8 n312 NA2HDLLX0
XU394 n311 VSS VDD_1V8 conf[0] INHDLLX0
XU51 VSS conf[0] n307 VDD_1V8 n55 NA2HDLLX0
XU52 n54 VSS VDD_1V8 clk_enable INHDLLX0
XU59 n62 VSS VDD_1V8 tx_shiftreg[1] INHDLLX0
XU67 VSS VDD_1V8 n61 n215 tx_shiftreg[0] n76 n218 AN211HDLLX0
XU70 CS VSS n225 state[2] VDD_1V8 n63 AN21HDLLX0
XU360 VSS n309 n188 n310 VDD_1V8 NO2HDLLX1
XU361 VSS n308 n310 n208 VDD_1V8 NO2HDLLX1
XU287 VSS N253 tx_shiftreg[61] n215 tx_shiftreg[59] tx_shiftreg[60] VDD_1V8 n228
+ n218 AO222HDLLX0
XU290 VSS n213 n212 VDD_1V8 N254 NA2HDLLX0
XU291 VSS N255 tx_shiftreg[63] n218 n215 tx_shiftreg[61] VDD_1V8 n228 tx_shiftreg[62] AO222HDLLX0
XU294 VSS N256 VDD_1V8 n217 n339 n219 ON21HDLLX0
XU296 VSS VDD_1V8 n183 state[0] n224 n220 n222 state[1] N335 AN321HDLLX0
XU298 IN1 VSS VDD_1V8 N336 n298 n281 AO21HDLLX0
XU301 VSS VDD_1V8 n280 n298 n342 n227 n232 AN22HDLLX0
XU303 n278 VSS VDD_1V8 n229 n214 n230 clk_enable SCK AN32HDLLX0
XU315 VSS n277 VDD_1V8 n238 n233 n346 bits_count[7] ON31HDLLX0
XU316 VSS VDD_1V8 n276 n237 n235 bits_count[0] n343 AN22HDLLX0
XU318 VSS VDD_1V8 n275 n238 n239 bits_count[6] n346 AN22HDLLX0
XU320 VSS n274 VDD_1V8 n241 n242 n348 ON21HDLLX0
XU324 n273 VSS VDD_1V8 n245 n344 bits_count[4] n246 n249 AN32HDLLX0
XU325 n272 VSS VDD_1V8 n247 n246 n347 n249 ON22HDLLX0
XU330 n271 VSS VDD_1V8 n253 n345 bits_count[2] n254 n257 AN32HDLLX0
XU331 n270 VSS VDD_1V8 n343 n254 n340 n257 ON22HDLLX0
XU343 VSS n269 VDD_1V8 n286 n261 n285 counter_CS[7] ON31HDLLX0
XU345 VSS VDD_1V8 n268 n286 n287 counter_CS[6] n285 AN22HDLLX0
XU348 n267 VSS VDD_1V8 n289 n288 n290 n291 ON22HDLLX0
XU352 n266 VSS VDD_1V8 n293 n292 counter_CS[4] n294 n297 AN32HDLLX0
XU353 n265 VSS VDD_1V8 n295 n294 n296 n297 ON22HDLLX0
XU357 n264 VSS VDD_1V8 n301 n300 counter_CS[2] n302 n304 AN32HDLLX0
XU358 n263 VSS VDD_1V8 n341 n302 n303 n304 ON22HDLLX0
XU359 VSS VDD_1V8 n262 n306 n307 counter_CS[0] n341 AN22HDLLX0
XU362 VSS n3 data_read[31] n308 MISO1 data_read[30] VDD_1V8 n310 n309 AO222HDLLX0
XU363 VSS n4 data_read[0] MISO1 data_read[1] n308 VDD_1V8 n310 n309 AO222HDLLX0
XU364 VSS n5 data_read[1] n308 data_read[2] data_read[0] VDD_1V8 n310 n309 AO222HDLLX0
XU365 VSS n6 data_read[2] n308 data_read[3] data_read[1] VDD_1V8 n310 n309 AO222HDLLX0
XU366 VSS n7 data_read[3] n308 data_read[4] data_read[2] VDD_1V8 n310 n309 AO222HDLLX0
XU367 VSS n8 data_read[4] n308 data_read[5] data_read[3] VDD_1V8 n310 n309 AO222HDLLX0
XU368 VSS n9 data_read[5] n308 data_read[6] data_read[4] VDD_1V8 n310 n309 AO222HDLLX0
XU369 VSS n10 data_read[6] n308 data_read[7] data_read[5] VDD_1V8 n310 n309 AO222HDLLX0
XU370 VSS n11 data_read[7] n308 data_read[8] data_read[6] VDD_1V8 n310 n309 AO222HDLLX0
XU371 VSS n12 data_read[8] n308 data_read[9] data_read[7] VDD_1V8 n310 n309 AO222HDLLX0
XU372 VSS n13 data_read[9] n308 data_read[10] data_read[8] VDD_1V8 n310 n309 AO222HDLLX0
XU177 VSS n130 n129 VDD_1V8 N217 NA2HDLLX0
XU182 VSS n132 n131 VDD_1V8 N218 NA2HDLLX0
XU185 VSS n134 n133 VDD_1V8 N219 NA2HDLLX0
XU188 VSS n136 n135 VDD_1V8 N220 NA2HDLLX0
XU191 VSS n138 n137 VDD_1V8 N221 NA2HDLLX0
XU194 VSS n140 n139 VDD_1V8 N222 NA2HDLLX0
XU197 VSS n142 n141 VDD_1V8 N223 NA2HDLLX0
XU200 VSS n144 n143 VDD_1V8 N224 NA2HDLLX0
XU203 VSS n146 n145 VDD_1V8 N225 NA2HDLLX0
XU206 VSS n148 n147 VDD_1V8 N226 NA2HDLLX0
XU210 VSS n151 n150 VDD_1V8 N227 NA2HDLLX0
XU213 VSS n153 n152 VDD_1V8 N228 NA2HDLLX0
XU217 VSS n155 n154 VDD_1V8 N229 NA2HDLLX0
XU221 VSS n158 n157 VDD_1V8 N230 NA2HDLLX0
XU224 VSS n160 n159 VDD_1V8 N231 NA2HDLLX0
XU227 VSS n162 n161 VDD_1V8 N232 NA2HDLLX0
XU230 VSS n164 n163 VDD_1V8 N233 NA2HDLLX0
XU233 VSS n166 n165 VDD_1V8 N234 NA2HDLLX0
XU236 VSS n168 n167 VDD_1V8 N235 NA2HDLLX0
XU239 VSS n170 n169 VDD_1V8 N236 NA2HDLLX0
XU286 VSS N252 tx_shiftreg[60] n215 tx_shiftreg[58] tx_shiftreg[59] VDD_1V8 n228
+ n218 AO222HDLLX0
XU242 VSS n172 n171 VDD_1V8 N237 NA2HDLLX0
XU245 VSS n174 n173 VDD_1V8 N238 NA2HDLLX0
XU248 VSS n178 n177 VDD_1V8 N239 NA2HDLLX0
XU251 VSS n182 n181 VDD_1V8 N240 NA2HDLLX0
XU254 VSS n185 n184 VDD_1V8 N241 NA2HDLLX0
XU257 VSS n187 n186 VDD_1V8 N242 NA2HDLLX0
XU260 VSS n190 n189 VDD_1V8 N243 NA2HDLLX0
XU263 VSS n192 n191 VDD_1V8 N244 NA2HDLLX0
XU266 VSS n194 n193 VDD_1V8 N245 NA2HDLLX0
XU269 VSS n196 n195 VDD_1V8 N246 NA2HDLLX0
XU272 VSS n198 n197 VDD_1V8 N247 NA2HDLLX0
XU76 VSS N54 counter_clk[0] n230 VDD_1V8 NO2HDLLX0
XU78 VSS N55 VDD_1V8 n214 counter_clk[0] counter_clk[1] n66 OA211HDLLX0
XU80 VSS N56 n230 n67 VDD_1V8 NO2HDLLX0
XU83 VSS N57 VDD_1V8 n69 counter_clk[3] n68 n214 OA211HDLLX0
XU86 VSS VDD_1V8 N58 n70 n69 n71 n230 AN211HDLLX0
XU88 VSS N59 VDD_1V8 n214 counter_clk[5] n71 n72 OA211HDLLX0
XU91 VSS VDD_1V8 N60 n73 n72 n75 n230 AN211HDLLX0
XU93 VSS VDD_1V8 N61 counter_clk[7] n75 n230 n74 AN211HDLLX0
XU99 VSS n78 n77 VDD_1V8 N257 NA2HDLLX0
XU103 VSS n80 n79 VDD_1V8 N194 NA2HDLLX0
XU106 VSS n82 n81 VDD_1V8 N195 NA2HDLLX0
XU110 VSS n84 n83 VDD_1V8 N196 NA2HDLLX0
XU113 VSS n86 n85 VDD_1V8 N197 NA2HDLLX0
XU116 VSS n88 n87 VDD_1V8 N198 NA2HDLLX0
XU119 VSS n90 n89 VDD_1V8 N199 NA2HDLLX0
XU122 VSS n92 n91 VDD_1V8 N200 NA2HDLLX0
XU125 VSS n94 n93 VDD_1V8 N201 NA2HDLLX0
XU129 VSS n96 n95 VDD_1V8 N202 NA2HDLLX0
XU132 VSS n98 n97 VDD_1V8 N203 NA2HDLLX0
XU136 VSS n100 n99 VDD_1V8 N204 NA2HDLLX0
XU140 VSS n102 n101 VDD_1V8 N205 NA2HDLLX0
XU143 VSS n105 n104 VDD_1V8 N206 NA2HDLLX0
XU146 VSS n107 n106 VDD_1V8 N207 NA2HDLLX0
XU149 VSS n109 n108 VDD_1V8 N208 NA2HDLLX0
XU152 VSS n111 n110 VDD_1V8 N209 NA2HDLLX0
XU155 VSS n113 n112 VDD_1V8 N210 NA2HDLLX0
XU158 VSS n115 n114 VDD_1V8 N211 NA2HDLLX0
XU161 VSS n117 n116 VDD_1V8 N212 NA2HDLLX0
XU164 VSS n119 n118 VDD_1V8 N213 NA2HDLLX0
XU167 VSS n122 n121 VDD_1V8 N214 NA2HDLLX0
XU171 VSS n124 n123 VDD_1V8 N215 NA2HDLLX0
XU174 VSS n126 n125 VDD_1V8 N216 NA2HDLLX0
XU26 n282 VSS VDD_1V8 n52 n40 n307 n128 ON22HDLLX0
XU49 N334 VSS VDD_1V8 n224 n223 n52 n53 ON22HDLLX0
XU53 n279 VSS VDD_1V8 n307 n54 n55 n56 ON22HDLLX0
XU68 VSS N193 VDD_1V8 n61 n62 n219 ON21HDLLX0
XU71 VSS n283 VDD_1V8 n63 state[2] n222 ON21HDLLX0
XU373 VSS n14 data_read[10] n308 data_read[11] data_read[9] VDD_1V8 n310 n309 AO222HDLLX0
XU374 VSS n15 data_read[11] n308 data_read[12] data_read[10] VDD_1V8 n310 n309 AO222HDLLX0
XU375 VSS n16 data_read[12] n308 data_read[13] data_read[11] VDD_1V8 n310 n309 AO222HDLLX0
XU376 VSS n17 data_read[13] n308 data_read[14] data_read[12] VDD_1V8 n310 n309 AO222HDLLX0
XU377 VSS n18 data_read[14] n308 data_read[15] data_read[13] VDD_1V8 n310 n309 AO222HDLLX0
XU378 VSS n19 data_read[15] n308 data_read[16] data_read[14] VDD_1V8 n310 n309 AO222HDLLX0
XU379 VSS n20 data_read[16] n308 data_read[17] data_read[15] VDD_1V8 n310 n309 AO222HDLLX0
XU380 VSS n21 data_read[17] n308 data_read[18] data_read[16] VDD_1V8 n310 n309 AO222HDLLX0
XU381 VSS n22 data_read[18] n308 data_read[19] data_read[17] VDD_1V8 n310 n309 AO222HDLLX0
XU382 VSS n23 data_read[19] n308 data_read[20] data_read[18] VDD_1V8 n310 n309 AO222HDLLX0
XU383 VSS n24 data_read[20] n308 data_read[21] data_read[19] VDD_1V8 n310 n309 AO222HDLLX0
XU384 VSS n25 data_read[21] n308 data_read[22] data_read[20] VDD_1V8 n310 n309 AO222HDLLX0
XU385 VSS n26 data_read[22] n308 data_read[23] data_read[21] VDD_1V8 n310 n309 AO222HDLLX0
XU386 VSS n27 data_read[23] n308 data_read[24] data_read[22] VDD_1V8 n310 n309 AO222HDLLX0
XU387 VSS n28 data_read[24] n308 data_read[25] data_read[23] VDD_1V8 n310 n309 AO222HDLLX0
XU388 VSS n29 data_read[25] n308 data_read[26] data_read[24] VDD_1V8 n310 n309 AO222HDLLX0
XU389 VSS n30 data_read[26] n308 data_read[27] data_read[25] VDD_1V8 n310 n309 AO222HDLLX0
XU390 VSS n31 data_read[27] n308 data_read[28] data_read[26] VDD_1V8 n310 n309 AO222HDLLX0
XU391 VSS n32 data_read[28] n308 data_read[29] data_read[27] VDD_1V8 n310 n309 AO222HDLLX0
XU392 VSS n33 data_read[29] data_read[28] data_read[30] n308 VDD_1V8 n310 n309 AO222HDLLX0
XU393 VSS n34 data_read[30] data_read[29] n309 n308 VDD_1V8 n310 data_read[31] AO222HDLLX0
XU396 VSS n37 VDD_1V8 n312 n311 config_enable ON21HDLLX0
XU397 VSS n39 VDD_1V8 n312 n208 config_enable ON21HDLLX0
XU398 VSS n48 VDD_1V8 config_enable conf[11] data_config[11] MU2HDLLX0
XU399 VSS n49 VDD_1V8 config_enable conf[12] data_config[12] MU2HDLLX0
XU400 VSS n50 VDD_1V8 config_enable conf[13] data_config[13] MU2HDLLX0
XU401 VSS n51 VDD_1V8 config_enable conf[14] data_config[14] MU2HDLLX0
XU275 VSS n200 n199 VDD_1V8 N248 NA2HDLLX0
XU278 VSS n202 n201 VDD_1V8 N249 NA2HDLLX0
XU281 VSS n204 n203 VDD_1V8 N250 NA2HDLLX0
XU284 VSS n206 n205 VDD_1V8 N251 NA2HDLLX0
Xplace19 n237 VSS VDD_1V8 n251 INHDLLX0
Xplace12 n214 VSS VDD_1V8 n230 INHDLLX0
Xplace7 n183 VSS VDD_1V8 state[1] INHDLLX0
XU57 VSS n60 flag_edge_detector[1] n59 VDD_1V8 NO2HDLLX1
Xtx_shiftreg_reg_35_ VSS VDD_1V8 tx_shiftreg[35] reset CLK_cts_3 N228 DFRSQHDLLX0
Xtx_shiftreg_reg_36_ VSS VDD_1V8 tx_shiftreg[36] reset CLK_cts_3 N229 DFRSQHDLLX0
Xtx_shiftreg_reg_37_ VSS VDD_1V8 tx_shiftreg[37] reset CLK_cts_3 N230 DFRSQHDLLX0
Xtx_shiftreg_reg_38_ VSS VDD_1V8 tx_shiftreg[38] IN5 CLK_cts_3 N231 DFRSQHDLLX0
Xtx_shiftreg_reg_39_ VSS VDD_1V8 tx_shiftreg[39] reset CLK_cts_3 N232 DFRSQHDLLX0
Xtx_shiftreg_reg_40_ VSS VDD_1V8 tx_shiftreg[40] reset CLK_cts_3 N233 DFRSQHDLLX0
Xtx_shiftreg_reg_41_ VSS VDD_1V8 tx_shiftreg[41] reset CLK_cts_3 N234 DFRSQHDLLX0
Xtx_shiftreg_reg_42_ VSS VDD_1V8 tx_shiftreg[42] reset CLK_cts_3 N235 DFRSQHDLLX0
Xtx_shiftreg_reg_43_ VSS VDD_1V8 tx_shiftreg[43] reset CLK_cts_3 N236 DFRSQHDLLX0
Xtx_shiftreg_reg_44_ VSS VDD_1V8 tx_shiftreg[44] reset CLK_cts_3 N237 DFRSQHDLLX0
Xtx_shiftreg_reg_45_ VSS VDD_1V8 tx_shiftreg[45] reset CLK_cts_3 N238 DFRSQHDLLX0
Xtx_shiftreg_reg_46_ VSS VDD_1V8 tx_shiftreg[46] reset CLK_cts_3 N239 DFRSQHDLLX0
Xtx_shiftreg_reg_47_ VSS VDD_1V8 tx_shiftreg[47] reset CLK_cts_3 N240 DFRSQHDLLX0
Xtx_shiftreg_reg_48_ VSS VDD_1V8 tx_shiftreg[48] reset CLK_cts_3 N241 DFRSQHDLLX0
Xtx_shiftreg_reg_49_ VSS VDD_1V8 tx_shiftreg[49] reset CLK_cts_3 N242 DFRSQHDLLX0
Xtx_shiftreg_reg_50_ VSS VDD_1V8 tx_shiftreg[50] reset CLK_cts_3 N243 DFRSQHDLLX0
Xtx_shiftreg_reg_51_ VSS VDD_1V8 tx_shiftreg[51] reset CLK_cts_3 N244 DFRSQHDLLX0
Xtx_shiftreg_reg_52_ VSS VDD_1V8 tx_shiftreg[52] reset CLK_cts_3 N245 DFRSQHDLLX0
Xtx_shiftreg_reg_53_ VSS VDD_1V8 tx_shiftreg[53] reset CLK_cts_3 N246 DFRSQHDLLX0
Xtx_shiftreg_reg_54_ VSS VDD_1V8 tx_shiftreg[54] reset CLK_cts_3 N247 DFRSQHDLLX0
Xtx_shiftreg_reg_55_ VSS VDD_1V8 tx_shiftreg[55] reset CLK_cts_3 N248 DFRSQHDLLX0
Xtx_shiftreg_reg_56_ VSS VDD_1V8 tx_shiftreg[56] reset CLK_cts_3 N249 DFRSQHDLLX0
Xtx_shiftreg_reg_57_ VSS VDD_1V8 tx_shiftreg[57] reset CLK_cts_3 N250 DFRSQHDLLX0
Xtx_shiftreg_reg_58_ VSS VDD_1V8 tx_shiftreg[58] reset CLK_cts_3 N251 DFRSQHDLLX0
Xtx_shiftreg_reg_59_ VSS VDD_1V8 tx_shiftreg[59] reset CLK_cts_3 N252 DFRSQHDLLX0
Xtx_shiftreg_reg_0_ VSS VDD_1V8 tx_shiftreg[0] reset CLK_cts_3 N193 DFRSQHDLLX0
Xtx_shiftreg_reg_63_ VSS VDD_1V8 tx_shiftreg[63] reset CLK_cts_3 N256 DFRSQHDLLX0
Xend_send_reg IN3 CLK_cts_5 n281 end_send VSS VDD_1V8 DFFRQHDLLX0
Xtx_loaddata_reg IN3 CLK_cts_5 n282 SYNOPSYS_UNCONNECTED_76 n258 VSS VDD_1V8 DFFRHDLLX0
Xcounter_CS_reg_1_ IN3 CLK_cts_5 n263 counter_CS[1] VSS VDD_1V8 DFFRQHDLLX0
Xcounter_CS_reg_2_ IN3 CLK_cts_5 n264 counter_CS[2] VSS VDD_1V8 DFFRQHDLLX0
Xcounter_CS_reg_3_ IN3 CLK_cts_5 n265 counter_CS[3] VSS VDD_1V8 DFFRQHDLLX0
Xcounter_CS_reg_4_ IN3 CLK_cts_5 n266 counter_CS[4] VSS VDD_1V8 DFFRQHDLLX0
Xcounter_CS_reg_5_ IN3 CLK_cts_5 n267 counter_CS[5] VSS VDD_1V8 DFFRQHDLLX0
Xcounter_CS_reg_6_ IN3 CLK_cts_5 n268 counter_CS[6] VSS VDD_1V8 DFFRQHDLLX0
Xcounter_CS_reg_7_ IN3 CLK_cts_5 n269 counter_CS[7] VSS VDD_1V8 DFFRQHDLLX0
XCS_reg VSS VDD_1V8 CS IN3 n35 CLK_cts_5 n283 DFFRSQHDLLX0
Xstate_reg_1_ IN3 CLK_cts_5 N335 state[1] VSS VDD_1V8 DFFRQHDLLX0
Xstate_reg_0_ IN3 CLK_cts_5 N334 state[0] VSS VDD_1V8 DFFRQHDLLX0
Xdata_read_reg_31_ IN2 CLK_cts_5 n3 data_read[31] VSS VDD_1V8 DFRRQHDLLX0
Xdata_read_reg_0_ IN2 CLK_cts_5 n4 data_read[0] VSS VDD_1V8 DFRRQHDLLX0
Xdata_read_reg_1_ IN2 CLK_cts_5 n5 data_read[1] VSS VDD_1V8 DFRRQHDLLX0
Xdata_read_reg_2_ IN2 CLK_cts_5 n6 data_read[2] VSS VDD_1V8 DFRRQHDLLX0
Xdata_read_reg_3_ IN2 CLK_cts_5 n7 data_read[3] VSS VDD_1V8 DFRRQHDLLX0
Xdata_read_reg_4_ IN2 CLK_cts_5 n8 data_read[4] VSS VDD_1V8 DFRRQHDLLX0
Xdata_read_reg_5_ IN2 CLK_cts_1 n9 data_read[5] VSS VDD_1V8 DFRRQHDLLX0
Xdata_read_reg_6_ IN2 CLK_cts_1 n10 data_read[6] VSS VDD_1V8 DFRRQHDLLX0
Xdata_read_reg_7_ IN2 CLK_cts_1 n11 data_read[7] VSS VDD_1V8 DFRRQHDLLX0
Xdata_read_reg_8_ IN4 CLK_cts_1 n12 data_read[8] VSS VDD_1V8 DFRRQHDLLX0
Xdata_read_reg_9_ IN4 CLK_cts_1 n13 data_read[9] VSS VDD_1V8 DFRRQHDLLX0
Xdata_read_reg_10_ IN4 CLK_cts_1 n14 data_read[10] VSS VDD_1V8 DFRRQHDLLX0
Xdata_read_reg_11_ IN4 CLK_cts_1 n15 data_read[11] VSS VDD_1V8 DFRRQHDLLX0
Xdata_read_reg_12_ IN4 CLK_cts_1 n16 data_read[12] VSS VDD_1V8 DFRRQHDLLX0
Xdata_read_reg_13_ IN4 CLK_cts_1 n17 data_read[13] VSS VDD_1V8 DFRRQHDLLX0
Xdata_read_reg_14_ IN4 CLK_cts_1 n18 data_read[14] VSS VDD_1V8 DFRRQHDLLX0
Xdata_read_reg_15_ IN4 CLK_cts_1 n19 data_read[15] VSS VDD_1V8 DFRRQHDLLX0
Xdata_read_reg_16_ IN4 CLK_cts_1 n20 data_read[16] VSS VDD_1V8 DFRRQHDLLX0
Xdata_read_reg_17_ IN4 CLK_cts_1 n21 data_read[17] VSS VDD_1V8 DFRRQHDLLX0
Xdata_read_reg_18_ IN4 CLK_cts_1 n22 data_read[18] VSS VDD_1V8 DFRRQHDLLX0
Xdata_read_reg_19_ IN4 CLK_cts_1 n23 data_read[19] VSS VDD_1V8 DFRRQHDLLX0
Xdata_read_reg_20_ IN4 CLK_cts_1 n24 data_read[20] VSS VDD_1V8 DFRRQHDLLX0
Xdata_read_reg_21_ IN4 CLK_cts_1 n25 data_read[21] VSS VDD_1V8 DFRRQHDLLX0
Xdata_read_reg_22_ IN4 CLK_cts_1 n26 data_read[22] VSS VDD_1V8 DFRRQHDLLX0
Xdata_read_reg_23_ IN4 CLK_cts_1 n27 data_read[23] VSS VDD_1V8 DFRRQHDLLX0
Xdata_read_reg_24_ IN4 CLK_cts_1 n28 data_read[24] VSS VDD_1V8 DFRRQHDLLX0
Xdata_read_reg_25_ IN4 CLK_cts_1 n29 data_read[25] VSS VDD_1V8 DFRRQHDLLX0
Xdata_read_reg_26_ IN2 CLK_cts_1 n30 data_read[26] VSS VDD_1V8 DFRRQHDLLX0
Xdata_read_reg_27_ IN2 CLK_cts_1 n31 data_read[27] VSS VDD_1V8 DFRRQHDLLX0
Xdata_read_reg_28_ IN2 CLK_cts_1 n32 data_read[28] VSS VDD_1V8 DFRRQHDLLX0
Xdata_read_reg_29_ IN2 CLK_cts_5 n33 data_read[29] VSS VDD_1V8 DFRRQHDLLX0
Xdata_read_reg_30_ IN2 CLK_cts_5 n34 data_read[30] VSS VDD_1V8 DFRRQHDLLX0
Xflag_edge_detector_reg_0_ IN3 CLK_cts_5 flag_edge_detector[1] flag_edge_detector[0]
+ VSS VDD_1V8 DFFRQHDLLX0
Xflag_edge_detector_reg_1_ IN3 CLK_cts_5 SCK flag_edge_detector[1] VSS VDD_1V8 DFFRQHDLLX0
XSCK_reg VSS VDD_1V8 SCK IN3 n35 CLK_cts_5 n278 DFRRSQHDLLX0
Xcounter_clk_reg_7_ IN3 CLK_cts_5 N61 counter_clk[7] VSS VDD_1V8 DFRRQHDLLX0
Xcounter_clk_reg_6_ IN3 CLK_cts_5 N60 counter_clk[6] VSS VDD_1V8 DFRRQHDLLX0
Xcounter_clk_reg_5_ IN3 CLK_cts_5 N59 counter_clk[5] VSS VDD_1V8 DFRRQHDLLX0
Xcounter_clk_reg_4_ IN3 CLK_cts_5 N58 counter_clk[4] VSS VDD_1V8 DFRRQHDLLX0
Xcounter_clk_reg_1_ IN3 CLK_cts_5 N55 counter_clk[1] VSS VDD_1V8 DFRRQHDLLX0
Xcounter_clk_reg_0_ IN3 CLK_cts_5 N54 counter_clk[0] VSS VDD_1V8 DFRRQHDLLX0
Xclk_enable_reg IN3 CLK_cts_5 n279 clk_enable VSS VDD_1V8 DFFRQHDLLX0
Xstate_reg_2_ IN3 CLK_cts_5 N336 state[2] n342 VSS VDD_1V8 DFFRHDLLX0
Xcounter_CS_reg_0_ IN3 CLK_cts_5 n262 counter_CS[0] n341 VSS VDD_1V8 DFFRHDLLX0
XMISO1_reg IN3 CLK_cts_5 MISO MISO1 VSS VDD_1V8 DFFRQHDLLX0
Xconf_reg_0_ IN7 CLK n37 conf[0] VSS VDD_1V8 DFFRQHDLLX0
Xconf_reg_2_ IN7 CLK n39 conf[2] VSS VDD_1V8 DFFRQHDLLX0
Xconf_reg_11_ IN7 CLK n48 conf[11] VSS VDD_1V8 DFFRQHDLLX0
Xconf_reg_12_ IN7 CLK n49 conf[12] VSS VDD_1V8 DFFRQHDLLX0
Xconf_reg_13_ IN7 CLK n50 conf[13] VSS VDD_1V8 DFFRQHDLLX0
Xconf_reg_14_ IN7 CLK n51 conf[14] VSS VDD_1V8 DFFRQHDLLX0
Xbits_count_reg_5_ IN3 CLK_cts_5 n274 bits_count[5] n348 VSS VDD_1V8 DFRRHDLLX0
Xbits_count_reg_3_ IN2 CLK_cts_5 n272 SYNOPSYS_UNCONNECTED_77 n347 VSS VDD_1V8 DFRRHDLLX0
Xbits_count_reg_0_ IN3 CLK_cts_5 n276 bits_count[0] n343 VSS VDD_1V8 DFRRHDLLX0
Xbits_count_reg_1_ IN3 CLK_cts_5 n270 bits_count[1] n340 VSS VDD_1V8 DFRRHDLLX0
Xbits_count_reg_6_ IN3 CLK_cts_5 n275 bits_count[6] n346 VSS VDD_1V8 DFRRHDLLX0
Xbits_count_reg_7_ IN3 CLK_cts_5 n277 bits_count[7] SYNOPSYS_UNCONNECTED_78 VSS
+ VDD_1V8 DFRRHDLLX0
Xbits_count_reg_4_ IN3 CLK_cts_5 n273 bits_count[4] n344 VSS VDD_1V8 DFRRHDLLX0
Xbits_count_reg_2_ IN3 CLK_cts_5 n271 bits_count[2] n345 VSS VDD_1V8 DFRRHDLLX0
XMOSI_reg VSS VDD_1V8 MOSI IN5 CLK_cts_3 N257 DFRSQHDLLX0
Xcounter_clk_reg_2_ IN3 CLK_cts_5 N56 counter_clk[2] SYNOPSYS_UNCONNECTED_79 VSS
+ VDD_1V8 DFRRHDLLX0
Xcounter_clk_reg_3_ IN3 CLK_cts_5 N57 counter_clk[3] SYNOPSYS_UNCONNECTED_80 VSS
+ VDD_1V8 DFRRHDLLX0
Xtx_shiftreg_reg_61_ VSS VDD_1V8 tx_shiftreg[61] reset CLK_cts_3 N254 DFRSQHDLLX0
Xtx_shiftreg_reg_60_ VSS VDD_1V8 tx_shiftreg[60] reset CLK_cts_3 N253 DFRSQHDLLX0
Xtx_shiftreg_reg_1_ VSS VDD_1V8 tx_shiftreg[1] IN6 CLK_cts_4 N194 DFRSQHDLLX0
Xtx_shiftreg_reg_62_ n339 VSS VDD_1V8 tx_shiftreg[62] reset CLK_cts_3 N255 DFRSHDLLX0
Xtx_shiftreg_reg_2_ VSS VDD_1V8 tx_shiftreg[2] IN6 CLK_cts_4 N195 DFRSQHDLLX0
Xtx_shiftreg_reg_3_ VSS VDD_1V8 tx_shiftreg[3] IN6 CLK_cts_3 N196 DFRSQHDLLX0
Xtx_shiftreg_reg_4_ VSS VDD_1V8 tx_shiftreg[4] IN6 CLK_cts_4 N197 DFRSQHDLLX0
Xtx_shiftreg_reg_5_ VSS VDD_1V8 tx_shiftreg[5] IN6 CLK_cts_4 N198 DFRSQHDLLX0
Xtx_shiftreg_reg_6_ VSS VDD_1V8 tx_shiftreg[6] IN6 CLK_cts_4 N199 DFRSQHDLLX0
Xtx_shiftreg_reg_7_ VSS VDD_1V8 tx_shiftreg[7] IN6 CLK_cts_3 N200 DFRSQHDLLX0
Xtx_shiftreg_reg_8_ VSS VDD_1V8 tx_shiftreg[8] IN6 CLK_cts_3 N201 DFRSQHDLLX0
Xtx_shiftreg_reg_9_ VSS VDD_1V8 tx_shiftreg[9] IN6 CLK_cts_3 N202 DFRSQHDLLX0
Xtx_shiftreg_reg_10_ VSS VDD_1V8 tx_shiftreg[10] IN6 CLK_cts_3 N203 DFRSQHDLLX0
Xtx_shiftreg_reg_11_ VSS VDD_1V8 tx_shiftreg[11] IN6 CLK_cts_3 N204 DFRSQHDLLX0
Xtx_shiftreg_reg_12_ VSS VDD_1V8 tx_shiftreg[12] IN6 CLK_cts_3 N205 DFRSQHDLLX0
Xtx_shiftreg_reg_13_ VSS VDD_1V8 tx_shiftreg[13] IN6 CLK_cts_3 N206 DFRSQHDLLX0
Xtx_shiftreg_reg_14_ VSS VDD_1V8 tx_shiftreg[14] IN6 CLK_cts_3 N207 DFRSQHDLLX0
Xtx_shiftreg_reg_15_ VSS VDD_1V8 tx_shiftreg[15] IN6 CLK_cts_3 N208 DFRSQHDLLX0
Xtx_shiftreg_reg_16_ VSS VDD_1V8 tx_shiftreg[16] IN6 CLK_cts_3 N209 DFRSQHDLLX0
Xtx_shiftreg_reg_17_ VSS VDD_1V8 tx_shiftreg[17] reset CLK_cts_3 N210 DFRSQHDLLX0
Xtx_shiftreg_reg_18_ VSS VDD_1V8 tx_shiftreg[18] IN6 CLK_cts_3 N211 DFRSQHDLLX0
Xtx_shiftreg_reg_19_ VSS VDD_1V8 tx_shiftreg[19] IN6 CLK_cts_3 N212 DFRSQHDLLX0
Xtx_shiftreg_reg_20_ VSS VDD_1V8 tx_shiftreg[20] IN6 CLK_cts_3 N213 DFRSQHDLLX0
Xtx_shiftreg_reg_21_ VSS VDD_1V8 tx_shiftreg[21] IN6 CLK_cts_3 N214 DFRSQHDLLX0
Xtx_shiftreg_reg_22_ VSS VDD_1V8 tx_shiftreg[22] IN6 CLK_cts_3 N215 DFRSQHDLLX0
Xtx_shiftreg_reg_23_ VSS VDD_1V8 tx_shiftreg[23] IN6 CLK_cts_3 N216 DFRSQHDLLX0
Xtx_shiftreg_reg_24_ VSS VDD_1V8 tx_shiftreg[24] IN6 CLK_cts_4 N217 DFRSQHDLLX0
Xtx_shiftreg_reg_25_ VSS VDD_1V8 tx_shiftreg[25] IN6 CLK_cts_4 N218 DFRSQHDLLX0
Xtx_shiftreg_reg_26_ VSS VDD_1V8 tx_shiftreg[26] IN6 CLK_cts_4 N219 DFRSQHDLLX0
Xtx_shiftreg_reg_27_ VSS VDD_1V8 tx_shiftreg[27] IN6 CLK_cts_3 N220 DFRSQHDLLX0
Xtx_shiftreg_reg_28_ VSS VDD_1V8 tx_shiftreg[28] IN6 CLK_cts_3 N221 DFRSQHDLLX0
Xtx_shiftreg_reg_29_ VSS VDD_1V8 tx_shiftreg[29] IN6 CLK_cts_3 N222 DFRSQHDLLX0
Xtx_shiftreg_reg_30_ VSS VDD_1V8 tx_shiftreg[30] reset CLK_cts_3 N223 DFRSQHDLLX0
Xtx_shiftreg_reg_31_ VSS VDD_1V8 tx_shiftreg[31] reset CLK_cts_3 N224 DFRSQHDLLX0
Xtx_shiftreg_reg_32_ VSS VDD_1V8 tx_shiftreg[32] reset CLK_cts_3 N225 DFRSQHDLLX0
Xtx_shiftreg_reg_33_ VSS VDD_1V8 tx_shiftreg[33] reset CLK_cts_3 N226 DFRSQHDLLX0
Xtx_shiftreg_reg_34_ VSS VDD_1V8 tx_shiftreg[34] reset CLK_cts_3 N227 DFRSQHDLLX0
XU9 VSS n35 VDD_1V8 LOGIC1HDLL
.ENDS

.SUBCKT dff_async_rst_1331 data clk reset q VSS VDD_1V8
Xq_reg reset clk data q VSS VDD_1V8 DFRRQHDLLX0
.ENDS

.SUBCKT dff_async_rst_1330 data clk reset q VSS VDD_1V8
Xq_reg reset clk data q VSS VDD_1V8 DFRRQHDLLX0
.ENDS

.SUBCKT dff_async_rst_1329 data clk reset q VSS VDD_1V8
Xq_reg reset clk data q VSS VDD_1V8 DFRRQHDLLX0
.ENDS

.SUBCKT dff_async_rst_1328 data clk reset q VSS VDD_1V8
Xq_reg reset clk data q VSS VDD_1V8 DFRRQHDLLX0
.ENDS

.SUBCKT dff_async_rst_1327 data clk reset q VSS VDD_1V8
Xq_reg reset clk data q VSS VDD_1V8 DFRRQHDLLX0
.ENDS

.SUBCKT dff_async_rst_1326 data clk reset q VSS VDD_1V8
Xq_reg reset clk data q VSS VDD_1V8 DFRRQHDLLX0
.ENDS

.SUBCKT dff_async_rst_1325 data clk reset q VSS VDD_1V8
Xq_reg reset clk data q VSS VDD_1V8 DFRRQHDLLX0
.ENDS

.SUBCKT dff_async_rst_1324 data clk reset q VSS VDD_1V8
Xq_reg reset clk data q VSS VDD_1V8 DFRRQHDLLX0
.ENDS

.SUBCKT mux_rd b h rd_fll sign_ext address[1] address[0] d_read_pre[31] d_read_pre[30]
+ d_read_pre[29] d_read_pre[28] d_read_pre[27] d_read_pre[26] d_read_pre[25] d_read_pre[24]
+ d_read_pre[23] d_read_pre[22] d_read_pre[21] d_read_pre[20] d_read_pre[19] d_read_pre[18]
+ d_read_pre[17] d_read_pre[16] d_read_pre[15] d_read_pre[14] d_read_pre[13] d_read_pre[12]
+ d_read_pre[11] d_read_pre[10] d_read_pre[9] d_read_pre[8] d_read_pre[7] d_read_pre[6]
+ d_read_pre[5] d_read_pre[4] d_read_pre[3] d_read_pre[2] d_read_pre[1] d_read_pre[0]
+ q[31] q[30] q[29] q[28] q[27] q[26] q[25] q[24] q[23] q[22] q[21] q[20] q[19]
+ q[18] q[17] q[16] q[15] q[14] q[13] q[12] q[11] q[10] q[9] q[8] q[7] q[6] q[5]
+ q[4] q[3] q[2] q[1] q[0] VSS VDD_1V8 IN0 IN1
XU2 VSS rd_fll h VDD_1V8 n22 b NA3I2HDLLX0
XU8 VSS n41 rd_fll VDD_1V8 b h NO3I1HDLLX0
XU36 VSS address[0] q[7] IN0 n24 address[1] VDD_1V8 q[31] IN1 AN33HDLLX0
XU37 VSS IN0 q[15] address[0] n23 address[1] VDD_1V8 q[23] IN1 AN33HDLLX0
XU11 VSS VDD_1V8 n43 n22 n41 NO2I1HDLLX0
XU38 n23 VSS n22 n24 VDD_1V8 n26 AN21HDLLX0
XU9 VSS IN1 n41 VDD_1V8 n19 NA2HDLLX0
XU12 address[1] VSS n43 n41 VDD_1V8 n20 AN21HDLLX0
XU42 VSS n26 sign_ext VDD_1V8 n38 NA2HDLLX0
XU13 VSS n15 VDD_1V8 n20 IN1 IN0 ON21HDLLX0
Xplace3 n45 VSS VDD_1V8 n20 INHDLLX0
XU10 VSS n16 VDD_1V8 address[1] n19 n22 IN0 ON31HDLLX0
Xplace2 n44 VSS VDD_1V8 n19 INHDLLX0
XU6 n13 VSS VDD_1V8 address[0] n22 IN1 NO3HDLLX0
XU5 n14 VSS VDD_1V8 address[0] address[1] n22 NO3HDLLX0
XU58 VSS VDD_1V8 q[31] q[15] IN1 address[1] n40 OA22HDLLX0
XU59 n39 VSS VDD_1V8 n38 INHDLLX0
XU60 n42 n40 n41 VSS VDD_1V8 sign_ext n39 AN31HDLLX0
XU56 VSS VDD_1V8 n36 q[15] n44 q[31] n45 AN22HDLLX0
XU54 VSS VDD_1V8 n33 q[14] n44 q[30] n45 AN22HDLLX0
XU52 VSS VDD_1V8 n32 q[13] n44 q[29] n45 AN22HDLLX0
XU50 VSS VDD_1V8 n31 q[12] n44 q[28] n45 AN22HDLLX0
XU48 VSS VDD_1V8 n30 q[11] n44 q[27] n45 AN22HDLLX0
XU46 VSS VDD_1V8 n29 q[10] n44 q[26] n45 AN22HDLLX0
XU44 VSS VDD_1V8 n28 q[9] n44 q[25] n45 AN22HDLLX0
XU41 VSS VDD_1V8 n27 q[8] n44 q[24] n45 AN22HDLLX0
XU39 n45 VSS n26 q[7] VDD_1V8 n25 AN21HDLLX0
XU32 VSS VDD_1V8 n17 q[6] n16 q[22] n15 AN22HDLLX0
XU31 VSS VDD_1V8 n18 n13 n14 q[30] q[14] AN22HDLLX0
XU29 VSS VDD_1V8 n11 q[5] n16 q[21] n15 AN22HDLLX0
XU28 VSS VDD_1V8 n12 n13 n14 q[29] q[13] AN22HDLLX0
XU26 VSS VDD_1V8 n9 q[4] n16 q[20] n15 AN22HDLLX0
XU25 VSS VDD_1V8 n10 n13 n14 q[28] q[12] AN22HDLLX0
XU23 VSS VDD_1V8 n7 q[3] n16 q[19] n15 AN22HDLLX0
XU22 VSS VDD_1V8 n8 n13 n14 q[27] q[11] AN22HDLLX0
XU20 VSS VDD_1V8 n5 q[2] n16 q[18] n15 AN22HDLLX0
XU19 VSS VDD_1V8 n6 n13 n14 q[26] q[10] AN22HDLLX0
XU17 VSS VDD_1V8 n3 q[1] n16 q[17] n15 AN22HDLLX0
XU16 VSS VDD_1V8 n4 n13 n14 q[25] q[9] AN22HDLLX0
XU14 VSS VDD_1V8 n1 q[0] n16 q[16] n15 AN22HDLLX0
XU7 VSS VDD_1V8 n2 q[8] n14 q[24] n13 AN22HDLLX0
XU68 VSS n43 q[23] VDD_1V8 n42 d_read_pre[23] NA22HDLLX0
XU67 VSS q[22] n43 VDD_1V8 n42 d_read_pre[22] NA22HDLLX0
XU66 VSS q[21] n43 VDD_1V8 n42 d_read_pre[21] NA22HDLLX0
XU65 VSS q[20] n43 VDD_1V8 n42 d_read_pre[20] NA22HDLLX0
XU64 VSS q[19] n43 VDD_1V8 n42 d_read_pre[19] NA22HDLLX0
XU63 VSS q[18] n43 VDD_1V8 n42 d_read_pre[18] NA22HDLLX0
XU62 VSS q[17] n43 VDD_1V8 n42 d_read_pre[17] NA22HDLLX0
XU61 VSS q[16] n43 VDD_1V8 n42 d_read_pre[16] NA22HDLLX0
XU57 VSS n36 n38 VDD_1V8 d_read_pre[15] NA2HDLLX0
XU55 VSS n33 n38 VDD_1V8 d_read_pre[14] NA2HDLLX0
XU53 VSS n32 n38 VDD_1V8 d_read_pre[13] NA2HDLLX0
XU51 VSS n31 n38 VDD_1V8 d_read_pre[12] NA2HDLLX0
XU49 VSS n30 n38 VDD_1V8 d_read_pre[11] NA2HDLLX0
XU47 VSS n29 n38 VDD_1V8 d_read_pre[10] NA2HDLLX0
XU45 VSS n28 n38 VDD_1V8 d_read_pre[9] NA2HDLLX0
XU43 VSS n27 n38 VDD_1V8 d_read_pre[8] NA2HDLLX0
XU40 VSS n44 q[23] VDD_1V8 n25 d_read_pre[7] NA22HDLLX0
XU33 VSS n18 n17 VDD_1V8 d_read_pre[6] NA2HDLLX0
XU30 VSS n12 n11 VDD_1V8 d_read_pre[5] NA2HDLLX0
XU27 VSS n10 n9 VDD_1V8 d_read_pre[4] NA2HDLLX0
XU24 VSS n8 n7 VDD_1V8 d_read_pre[3] NA2HDLLX0
XU21 VSS n6 n5 VDD_1V8 d_read_pre[2] NA2HDLLX0
XU18 VSS n4 n3 VDD_1V8 d_read_pre[1] NA2HDLLX0
XU15 VSS n2 n1 VDD_1V8 d_read_pre[0] NA2HDLLX0
XU76 VSS n43 q[31] VDD_1V8 n42 d_read_pre[31] NA22HDLLX0
XU75 VSS q[30] n43 VDD_1V8 n42 d_read_pre[30] NA22HDLLX0
XU74 VSS q[29] n43 VDD_1V8 n42 d_read_pre[29] NA22HDLLX0
XU73 VSS q[28] n43 VDD_1V8 n42 d_read_pre[28] NA22HDLLX0
XU72 VSS q[27] n43 VDD_1V8 n42 d_read_pre[27] NA22HDLLX0
XU71 VSS q[26] n43 VDD_1V8 n42 d_read_pre[26] NA22HDLLX0
XU70 VSS q[25] n43 VDD_1V8 n42 d_read_pre[25] NA22HDLLX0
XU69 VSS q[24] n43 VDD_1V8 n42 d_read_pre[24] NA22HDLLX0
.ENDS

.SUBCKT DECO_INSTR ld_id inst[31] inst[30] inst[29] inst[28] inst[27] inst[26] inst[25]
+ inst[24] inst[23] inst[22] inst[21] inst[20] inst[19] inst[18] inst[17] inst[16]
+ inst[15] inst[14] inst[13] inst[12] inst[11] inst[10] inst[9] inst[8] inst[7]
+ inst[6] inst[5] inst[4] inst[3] inst[2] inst[1] inst[0] reset rs1[4] rs1[3] rs1[2]
+ rs1[1] rs1[0] rs2[4] rs2[3] rs2[2] rs2[1] rs2[0] rd[4] rd[3] rd[2] rd[1] rd[0]
+ imm[31] imm[30] imm[29] imm[28] imm[27] imm[26] imm[25] imm[24] imm[23] imm[22]
+ imm[21] imm[20] imm[19] imm[18] imm[17] imm[16] imm[15] imm[14] imm[13] imm[12]
+ imm[11] imm[10] imm[9] imm[8] imm[7] imm[6] imm[5] imm[4] imm[3] imm[2] imm[1]
+ imm[0] codif[6] codif[5] codif[4] codif[3] codif[2] codif[1] codif[0] csr[3] csr[2]
+ csr[1] csr[0] VSS VDD_1V8 IN0
Xinst_reg_reg_24_ reset n22 inst[24] n112 n106 VSS VDD_1V8 DFRRHDLLX0
Xinst_reg_reg_31_ IN0 n22 inst[31] n110 n61 VSS VDD_1V8 DFRRHDLLX0
Xinst_reg_reg_19_ reset n22 inst[19] SYNOPSYS_UNCONNECTED_64 n100 VSS VDD_1V8 DFRRHDLLX0
Xinst_reg_reg_20_ reset n22 inst[20] n114 n111 VSS VDD_1V8 DFRRHDLLX0
Xinst_reg_reg_23_ reset n22 inst[23] n113 n107 VSS VDD_1V8 DFRRHDLLX0
Xinst_reg_reg_16_ reset n22 inst[16] SYNOPSYS_UNCONNECTED_65 n103 VSS VDD_1V8 DFRRHDLLX0
Xinst_reg_reg_17_ reset n22 inst[17] SYNOPSYS_UNCONNECTED_66 n102 VSS VDD_1V8 DFRRHDLLX0
Xinst_reg_reg_18_ reset n22 inst[18] SYNOPSYS_UNCONNECTED_67 n101 VSS VDD_1V8 DFRRHDLLX0
Xinst_reg_reg_30_ reset n22 inst[30] inst_reg[30] n109 VSS VDD_1V8 DFRRHDLLX0
Xinst_reg_reg_13_ reset n22 inst[13] SYNOPSYS_UNCONNECTED_68 n58 VSS VDD_1V8 DFRRHDLLX0
Xinst_reg_reg_15_ reset n22 inst[15] SYNOPSYS_UNCONNECTED_69 n104 VSS VDD_1V8 DFRRHDLLX0
Xinst_reg_reg_3_ reset n22 inst[3] inst_reg[3] n115 VSS VDD_1V8 DFRRHDLLX0
XU10 n4 VSS VDD_1V8 inst_reg[4] INHDLLX0
XU11 VSS n71 inst_reg[3] n4 VDD_1V8 NO2HDLLX0
XU6 n5 VSS VDD_1V8 inst_reg[5] INHDLLX0
XU8 VSS inst_reg[3] inst_reg[4] VDD_1V8 n47 NA2HDLLX0
XU13 inst_reg[2] VSS n71 n40 VDD_1V8 inst_reg[5] n92 NO4I3HDLLX0
XU9 n55 VSS VDD_1V8 n47 INHDLLX0
XU35 inst_reg[2] n71 VSS VDD_1V8 n69 n5 NO3I2HDLLX0
XU17 n70 VSS VDD_1V8 inst_reg[14] INHDLLX0
XU23 inst_reg[0] VSS inst_reg[5] n40 inst_reg[1] VDD_1V8 n1 ON211HDLLX0
XU22 VSS VDD_1V8 n2 inst_reg[4] n5 inst_reg[2] n115 AN211HDLLX0
XU18 n10 VSS VDD_1V8 inst_reg[12] INHDLLX0
XU37 n75 VSS n4 inst_reg[2] VDD_1V8 n115 NA3HDLLX0
XU14 VSS n79 n55 n92 VDD_1V8 NO2HDLLX0
XU20 VSS VDD_1V8 n3 n71 n4 inst_reg[6] n40 AN22HDLLX0
XU36 n88 VSS VDD_1V8 n69 INHDLLX0
XU7 n53 VSS VDD_1V8 inst_reg[2] n5 inst_reg[4] NO3HDLLX0
XU19 n14 VSS n10 n58 VDD_1V8 n70 NA3HDLLX0
XU38 VSS n88 n75 VDD_1V8 n8 NA2HDLLX0
XU15 n68 VSS VDD_1V8 n79 INHDLLX0
XU24 VSS VDD_1V8 n80 inst_reg[2] n3 n2 n1 AN211HDLLX0
XU34 VSS n24 inst_reg[4] inst_reg[2] VDD_1V8 NO2HDLLX0
XU39 n5 VSS n8 n24 VDD_1V8 n78 AN21HDLLX0
XU25 VSS n54 VDD_1V8 n80 n47 n14 ON21HDLLX0
XU16 VSS n76 n53 n68 VDD_1V8 NO2HDLLX0
XU40 n70 n14 VSS VDD_1V8 inst_reg[6] n6 n71 NA4HDLLX0
Xplace6 n42 VSS VDD_1V8 n54 INHDLLX0
XU41 VSS n12 n6 n78 VDD_1V8 n76 AND3HDLLX0
XU42 VSS rs1[4] VDD_1V8 n42 n100 n12 ON21HDLLX0
XU43 VSS rs1[3] VDD_1V8 n42 n101 n12 ON21HDLLX0
XU44 VSS rs1[2] VDD_1V8 n42 n102 n12 ON21HDLLX0
XU45 VSS rs1[1] VDD_1V8 n42 n103 n12 ON21HDLLX0
XU46 VSS rs1[0] VDD_1V8 n42 n104 n12 ON21HDLLX0
XU67 VSS inst_reg[6] n71 VDD_1V8 n13 NA2HDLLX0
XU68 VSS n91 n14 n13 VDD_1V8 NO2HDLLX0
XU118 n60 VSS VDD_1V8 inst_reg[25] INHDLLX0
XU51 VSS n96 n115 n40 VDD_1V8 NO2HDLLX0
XU69 n45 VSS VDD_1V8 n91 INHDLLX0
XU126 n46 VSS VDD_1V8 inst_reg[7] INHDLLX0
XU88 VSS n53 n40 VDD_1V8 n73 NA2HDLLX0
XU127 n48 VSS VDD_1V8 n46 n73 n60 n47 ON22HDLLX0
XU74 n26 VSS VDD_1V8 n96 INHDLLX0
XU125 VSS n78 n45 VDD_1V8 n49 NA2HDLLX0
XU29 n84 VSS VDD_1V8 inst_reg[22] INHDLLX0
XU31 n34 VSS VDD_1V8 inst_reg[21] INHDLLX0
XU27 VSS rs2[4] VDD_1V8 n42 n76 n106 ON21HDLLX0
XU33 VSS rs2[0] VDD_1V8 n42 n76 n111 ON21HDLLX0
XU28 VSS rs2[3] VDD_1V8 n42 n76 n107 ON21HDLLX0
XU30 VSS rs2[2] VDD_1V8 n42 n84 n76 ON21HDLLX0
XU32 VSS rs2[1] VDD_1V8 n42 n34 n76 ON21HDLLX0
XU75 n52 VSS n26 n45 VDD_1V8 n78 NA3HDLLX0
XU47 n51 VSS n71 inst_reg[14] VDD_1V8 inst_reg[6] NA3HDLLX0
XU128 VSS VDD_1V8 n50 n114 n49 n54 n48 AN211HDLLX0
XU129 VSS imm[0] VDD_1V8 n50 n51 n104 ON21HDLLX0
XU104 n52 VSS n54 inst_reg[21] VDD_1V8 n31 AN21HDLLX0
XU103 VSS VDD_1V8 n32 n55 inst_reg[8] n53 inst_reg[26] AN22HDLLX0
XU105 n31 VSS n103 n51 n32 VDD_1V8 imm[1] ON211HDLLX0
XU73 VSS VDD_1V8 n16 n55 inst_reg[9] n53 inst_reg[27] AN22HDLLX0
XU76 n52 VSS n54 inst_reg[22] VDD_1V8 n15 AN21HDLLX0
XU86 n52 VSS n54 n113 VDD_1V8 n20 AN21HDLLX0
XU77 n15 VSS n102 n51 n16 VDD_1V8 imm[2] ON211HDLLX0
XU84 VSS VDD_1V8 n21 n55 inst_reg[10] n53 inst_reg[28] AN22HDLLX0
XU87 n20 VSS n101 n51 n21 VDD_1V8 imm[3] ON211HDLLX0
XU93 VSS VDD_1V8 n28 n55 inst_reg[11] n53 inst_reg[29] AN22HDLLX0
XU95 n52 VSS n54 n112 VDD_1V8 n27 AN21HDLLX0
XU96 n27 VSS n100 n51 n28 VDD_1V8 imm[4] ON211HDLLX0
XU130 VSS n59 n53 n52 VDD_1V8 NO2HDLLX0
XU131 inst_reg[30] VSS n54 n55 VDD_1V8 n56 AN21HDLLX0
XU132 VSS imm[5] VDD_1V8 n56 n60 n59 ON21HDLLX0
XU57 n110 VSS n54 n55 VDD_1V8 n57 AN21HDLLX0
XU52 VSS inst_reg[2] n71 VDD_1V8 n67 NA2HDLLX0
XU55 VSS VDD_1V8 n9 n24 n70 n53 n8 AN211HDLLX0
XU89 n23 n73 n45 VSS VDD_1V8 n78 n61 AN31HDLLX0
XU133 n62 VSS VDD_1V8 inst_reg[26] INHDLLX0
XU58 VSS n11 VDD_1V8 n57 n9 n61 ON21HDLLX0
XU90 n25 inst_reg[7] inst_reg[6] VSS VDD_1V8 n24 n23 AN31HDLLX0
XU135 n63 VSS VDD_1V8 inst_reg[27] INHDLLX0
XU134 VSS imm[6] VDD_1V8 n57 n62 n59 ON21HDLLX0
XU136 VSS imm[7] VDD_1V8 n57 n63 n59 ON21HDLLX0
XU139 VSS imm[10] VDD_1V8 n57 n109 n59 ON21HDLLX0
XU54 VSS n30 n96 n41 VDD_1V8 NO2HDLLX0
XU59 n29 VSS VDD_1V8 n11 INHDLLX0
XU91 n25 VSS n111 n26 n57 VDD_1V8 imm[11] ON211HDLLX0
XU111 n64 VSS VDD_1V8 inst_reg[28] INHDLLX0
XU114 n65 VSS VDD_1V8 inst_reg[29] INHDLLX0
XU99 VSS imm[15] VDD_1V8 n29 n104 n30 ON21HDLLX0
XU63 VSS imm[14] VDD_1V8 n29 n70 n30 ON21HDLLX0
XU98 VSS imm[13] VDD_1V8 n29 n30 n58 ON21HDLLX0
XU138 VSS imm[9] VDD_1V8 n57 n65 n59 ON21HDLLX0
XU137 VSS imm[8] VDD_1V8 n57 n64 n59 ON21HDLLX0
XU60 VSS imm[12] VDD_1V8 n29 n30 n10 ON21HDLLX0
XU61 n110 VSS n11 n96 VDD_1V8 n66 AN21HDLLX0
XU92 VSS imm[17] VDD_1V8 n29 n102 n30 ON21HDLLX0
XU100 VSS imm[16] VDD_1V8 n29 n103 n30 ON21HDLLX0
XU101 VSS imm[18] VDD_1V8 n29 n101 n30 ON21HDLLX0
XU102 VSS imm[19] VDD_1V8 n29 n100 n30 ON21HDLLX0
XU97 VSS imm[20] VDD_1V8 n66 n67 n111 ON21HDLLX0
XU62 VSS imm[21] VDD_1V8 n66 n34 n67 ON21HDLLX0
XU107 VSS imm[23] VDD_1V8 n66 n67 n107 ON21HDLLX0
XU140 VSS imm[25] VDD_1V8 n66 n60 n67 ON21HDLLX0
XU64 VSS imm[22] VDD_1V8 n66 n84 n67 ON21HDLLX0
XU106 VSS imm[24] VDD_1V8 n66 n67 n106 ON21HDLLX0
XU143 VSS imm[28] VDD_1V8 n66 n64 n67 ON21HDLLX0
XU142 VSS imm[27] VDD_1V8 n66 n63 n67 ON21HDLLX0
XU141 VSS imm[26] VDD_1V8 n66 n62 n67 ON21HDLLX0
XU144 VSS imm[29] VDD_1V8 n66 n65 n67 ON21HDLLX0
XU146 VSS imm[31] VDD_1V8 n66 n67 n61 ON21HDLLX0
XU108 inst_reg[29] n84 VSS VDD_1V8 inst_reg[28] n33 n111 NA4HDLLX0
XU145 VSS imm[30] VDD_1V8 n66 n109 n67 ON21HDLLX0
XU109 VSS n43 n34 n33 VDD_1V8 NO2HDLLX0
XU112 n90 VSS VDD_1V8 n84 n64 n111 NO3HDLLX0
XU113 VSS n35 inst_reg[22] inst_reg[28] VDD_1V8 NO2HDLLX0
XU110 n37 VSS VDD_1V8 n43 INHDLLX0
XU115 n65 VSS n90 n35 n34 VDD_1V8 n36 ON211HDLLX0
XU116 VSS VDD_1V8 n38 n37 n36 inst_reg[26] inst_reg[27] AN211HDLLX0
XU119 n109 n60 VSS VDD_1V8 n38 n39 n107 NA4HDLLX0
XU120 VSS n77 VDD_1V8 n39 n91 n112 n110 ON31HDLLX0
XU121 VSS n42 n77 VDD_1V8 n94 NA2HDLLX0
XU65 VSS n12 n51 VDD_1V8 n81 NA2HDLLX0
XU122 n43 VSS n94 n91 VDD_1V8 n87 AN21HDLLX0
XU66 n44 VSS VDD_1V8 n81 INHDLLX0
XU153 n85 VSS n84 n114 VDD_1V8 n91 NA3HDLLX0
XU152 VSS VDD_1V8 n86 inst_reg[12] n41 inst_reg[5] n81 AN22HDLLX0
XU156 VSS VDD_1V8 n93 n91 n92 inst_reg[30] n90 AN22HDLLX0
XU155 n95 n109 n58 VSS VDD_1V8 inst_reg[12] n88 AN31HDLLX0
XU154 codif[3] VSS n86 n85 VDD_1V8 n87 NA3HDLLX0
XU123 VSS codif[4] VDD_1V8 n87 n44 n58 ON21HDLLX0
XU70 n45 VSS n44 n70 n42 VDD_1V8 codif[5] ON211HDLLX1
XU157 VSS VDD_1V8 n95 n96 n93 codif[6] n94 NA4I3HDLLX0
XU150 n75 n77 VSS VDD_1V8 n76 codif[1] n80 NA4HDLLX0
XU147 n74 inst_reg[12] n58 VSS VDD_1V8 n69 n68 AN31HDLLX0
XU148 n72 VSS inst_reg[6] n70 VDD_1V8 n71 NA3HDLLX0
XU151 n78 n77 VSS VDD_1V8 n79 codif[2] n80 NA4HDLLX0
XU149 n73 n72 VSS VDD_1V8 n74 codif[0] n80 NA4HDLLX0
XU48 VSS n51 n6 VDD_1V8 n17 AND2HDLLX0
XU78 n30 n78 VSS VDD_1V8 n17 n18 n79 NA4HDLLX0
XU79 VSS n18 inst_reg[9] VDD_1V8 n42 rd[2] NA22HDLLX0
XU80 VSS n18 inst_reg[10] VDD_1V8 n42 rd[3] NA22HDLLX0
XU81 VSS n18 inst_reg[11] VDD_1V8 n42 rd[4] NA22HDLLX0
XU82 VSS n18 inst_reg[7] VDD_1V8 n42 rd[0] NA22HDLLX0
XU83 VSS n18 inst_reg[8] VDD_1V8 n42 rd[1] NA22HDLLX0
XU49 VSS csr[1] VDD_1V8 n42 n34 n17 ON21HDLLX0
XU50 VSS csr[2] VDD_1V8 n42 n84 n17 ON21HDLLX0
XU72 VSS csr[3] VDD_1V8 n42 n17 n107 ON21HDLLX0
XU71 VSS csr[0] VDD_1V8 n42 n17 n111 ON21HDLLX0
Xplace3 VSS VDD_1V8 n22 ld_id BUHDLLX0
Xplace5 n41 VSS VDD_1V8 n67 INHDLLX0
Xplace4 n40 VSS VDD_1V8 inst_reg[6] INHDLLX0
Xinst_reg_reg_0_ reset n22 inst[0] inst_reg[0] VSS VDD_1V8 DFRRQHDLLX0
Xinst_reg_reg_1_ reset n22 inst[1] inst_reg[1] VSS VDD_1V8 DFRRQHDLLX0
Xinst_reg_reg_2_ reset n22 inst[2] inst_reg[2] VSS VDD_1V8 DFRRQHDLLX0
Xinst_reg_reg_4_ reset n22 inst[4] inst_reg[4] VSS VDD_1V8 DFRRQHDLLX0
Xinst_reg_reg_5_ reset n22 inst[5] inst_reg[5] VSS VDD_1V8 DFRRQHDLLX0
Xinst_reg_reg_6_ reset n22 inst[6] inst_reg[6] VSS VDD_1V8 DFRRQHDLLX0
Xinst_reg_reg_7_ reset n22 inst[7] inst_reg[7] VSS VDD_1V8 DFRRQHDLLX0
Xinst_reg_reg_8_ reset n22 inst[8] inst_reg[8] VSS VDD_1V8 DFRRQHDLLX0
Xinst_reg_reg_9_ reset n22 inst[9] inst_reg[9] VSS VDD_1V8 DFRRQHDLLX0
Xinst_reg_reg_10_ reset n22 inst[10] inst_reg[10] VSS VDD_1V8 DFRRQHDLLX0
Xinst_reg_reg_11_ reset n22 inst[11] inst_reg[11] VSS VDD_1V8 DFRRQHDLLX0
Xinst_reg_reg_12_ reset n22 inst[12] inst_reg[12] VSS VDD_1V8 DFRRQHDLLX0
Xinst_reg_reg_14_ reset n22 inst[14] inst_reg[14] VSS VDD_1V8 DFRRQHDLLX0
Xinst_reg_reg_21_ reset n22 inst[21] inst_reg[21] VSS VDD_1V8 DFRRQHDLLX0
Xinst_reg_reg_22_ reset n22 inst[22] inst_reg[22] VSS VDD_1V8 DFRRQHDLLX0
Xinst_reg_reg_25_ reset n22 inst[25] inst_reg[25] VSS VDD_1V8 DFRRQHDLLX0
Xinst_reg_reg_26_ reset n22 inst[26] inst_reg[26] VSS VDD_1V8 DFRRQHDLLX0
Xinst_reg_reg_27_ reset n22 inst[27] inst_reg[27] VSS VDD_1V8 DFRRQHDLLX0
Xinst_reg_reg_28_ reset n22 inst[28] inst_reg[28] VSS VDD_1V8 DFRRQHDLLX0
Xinst_reg_reg_29_ reset n22 inst[29] inst_reg[29] VSS VDD_1V8 DFRRQHDLLX0
.ENDS

.SUBCKT csk_bloque_7 a[3] a[2] a[1] a[0] b[3] b[2] b[1] b[0] cin s[3] s[2] s[1] s[0]
+ cout VSS VDD_1V8
XU6 n5 b[0] VSS VDD_1V8 s[0] a[0] NO22HDLLX0
XU5 VSS VDD_1V8 b[1] s[1] n5 a[1] n4 FAHDLLX0
XU4 VSS VDD_1V8 b[2] s[2] n4 a[2] n3 FAHDLLX0
XU3 VSS VDD_1V8 b[3] s[3] n3 a[3] cout FAHDLLX0
XU1 VSS b[0] a[0] VDD_1V8 n5 AND2HDLLX0
.ENDS

.SUBCKT csk_bloque_6 a[3] a[2] a[1] a[0] b[3] b[2] b[1] b[0] cin s[3] s[2] s[1] s[0]
+ cout VSS VDD_1V8
XU5 VSS VDD_1V8 b[0] s[0] cin a[0] n4 FAHDLLX0
XU4 VSS VDD_1V8 b[1] s[1] n4 a[1] n3 FAHDLLX0
XU3 VSS VDD_1V8 b[2] s[2] n3 a[2] n2 FAHDLLX0
XU2 VSS VDD_1V8 a[3] s[3] n2 b[3] cout FAHDLLX0
.ENDS

.SUBCKT csk_bloque_5 a[3] a[2] a[1] a[0] b[3] b[2] b[1] b[0] cin s[3] s[2] s[1] s[0]
+ cout VSS VDD_1V8
XU5 VSS VDD_1V8 b[0] s[0] cin a[0] n4 FAHDLLX0
XU4 VSS VDD_1V8 b[1] s[1] n4 a[1] n3 FAHDLLX0
XU3 VSS VDD_1V8 b[2] s[2] n3 a[2] n2 FAHDLLX0
XU2 VSS VDD_1V8 a[3] s[3] n2 b[3] cout FAHDLLX0
.ENDS

.SUBCKT csk_bloque_4 a[3] a[2] a[1] a[0] b[3] b[2] b[1] b[0] cin s[3] s[2] s[1] s[0]
+ cout VSS VDD_1V8
XU5 VSS VDD_1V8 b[0] s[0] cin a[0] n4 FAHDLLX0
XU4 VSS VDD_1V8 b[1] s[1] n4 a[1] n3 FAHDLLX0
XU3 VSS VDD_1V8 b[2] s[2] n3 a[2] n2 FAHDLLX0
XU2 VSS VDD_1V8 a[3] s[3] n2 b[3] cout FAHDLLX0
.ENDS

.SUBCKT csk_bloque_3 a[3] a[2] a[1] a[0] b[3] b[2] b[1] b[0] cin s[3] s[2] s[1] s[0]
+ cout VSS VDD_1V8
XU5 VSS VDD_1V8 b[0] s[0] cin a[0] n4 FAHDLLX0
XU4 VSS VDD_1V8 b[1] s[1] n4 a[1] n3 FAHDLLX0
XU3 VSS VDD_1V8 b[2] s[2] n3 a[2] n2 FAHDLLX0
XU2 VSS VDD_1V8 a[3] s[3] n2 b[3] cout FAHDLLX0
.ENDS

.SUBCKT csk_bloque_2 a[3] a[2] a[1] a[0] b[3] b[2] b[1] b[0] cin s[3] s[2] s[1] s[0]
+ cout VSS VDD_1V8
XU5 VSS VDD_1V8 b[0] s[0] cin a[0] n4 FAHDLLX0
XU4 VSS VDD_1V8 b[1] s[1] n4 a[1] n3 FAHDLLX0
XU3 VSS VDD_1V8 b[2] s[2] n3 a[2] n2 FAHDLLX0
XU2 VSS VDD_1V8 a[3] s[3] n2 b[3] cout FAHDLLX0
.ENDS

.SUBCKT csk_bloque_1 a[3] a[2] a[1] a[0] b[3] b[2] b[1] b[0] cin s[3] s[2] s[1] s[0]
+ cout VSS VDD_1V8
XU5 VSS VDD_1V8 b[0] s[0] cin a[0] n4 FAHDLLX0
XU4 VSS VDD_1V8 b[1] s[1] n4 a[1] n3 FAHDLLX0
XU3 VSS VDD_1V8 b[2] s[2] n3 a[2] n2 FAHDLLX0
XU2 VSS VDD_1V8 a[3] s[3] n2 b[3] cout FAHDLLX0
.ENDS

.SUBCKT csk_bloque_0 a[3] a[2] a[1] a[0] b[3] b[2] b[1] b[0] cin s[3] s[2] s[1] s[0]
+ cout VSS VDD_1V8
XU5 VSS s[3] a[3] VDD_1V8 b[3] n3 EO3HDLLX0
XU3 VSS VDD_1V8 b[2] s[2] n2 a[2] n3 FAHDLLX0
XU2 VSS VDD_1V8 b[1] s[1] n1 a[1] n2 FAHDLLX0
XU1 VSS VDD_1V8 b[0] s[0] cin a[0] n1 FAHDLLX0
.ENDS

.SUBCKT tristate_buffer_11 input_x[31] input_x[30] input_x[29] input_x[28] input_x[27]
+ input_x[26] input_x[25] input_x[24] input_x[23] input_x[22] input_x[21] input_x[20]
+ input_x[19] input_x[18] input_x[17] input_x[16] input_x[15] input_x[14] input_x[13]
+ input_x[12] input_x[11] input_x[10] input_x[9] input_x[8] input_x[7] input_x[6]
+ input_x[5] input_x[4] input_x[3] input_x[2] input_x[1] input_x[0] enable output_x[31]
+ output_x[30] output_x[29] output_x[28] output_x[27] output_x[26] output_x[25]
+ output_x[24] output_x[23] output_x[22] output_x[21] output_x[20] output_x[19]
+ output_x[18] output_x[17] output_x[16] output_x[15] output_x[14] output_x[13]
+ output_x[12] output_x[11] output_x[10] output_x[9] output_x[8] output_x[7] output_x[6]
+ output_x[5] output_x[4] output_x[3] output_x[2] output_x[1] output_x[0] VSS VDD_1V8
Xoutput_x_tri_20_ VSS enable VDD_1V8 input_x[20] output_x[20] BTHHDLLX2
Xoutput_x_tri_16_ VSS enable VDD_1V8 input_x[16] output_x[16] BTHHDLLX2
Xoutput_x_tri_0_ VSS enable VDD_1V8 input_x[0] output_x[0] BTHHDLLX2
Xoutput_x_tri_24_ VSS enable VDD_1V8 input_x[24] output_x[24] BTHHDLLX2
Xoutput_x_tri_4_ VSS enable VDD_1V8 input_x[4] output_x[4] BTHHDLLX2
Xoutput_x_tri_28_ VSS enable VDD_1V8 input_x[28] output_x[28] BTHHDLLX2
Xoutput_x_tri_8_ VSS enable VDD_1V8 input_x[8] output_x[8] BTHHDLLX2
Xoutput_x_tri_12_ VSS enable VDD_1V8 input_x[12] output_x[12] BTHHDLLX2
Xoutput_x_tri_2_ VSS enable VDD_1V8 input_x[2] output_x[2] BTHHDLLX2
Xoutput_x_tri_6_ VSS enable VDD_1V8 input_x[6] output_x[6] BTHHDLLX2
Xoutput_x_tri_10_ VSS enable VDD_1V8 input_x[10] output_x[10] BTHHDLLX2
Xoutput_x_tri_30_ VSS enable VDD_1V8 input_x[30] output_x[30] BTHHDLLX2
Xoutput_x_tri_5_ VSS enable VDD_1V8 input_x[5] output_x[5] BTHHDLLX2
Xoutput_x_tri_14_ VSS enable VDD_1V8 input_x[14] output_x[14] BTHHDLLX2
Xoutput_x_tri_18_ VSS enable VDD_1V8 input_x[18] output_x[18] BTHHDLLX2
Xoutput_x_tri_9_ VSS enable VDD_1V8 input_x[9] output_x[9] BTHHDLLX2
Xoutput_x_tri_1_ VSS enable VDD_1V8 input_x[1] output_x[1] BTHHDLLX2
Xoutput_x_tri_26_ VSS enable VDD_1V8 input_x[26] output_x[26] BTHHDLLX2
Xoutput_x_tri_19_ VSS enable VDD_1V8 input_x[19] output_x[19] BTHHDLLX2
Xoutput_x_tri_13_ VSS enable VDD_1V8 input_x[13] output_x[13] BTHHDLLX2
Xoutput_x_tri_22_ VSS enable VDD_1V8 input_x[22] output_x[22] BTHHDLLX2
Xoutput_x_tri_29_ VSS enable VDD_1V8 input_x[29] output_x[29] BTHHDLLX2
Xoutput_x_tri_17_ VSS enable VDD_1V8 input_x[17] output_x[17] BTHHDLLX2
Xoutput_x_tri_15_ VSS enable VDD_1V8 input_x[15] output_x[15] BTHHDLLX2
Xoutput_x_tri_31_ VSS enable VDD_1V8 input_x[31] output_x[31] BTHHDLLX2
Xoutput_x_tri_23_ VSS enable VDD_1V8 input_x[23] output_x[23] BTHHDLLX2
Xoutput_x_tri_3_ VSS enable VDD_1V8 input_x[3] output_x[3] BTHHDLLX2
Xoutput_x_tri_21_ VSS enable VDD_1V8 input_x[21] output_x[21] BTHHDLLX2
Xoutput_x_tri_25_ VSS enable VDD_1V8 input_x[25] output_x[25] BTHHDLLX2
Xoutput_x_tri_7_ VSS enable VDD_1V8 input_x[7] output_x[7] BTHHDLLX2
Xoutput_x_tri_27_ VSS enable VDD_1V8 input_x[27] output_x[27] BTHHDLLX2
Xoutput_x_tri_11_ VSS enable VDD_1V8 input_x[11] output_x[11] BTHHDLLX2
.ENDS

.SUBCKT tristate_buffer_10 input_x[31] input_x[30] input_x[29] input_x[28] input_x[27]
+ input_x[26] input_x[25] input_x[24] input_x[23] input_x[22] input_x[21] input_x[20]
+ input_x[19] input_x[18] input_x[17] input_x[16] input_x[15] input_x[14] input_x[13]
+ input_x[12] input_x[11] input_x[10] input_x[9] input_x[8] input_x[7] input_x[6]
+ input_x[5] input_x[4] input_x[3] input_x[2] input_x[1] input_x[0] enable output_x[31]
+ output_x[30] output_x[29] output_x[28] output_x[27] output_x[26] output_x[25]
+ output_x[24] output_x[23] output_x[22] output_x[21] output_x[20] output_x[19]
+ output_x[18] output_x[17] output_x[16] output_x[15] output_x[14] output_x[13]
+ output_x[12] output_x[11] output_x[10] output_x[9] output_x[8] output_x[7] output_x[6]
+ output_x[5] output_x[4] output_x[3] output_x[2] output_x[1] output_x[0] VSS VDD_1V8
Xoutput_x_tri_2_ VSS enable VDD_1V8 input_x[2] output_x[2] BTHHDLLX2
Xoutput_x_tri_6_ VSS enable VDD_1V8 input_x[6] output_x[6] BTHHDLLX2
Xoutput_x_tri_10_ VSS enable VDD_1V8 input_x[10] output_x[10] BTHHDLLX2
Xoutput_x_tri_20_ VSS enable VDD_1V8 input_x[20] output_x[20] BTHHDLLX2
Xoutput_x_tri_16_ VSS enable VDD_1V8 input_x[16] output_x[16] BTHHDLLX2
Xoutput_x_tri_0_ VSS enable VDD_1V8 input_x[0] output_x[0] BTHHDLLX2
Xoutput_x_tri_24_ VSS enable VDD_1V8 input_x[24] output_x[24] BTHHDLLX2
Xoutput_x_tri_4_ VSS enable VDD_1V8 input_x[4] output_x[4] BTHHDLLX2
Xoutput_x_tri_28_ VSS enable VDD_1V8 input_x[28] output_x[28] BTHHDLLX2
Xoutput_x_tri_8_ VSS enable VDD_1V8 input_x[8] output_x[8] BTHHDLLX2
Xoutput_x_tri_12_ VSS enable VDD_1V8 input_x[12] output_x[12] BTHHDLLX2
Xoutput_x_tri_30_ VSS enable VDD_1V8 input_x[30] output_x[30] BTHHDLLX2
Xoutput_x_tri_5_ VSS enable VDD_1V8 input_x[5] output_x[5] BTHHDLLX2
Xoutput_x_tri_14_ VSS enable VDD_1V8 input_x[14] output_x[14] BTHHDLLX2
Xoutput_x_tri_18_ VSS enable VDD_1V8 input_x[18] output_x[18] BTHHDLLX2
Xoutput_x_tri_9_ VSS enable VDD_1V8 input_x[9] output_x[9] BTHHDLLX2
Xoutput_x_tri_1_ VSS enable VDD_1V8 input_x[1] output_x[1] BTHHDLLX2
Xoutput_x_tri_26_ VSS enable VDD_1V8 input_x[26] output_x[26] BTHHDLLX2
Xoutput_x_tri_19_ VSS enable VDD_1V8 input_x[19] output_x[19] BTHHDLLX2
Xoutput_x_tri_13_ VSS enable VDD_1V8 input_x[13] output_x[13] BTHHDLLX2
Xoutput_x_tri_22_ VSS enable VDD_1V8 input_x[22] output_x[22] BTHHDLLX2
Xoutput_x_tri_29_ VSS enable VDD_1V8 input_x[29] output_x[29] BTHHDLLX2
Xoutput_x_tri_17_ VSS enable VDD_1V8 input_x[17] output_x[17] BTHHDLLX2
Xoutput_x_tri_15_ VSS enable VDD_1V8 input_x[15] output_x[15] BTHHDLLX2
Xoutput_x_tri_31_ VSS enable VDD_1V8 input_x[31] output_x[31] BTHHDLLX2
Xoutput_x_tri_23_ VSS enable VDD_1V8 input_x[23] output_x[23] BTHHDLLX2
Xoutput_x_tri_3_ VSS enable VDD_1V8 input_x[3] output_x[3] BTHHDLLX2
Xoutput_x_tri_21_ VSS enable VDD_1V8 input_x[21] output_x[21] BTHHDLLX2
Xoutput_x_tri_25_ VSS enable VDD_1V8 input_x[25] output_x[25] BTHHDLLX2
Xoutput_x_tri_7_ VSS enable VDD_1V8 input_x[7] output_x[7] BTHHDLLX2
Xoutput_x_tri_27_ VSS enable VDD_1V8 input_x[27] output_x[27] BTHHDLLX2
Xoutput_x_tri_11_ VSS enable VDD_1V8 input_x[11] output_x[11] BTHHDLLX2
.ENDS

.SUBCKT tristate_buffer_9 input_x[31] input_x[30] input_x[29] input_x[28] input_x[27]
+ input_x[26] input_x[25] input_x[24] input_x[23] input_x[22] input_x[21] input_x[20]
+ input_x[19] input_x[18] input_x[17] input_x[16] input_x[15] input_x[14] input_x[13]
+ input_x[12] input_x[11] input_x[10] input_x[9] input_x[8] input_x[7] input_x[6]
+ input_x[5] input_x[4] input_x[3] input_x[2] input_x[1] input_x[0] enable output_x[31]
+ output_x[30] output_x[29] output_x[28] output_x[27] output_x[26] output_x[25]
+ output_x[24] output_x[23] output_x[22] output_x[21] output_x[20] output_x[19]
+ output_x[18] output_x[17] output_x[16] output_x[15] output_x[14] output_x[13]
+ output_x[12] output_x[11] output_x[10] output_x[9] output_x[8] output_x[7] output_x[6]
+ output_x[5] output_x[4] output_x[3] output_x[2] output_x[1] output_x[0] VSS VDD_1V8
Xoutput_x_tri_2_ VSS enable VDD_1V8 input_x[2] output_x[2] BTHHDLLX2
Xoutput_x_tri_6_ VSS enable VDD_1V8 input_x[6] output_x[6] BTHHDLLX2
Xoutput_x_tri_10_ VSS enable VDD_1V8 input_x[10] output_x[10] BTHHDLLX2
Xoutput_x_tri_20_ VSS enable VDD_1V8 input_x[20] output_x[20] BTHHDLLX2
Xoutput_x_tri_30_ VSS enable VDD_1V8 input_x[30] output_x[30] BTHHDLLX2
Xoutput_x_tri_5_ VSS enable VDD_1V8 input_x[5] output_x[5] BTHHDLLX2
Xoutput_x_tri_14_ VSS enable VDD_1V8 input_x[14] output_x[14] BTHHDLLX2
Xoutput_x_tri_16_ VSS enable VDD_1V8 input_x[16] output_x[16] BTHHDLLX2
Xoutput_x_tri_18_ VSS enable VDD_1V8 input_x[18] output_x[18] BTHHDLLX2
Xoutput_x_tri_0_ VSS enable VDD_1V8 input_x[0] output_x[0] BTHHDLLX2
Xoutput_x_tri_24_ VSS enable VDD_1V8 input_x[24] output_x[24] BTHHDLLX2
Xoutput_x_tri_9_ VSS enable VDD_1V8 input_x[9] output_x[9] BTHHDLLX2
Xoutput_x_tri_4_ VSS enable VDD_1V8 input_x[4] output_x[4] BTHHDLLX2
Xoutput_x_tri_1_ VSS enable VDD_1V8 input_x[1] output_x[1] BTHHDLLX2
Xoutput_x_tri_28_ VSS enable VDD_1V8 input_x[28] output_x[28] BTHHDLLX2
Xoutput_x_tri_26_ VSS enable VDD_1V8 input_x[26] output_x[26] BTHHDLLX2
Xoutput_x_tri_19_ VSS enable VDD_1V8 input_x[19] output_x[19] BTHHDLLX2
Xoutput_x_tri_8_ VSS enable VDD_1V8 input_x[8] output_x[8] BTHHDLLX2
Xoutput_x_tri_13_ VSS enable VDD_1V8 input_x[13] output_x[13] BTHHDLLX2
Xoutput_x_tri_22_ VSS enable VDD_1V8 input_x[22] output_x[22] BTHHDLLX2
Xoutput_x_tri_29_ VSS enable VDD_1V8 input_x[29] output_x[29] BTHHDLLX2
Xoutput_x_tri_17_ VSS enable VDD_1V8 input_x[17] output_x[17] BTHHDLLX2
Xoutput_x_tri_12_ VSS enable VDD_1V8 input_x[12] output_x[12] BTHHDLLX2
Xoutput_x_tri_15_ VSS enable VDD_1V8 input_x[15] output_x[15] BTHHDLLX2
Xoutput_x_tri_31_ VSS enable VDD_1V8 input_x[31] output_x[31] BTHHDLLX2
Xoutput_x_tri_23_ VSS enable VDD_1V8 input_x[23] output_x[23] BTHHDLLX2
Xoutput_x_tri_3_ VSS enable VDD_1V8 input_x[3] output_x[3] BTHHDLLX2
Xoutput_x_tri_21_ VSS enable VDD_1V8 input_x[21] output_x[21] BTHHDLLX2
Xoutput_x_tri_25_ VSS enable VDD_1V8 input_x[25] output_x[25] BTHHDLLX2
Xoutput_x_tri_7_ VSS enable VDD_1V8 input_x[7] output_x[7] BTHHDLLX2
Xoutput_x_tri_27_ VSS enable VDD_1V8 input_x[27] output_x[27] BTHHDLLX2
Xoutput_x_tri_11_ VSS enable VDD_1V8 input_x[11] output_x[11] BTHHDLLX2
.ENDS

.SUBCKT tristate_buffer_8 input_x[31] input_x[30] input_x[29] input_x[28] input_x[27]
+ input_x[26] input_x[25] input_x[24] input_x[23] input_x[22] input_x[21] input_x[20]
+ input_x[19] input_x[18] input_x[17] input_x[16] input_x[15] input_x[14] input_x[13]
+ input_x[12] input_x[11] input_x[10] input_x[9] input_x[8] input_x[7] input_x[6]
+ input_x[5] input_x[4] input_x[3] input_x[2] input_x[1] input_x[0] enable output_x[31]
+ output_x[30] output_x[29] output_x[28] output_x[27] output_x[26] output_x[25]
+ output_x[24] output_x[23] output_x[22] output_x[21] output_x[20] output_x[19]
+ output_x[18] output_x[17] output_x[16] output_x[15] output_x[14] output_x[13]
+ output_x[12] output_x[11] output_x[10] output_x[9] output_x[8] output_x[7] output_x[6]
+ output_x[5] output_x[4] output_x[3] output_x[2] output_x[1] output_x[0] VSS VDD_1V8
Xoutput_x_tri_20_ VSS enable VDD_1V8 input_x[20] output_x[20] BTHHDLLX2
Xoutput_x_tri_16_ VSS enable VDD_1V8 input_x[16] output_x[16] BTHHDLLX2
Xoutput_x_tri_0_ VSS enable VDD_1V8 input_x[0] output_x[0] BTHHDLLX2
Xoutput_x_tri_24_ VSS enable VDD_1V8 input_x[24] output_x[24] BTHHDLLX2
Xoutput_x_tri_4_ VSS enable VDD_1V8 input_x[4] output_x[4] BTHHDLLX2
Xoutput_x_tri_28_ VSS enable VDD_1V8 input_x[28] output_x[28] BTHHDLLX2
Xoutput_x_tri_8_ VSS enable VDD_1V8 input_x[8] output_x[8] BTHHDLLX2
Xoutput_x_tri_12_ VSS enable VDD_1V8 input_x[12] output_x[12] BTHHDLLX2
Xoutput_x_tri_2_ VSS enable VDD_1V8 input_x[2] output_x[2] BTHHDLLX2
Xoutput_x_tri_6_ VSS enable VDD_1V8 input_x[6] output_x[6] BTHHDLLX2
Xoutput_x_tri_10_ VSS enable VDD_1V8 input_x[10] output_x[10] BTHHDLLX2
Xoutput_x_tri_30_ VSS enable VDD_1V8 input_x[30] output_x[30] BTHHDLLX2
Xoutput_x_tri_5_ VSS enable VDD_1V8 input_x[5] output_x[5] BTHHDLLX2
Xoutput_x_tri_14_ VSS enable VDD_1V8 input_x[14] output_x[14] BTHHDLLX2
Xoutput_x_tri_18_ VSS enable VDD_1V8 input_x[18] output_x[18] BTHHDLLX2
Xoutput_x_tri_9_ VSS enable VDD_1V8 input_x[9] output_x[9] BTHHDLLX2
Xoutput_x_tri_1_ VSS enable VDD_1V8 input_x[1] output_x[1] BTHHDLLX2
Xoutput_x_tri_26_ VSS enable VDD_1V8 input_x[26] output_x[26] BTHHDLLX2
Xoutput_x_tri_19_ VSS enable VDD_1V8 input_x[19] output_x[19] BTHHDLLX2
Xoutput_x_tri_13_ VSS enable VDD_1V8 input_x[13] output_x[13] BTHHDLLX2
Xoutput_x_tri_22_ VSS enable VDD_1V8 input_x[22] output_x[22] BTHHDLLX2
Xoutput_x_tri_29_ VSS enable VDD_1V8 input_x[29] output_x[29] BTHHDLLX2
Xoutput_x_tri_17_ VSS enable VDD_1V8 input_x[17] output_x[17] BTHHDLLX2
Xoutput_x_tri_15_ VSS enable VDD_1V8 input_x[15] output_x[15] BTHHDLLX2
Xoutput_x_tri_31_ VSS enable VDD_1V8 input_x[31] output_x[31] BTHHDLLX2
Xoutput_x_tri_23_ VSS enable VDD_1V8 input_x[23] output_x[23] BTHHDLLX2
Xoutput_x_tri_3_ VSS enable VDD_1V8 input_x[3] output_x[3] BTHHDLLX2
Xoutput_x_tri_21_ VSS enable VDD_1V8 input_x[21] output_x[21] BTHHDLLX2
Xoutput_x_tri_25_ VSS enable VDD_1V8 input_x[25] output_x[25] BTHHDLLX2
Xoutput_x_tri_7_ VSS enable VDD_1V8 input_x[7] output_x[7] BTHHDLLX2
Xoutput_x_tri_27_ VSS enable VDD_1V8 input_x[27] output_x[27] BTHHDLLX2
Xoutput_x_tri_11_ VSS enable VDD_1V8 input_x[11] output_x[11] BTHHDLLX2
.ENDS

.SUBCKT tristate_buffer_7 input_x[31] input_x[30] input_x[29] input_x[28] input_x[27]
+ input_x[26] input_x[25] input_x[24] input_x[23] input_x[22] input_x[21] input_x[20]
+ input_x[19] input_x[18] input_x[17] input_x[16] input_x[15] input_x[14] input_x[13]
+ input_x[12] input_x[11] input_x[10] input_x[9] input_x[8] input_x[7] input_x[6]
+ input_x[5] input_x[4] input_x[3] input_x[2] input_x[1] input_x[0] enable output_x[31]
+ output_x[30] output_x[29] output_x[28] output_x[27] output_x[26] output_x[25]
+ output_x[24] output_x[23] output_x[22] output_x[21] output_x[20] output_x[19]
+ output_x[18] output_x[17] output_x[16] output_x[15] output_x[14] output_x[13]
+ output_x[12] output_x[11] output_x[10] output_x[9] output_x[8] output_x[7] output_x[6]
+ output_x[5] output_x[4] output_x[3] output_x[2] output_x[1] output_x[0] VSS VDD_1V8
Xplace1 n2 VSS VDD_1V8 enable INHDLLX0
Xoutput_x_tri_4_ VSS n2 VDD_1V8 input_x[4] output_x[4] BTHHDLLX2
Xoutput_x_tri_2_ VSS n2 VDD_1V8 input_x[2] output_x[2] BTHHDLLX2
Xoutput_x_tri_1_ VSS n2 VDD_1V8 input_x[1] output_x[1] BTHHDLLX2
Xoutput_x_tri_12_ VSS n2 VDD_1V8 input_x[12] output_x[12] BTHHDLLX2
Xoutput_x_tri_28_ VSS n2 VDD_1V8 input_x[28] output_x[28] BTHHDLLX2
Xoutput_x_tri_8_ VSS n2 VDD_1V8 input_x[8] output_x[8] BTHHDLLX2
Xoutput_x_tri_31_ VSS n2 VDD_1V8 input_x[31] output_x[31] BTHHDLLX2
Xoutput_x_tri_29_ VSS n2 VDD_1V8 input_x[29] output_x[29] BTHHDLLX2
Xoutput_x_tri_27_ VSS n2 VDD_1V8 input_x[27] output_x[27] BTHHDLLX2
Xoutput_x_tri_25_ VSS n2 VDD_1V8 input_x[25] output_x[25] BTHHDLLX2
Xoutput_x_tri_24_ VSS n2 VDD_1V8 input_x[24] output_x[24] BTHHDLLX2
Xoutput_x_tri_22_ VSS n2 VDD_1V8 input_x[22] output_x[22] BTHHDLLX2
Xoutput_x_tri_20_ VSS n2 VDD_1V8 input_x[20] output_x[20] BTHHDLLX2
Xoutput_x_tri_18_ VSS n2 VDD_1V8 input_x[18] output_x[18] BTHHDLLX2
Xoutput_x_tri_3_ VSS n2 VDD_1V8 input_x[3] output_x[3] BTHHDLLX2
Xoutput_x_tri_0_ VSS n2 VDD_1V8 input_x[0] output_x[0] BTHHDLLX2
Xoutput_x_tri_30_ VSS n2 VDD_1V8 input_x[30] output_x[30] BTHHDLLX2
Xoutput_x_tri_26_ VSS n2 VDD_1V8 input_x[26] output_x[26] BTHHDLLX2
Xoutput_x_tri_23_ VSS n2 VDD_1V8 input_x[23] output_x[23] BTHHDLLX2
Xoutput_x_tri_21_ VSS n2 VDD_1V8 input_x[21] output_x[21] BTHHDLLX2
Xoutput_x_tri_19_ VSS n2 VDD_1V8 input_x[19] output_x[19] BTHHDLLX2
Xoutput_x_tri_17_ VSS n2 VDD_1V8 input_x[17] output_x[17] BTHHDLLX2
Xoutput_x_tri_16_ VSS n2 VDD_1V8 input_x[16] output_x[16] BTHHDLLX2
Xoutput_x_tri_15_ VSS n2 VDD_1V8 input_x[15] output_x[15] BTHHDLLX2
Xoutput_x_tri_14_ VSS n2 VDD_1V8 input_x[14] output_x[14] BTHHDLLX2
Xoutput_x_tri_13_ VSS n2 VDD_1V8 input_x[13] output_x[13] BTHHDLLX2
Xoutput_x_tri_11_ VSS n2 VDD_1V8 input_x[11] output_x[11] BTHHDLLX2
Xoutput_x_tri_10_ VSS n2 VDD_1V8 input_x[10] output_x[10] BTHHDLLX2
Xoutput_x_tri_9_ VSS n2 VDD_1V8 input_x[9] output_x[9] BTHHDLLX2
Xoutput_x_tri_7_ VSS n2 VDD_1V8 input_x[7] output_x[7] BTHHDLLX2
Xoutput_x_tri_6_ VSS n2 VDD_1V8 input_x[6] output_x[6] BTHHDLLX2
Xoutput_x_tri_5_ VSS n2 VDD_1V8 input_x[5] output_x[5] BTHHDLLX2
.ENDS

.SUBCKT tristate_buffer_6 input_x[31] input_x[30] input_x[29] input_x[28] input_x[27]
+ input_x[26] input_x[25] input_x[24] input_x[23] input_x[22] input_x[21] input_x[20]
+ input_x[19] input_x[18] input_x[17] input_x[16] input_x[15] input_x[14] input_x[13]
+ input_x[12] input_x[11] input_x[10] input_x[9] input_x[8] input_x[7] input_x[6]
+ input_x[5] input_x[4] input_x[3] input_x[2] input_x[1] input_x[0] enable output_x[31]
+ output_x[30] output_x[29] output_x[28] output_x[27] output_x[26] output_x[25]
+ output_x[24] output_x[23] output_x[22] output_x[21] output_x[20] output_x[19]
+ output_x[18] output_x[17] output_x[16] output_x[15] output_x[14] output_x[13]
+ output_x[12] output_x[11] output_x[10] output_x[9] output_x[8] output_x[7] output_x[6]
+ output_x[5] output_x[4] output_x[3] output_x[2] output_x[1] output_x[0] VSS VDD_1V8
Xplace1 n2 VSS VDD_1V8 enable INHDLLX1
Xoutput_x_tri_12_ VSS n2 VDD_1V8 input_x[12] output_x[12] BTHHDLLX2
Xoutput_x_tri_28_ VSS n2 VDD_1V8 input_x[28] output_x[28] BTHHDLLX2
Xoutput_x_tri_8_ VSS n2 VDD_1V8 input_x[8] output_x[8] BTHHDLLX2
Xoutput_x_tri_31_ VSS n2 VDD_1V8 input_x[31] output_x[31] BTHHDLLX2
Xoutput_x_tri_29_ VSS n2 VDD_1V8 input_x[29] output_x[29] BTHHDLLX2
Xoutput_x_tri_27_ VSS n2 VDD_1V8 input_x[27] output_x[27] BTHHDLLX2
Xoutput_x_tri_25_ VSS n2 VDD_1V8 input_x[25] output_x[25] BTHHDLLX2
Xoutput_x_tri_24_ VSS n2 VDD_1V8 input_x[24] output_x[24] BTHHDLLX2
Xoutput_x_tri_22_ VSS n2 VDD_1V8 input_x[22] output_x[22] BTHHDLLX2
Xoutput_x_tri_20_ VSS n2 VDD_1V8 input_x[20] output_x[20] BTHHDLLX2
Xoutput_x_tri_18_ VSS n2 VDD_1V8 input_x[18] output_x[18] BTHHDLLX2
Xoutput_x_tri_3_ VSS n2 VDD_1V8 input_x[3] output_x[3] BTHHDLLX2
Xoutput_x_tri_0_ VSS n2 VDD_1V8 input_x[0] output_x[0] BTHHDLLX2
Xoutput_x_tri_30_ VSS n2 VDD_1V8 input_x[30] output_x[30] BTHHDLLX2
Xoutput_x_tri_26_ VSS n2 VDD_1V8 input_x[26] output_x[26] BTHHDLLX2
Xoutput_x_tri_23_ VSS n2 VDD_1V8 input_x[23] output_x[23] BTHHDLLX2
Xoutput_x_tri_21_ VSS n2 VDD_1V8 input_x[21] output_x[21] BTHHDLLX2
Xoutput_x_tri_19_ VSS n2 VDD_1V8 input_x[19] output_x[19] BTHHDLLX2
Xoutput_x_tri_17_ VSS n2 VDD_1V8 input_x[17] output_x[17] BTHHDLLX2
Xoutput_x_tri_16_ VSS n2 VDD_1V8 input_x[16] output_x[16] BTHHDLLX2
Xoutput_x_tri_15_ VSS n2 VDD_1V8 input_x[15] output_x[15] BTHHDLLX2
Xoutput_x_tri_14_ VSS n2 VDD_1V8 input_x[14] output_x[14] BTHHDLLX2
Xoutput_x_tri_13_ VSS n2 VDD_1V8 input_x[13] output_x[13] BTHHDLLX2
Xoutput_x_tri_11_ VSS n2 VDD_1V8 input_x[11] output_x[11] BTHHDLLX2
Xoutput_x_tri_10_ VSS n2 VDD_1V8 input_x[10] output_x[10] BTHHDLLX2
Xoutput_x_tri_9_ VSS n2 VDD_1V8 input_x[9] output_x[9] BTHHDLLX2
Xoutput_x_tri_7_ VSS n2 VDD_1V8 input_x[7] output_x[7] BTHHDLLX2
Xoutput_x_tri_6_ VSS n2 VDD_1V8 input_x[6] output_x[6] BTHHDLLX2
Xoutput_x_tri_5_ VSS n2 VDD_1V8 input_x[5] output_x[5] BTHHDLLX2
Xoutput_x_tri_4_ VSS n2 VDD_1V8 input_x[4] output_x[4] BTHHDLLX2
Xoutput_x_tri_2_ VSS n2 VDD_1V8 input_x[2] output_x[2] BTHHDLLX2
Xoutput_x_tri_1_ VSS n2 VDD_1V8 input_x[1] output_x[1] BTHHDLLX2
.ENDS

.SUBCKT tristate_buffer_5 input_x[31] input_x[30] input_x[29] input_x[28] input_x[27]
+ input_x[26] input_x[25] input_x[24] input_x[23] input_x[22] input_x[21] input_x[20]
+ input_x[19] input_x[18] input_x[17] input_x[16] input_x[15] input_x[14] input_x[13]
+ input_x[12] input_x[11] input_x[10] input_x[9] input_x[8] input_x[7] input_x[6]
+ input_x[5] input_x[4] input_x[3] input_x[2] input_x[1] input_x[0] enable output_x[31]
+ output_x[30] output_x[29] output_x[28] output_x[27] output_x[26] output_x[25]
+ output_x[24] output_x[23] output_x[22] output_x[21] output_x[20] output_x[19]
+ output_x[18] output_x[17] output_x[16] output_x[15] output_x[14] output_x[13]
+ output_x[12] output_x[11] output_x[10] output_x[9] output_x[8] output_x[7] output_x[6]
+ output_x[5] output_x[4] output_x[3] output_x[2] output_x[1] output_x[0] VSS VDD_1V8
Xoutput_x_tri_28_ VSS enable VDD_1V8 input_x[28] output_x[28] BTHHDLLX2
Xoutput_x_tri_8_ VSS enable VDD_1V8 input_x[8] output_x[8] BTHHDLLX2
Xoutput_x_tri_31_ VSS enable VDD_1V8 input_x[31] output_x[31] BTHHDLLX2
Xoutput_x_tri_29_ VSS enable VDD_1V8 input_x[29] output_x[29] BTHHDLLX2
Xoutput_x_tri_27_ VSS enable VDD_1V8 input_x[27] output_x[27] BTHHDLLX2
Xoutput_x_tri_25_ VSS enable VDD_1V8 input_x[25] output_x[25] BTHHDLLX2
Xoutput_x_tri_24_ VSS enable VDD_1V8 input_x[24] output_x[24] BTHHDLLX2
Xoutput_x_tri_22_ VSS enable VDD_1V8 input_x[22] output_x[22] BTHHDLLX2
Xoutput_x_tri_20_ VSS enable VDD_1V8 input_x[20] output_x[20] BTHHDLLX2
Xoutput_x_tri_18_ VSS enable VDD_1V8 input_x[18] output_x[18] BTHHDLLX2
Xoutput_x_tri_3_ VSS enable VDD_1V8 input_x[3] output_x[3] BTHHDLLX2
Xoutput_x_tri_0_ VSS enable VDD_1V8 input_x[0] output_x[0] BTHHDLLX2
Xoutput_x_tri_30_ VSS enable VDD_1V8 input_x[30] output_x[30] BTHHDLLX2
Xoutput_x_tri_26_ VSS enable VDD_1V8 input_x[26] output_x[26] BTHHDLLX2
Xoutput_x_tri_23_ VSS enable VDD_1V8 input_x[23] output_x[23] BTHHDLLX2
Xoutput_x_tri_21_ VSS enable VDD_1V8 input_x[21] output_x[21] BTHHDLLX2
Xoutput_x_tri_19_ VSS enable VDD_1V8 input_x[19] output_x[19] BTHHDLLX2
Xoutput_x_tri_17_ VSS enable VDD_1V8 input_x[17] output_x[17] BTHHDLLX2
Xoutput_x_tri_16_ VSS enable VDD_1V8 input_x[16] output_x[16] BTHHDLLX2
Xoutput_x_tri_15_ VSS enable VDD_1V8 input_x[15] output_x[15] BTHHDLLX2
Xoutput_x_tri_14_ VSS enable VDD_1V8 input_x[14] output_x[14] BTHHDLLX2
Xoutput_x_tri_13_ VSS enable VDD_1V8 input_x[13] output_x[13] BTHHDLLX2
Xoutput_x_tri_12_ VSS enable VDD_1V8 input_x[12] output_x[12] BTHHDLLX2
Xoutput_x_tri_11_ VSS enable VDD_1V8 input_x[11] output_x[11] BTHHDLLX2
Xoutput_x_tri_10_ VSS enable VDD_1V8 input_x[10] output_x[10] BTHHDLLX2
Xoutput_x_tri_9_ VSS enable VDD_1V8 input_x[9] output_x[9] BTHHDLLX2
Xoutput_x_tri_7_ VSS enable VDD_1V8 input_x[7] output_x[7] BTHHDLLX2
Xoutput_x_tri_6_ VSS enable VDD_1V8 input_x[6] output_x[6] BTHHDLLX2
Xoutput_x_tri_5_ VSS enable VDD_1V8 input_x[5] output_x[5] BTHHDLLX2
Xoutput_x_tri_4_ VSS enable VDD_1V8 input_x[4] output_x[4] BTHHDLLX2
Xoutput_x_tri_2_ VSS enable VDD_1V8 input_x[2] output_x[2] BTHHDLLX2
Xoutput_x_tri_1_ VSS enable VDD_1V8 input_x[1] output_x[1] BTHHDLLX2
.ENDS

.SUBCKT tristate_buffer_4 input_x[31] input_x[30] input_x[29] input_x[28] input_x[27]
+ input_x[26] input_x[25] input_x[24] input_x[23] input_x[22] input_x[21] input_x[20]
+ input_x[19] input_x[18] input_x[17] input_x[16] input_x[15] input_x[14] input_x[13]
+ input_x[12] input_x[11] input_x[10] input_x[9] input_x[8] input_x[7] input_x[6]
+ input_x[5] input_x[4] input_x[3] input_x[2] input_x[1] input_x[0] enable output_x[31]
+ output_x[30] output_x[29] output_x[28] output_x[27] output_x[26] output_x[25]
+ output_x[24] output_x[23] output_x[22] output_x[21] output_x[20] output_x[19]
+ output_x[18] output_x[17] output_x[16] output_x[15] output_x[14] output_x[13]
+ output_x[12] output_x[11] output_x[10] output_x[9] output_x[8] output_x[7] output_x[6]
+ output_x[5] output_x[4] output_x[3] output_x[2] output_x[1] output_x[0] VSS VDD_1V8
Xoutput_x_tri_28_ VSS enable VDD_1V8 input_x[28] output_x[28] BTHHDLLX2
Xoutput_x_tri_8_ VSS enable VDD_1V8 input_x[8] output_x[8] BTHHDLLX2
Xoutput_x_tri_31_ VSS enable VDD_1V8 input_x[31] output_x[31] BTHHDLLX2
Xoutput_x_tri_29_ VSS enable VDD_1V8 input_x[29] output_x[29] BTHHDLLX2
Xoutput_x_tri_27_ VSS enable VDD_1V8 input_x[27] output_x[27] BTHHDLLX2
Xoutput_x_tri_25_ VSS enable VDD_1V8 input_x[25] output_x[25] BTHHDLLX2
Xoutput_x_tri_24_ VSS enable VDD_1V8 input_x[24] output_x[24] BTHHDLLX2
Xoutput_x_tri_22_ VSS enable VDD_1V8 input_x[22] output_x[22] BTHHDLLX2
Xoutput_x_tri_20_ VSS enable VDD_1V8 input_x[20] output_x[20] BTHHDLLX2
Xoutput_x_tri_18_ VSS enable VDD_1V8 input_x[18] output_x[18] BTHHDLLX2
Xoutput_x_tri_3_ VSS enable VDD_1V8 input_x[3] output_x[3] BTHHDLLX2
Xoutput_x_tri_0_ VSS enable VDD_1V8 input_x[0] output_x[0] BTHHDLLX2
Xoutput_x_tri_30_ VSS enable VDD_1V8 input_x[30] output_x[30] BTHHDLLX2
Xoutput_x_tri_26_ VSS enable VDD_1V8 input_x[26] output_x[26] BTHHDLLX2
Xoutput_x_tri_23_ VSS enable VDD_1V8 input_x[23] output_x[23] BTHHDLLX2
Xoutput_x_tri_21_ VSS enable VDD_1V8 input_x[21] output_x[21] BTHHDLLX2
Xoutput_x_tri_19_ VSS enable VDD_1V8 input_x[19] output_x[19] BTHHDLLX2
Xoutput_x_tri_17_ VSS enable VDD_1V8 input_x[17] output_x[17] BTHHDLLX2
Xoutput_x_tri_16_ VSS enable VDD_1V8 input_x[16] output_x[16] BTHHDLLX2
Xoutput_x_tri_15_ VSS enable VDD_1V8 input_x[15] output_x[15] BTHHDLLX2
Xoutput_x_tri_14_ VSS enable VDD_1V8 input_x[14] output_x[14] BTHHDLLX2
Xoutput_x_tri_13_ VSS enable VDD_1V8 input_x[13] output_x[13] BTHHDLLX2
Xoutput_x_tri_12_ VSS enable VDD_1V8 input_x[12] output_x[12] BTHHDLLX2
Xoutput_x_tri_11_ VSS enable VDD_1V8 input_x[11] output_x[11] BTHHDLLX2
Xoutput_x_tri_10_ VSS enable VDD_1V8 input_x[10] output_x[10] BTHHDLLX2
Xoutput_x_tri_9_ VSS enable VDD_1V8 input_x[9] output_x[9] BTHHDLLX2
Xoutput_x_tri_7_ VSS enable VDD_1V8 input_x[7] output_x[7] BTHHDLLX2
Xoutput_x_tri_6_ VSS enable VDD_1V8 input_x[6] output_x[6] BTHHDLLX2
Xoutput_x_tri_5_ VSS enable VDD_1V8 input_x[5] output_x[5] BTHHDLLX2
Xoutput_x_tri_4_ VSS enable VDD_1V8 input_x[4] output_x[4] BTHHDLLX2
Xoutput_x_tri_2_ VSS enable VDD_1V8 input_x[2] output_x[2] BTHHDLLX2
Xoutput_x_tri_1_ VSS enable VDD_1V8 input_x[1] output_x[1] BTHHDLLX2
.ENDS

.SUBCKT tristate_buffer_3 input_x[31] input_x[30] input_x[29] input_x[28] input_x[27]
+ input_x[26] input_x[25] input_x[24] input_x[23] input_x[22] input_x[21] input_x[20]
+ input_x[19] input_x[18] input_x[17] input_x[16] input_x[15] input_x[14] input_x[13]
+ input_x[12] input_x[11] input_x[10] input_x[9] input_x[8] input_x[7] input_x[6]
+ input_x[5] input_x[4] input_x[3] input_x[2] input_x[1] input_x[0] enable output_x[31]
+ output_x[30] output_x[29] output_x[28] output_x[27] output_x[26] output_x[25]
+ output_x[24] output_x[23] output_x[22] output_x[21] output_x[20] output_x[19]
+ output_x[18] output_x[17] output_x[16] output_x[15] output_x[14] output_x[13]
+ output_x[12] output_x[11] output_x[10] output_x[9] output_x[8] output_x[7] output_x[6]
+ output_x[5] output_x[4] output_x[3] output_x[2] output_x[1] output_x[0] VSS VDD_1V8
Xoutput_x_tri_28_ VSS enable VDD_1V8 input_x[28] output_x[28] BTHHDLLX2
Xoutput_x_tri_8_ VSS enable VDD_1V8 input_x[8] output_x[8] BTHHDLLX2
Xoutput_x_tri_31_ VSS enable VDD_1V8 input_x[31] output_x[31] BTHHDLLX2
Xoutput_x_tri_29_ VSS enable VDD_1V8 input_x[29] output_x[29] BTHHDLLX2
Xoutput_x_tri_27_ VSS enable VDD_1V8 input_x[27] output_x[27] BTHHDLLX2
Xoutput_x_tri_25_ VSS enable VDD_1V8 input_x[25] output_x[25] BTHHDLLX2
Xoutput_x_tri_24_ VSS enable VDD_1V8 input_x[24] output_x[24] BTHHDLLX2
Xoutput_x_tri_22_ VSS enable VDD_1V8 input_x[22] output_x[22] BTHHDLLX2
Xoutput_x_tri_20_ VSS enable VDD_1V8 input_x[20] output_x[20] BTHHDLLX2
Xoutput_x_tri_18_ VSS enable VDD_1V8 input_x[18] output_x[18] BTHHDLLX2
Xoutput_x_tri_3_ VSS enable VDD_1V8 input_x[3] output_x[3] BTHHDLLX2
Xoutput_x_tri_0_ VSS enable VDD_1V8 input_x[0] output_x[0] BTHHDLLX2
Xoutput_x_tri_30_ VSS enable VDD_1V8 input_x[30] output_x[30] BTHHDLLX2
Xoutput_x_tri_26_ VSS enable VDD_1V8 input_x[26] output_x[26] BTHHDLLX2
Xoutput_x_tri_23_ VSS enable VDD_1V8 input_x[23] output_x[23] BTHHDLLX2
Xoutput_x_tri_21_ VSS enable VDD_1V8 input_x[21] output_x[21] BTHHDLLX2
Xoutput_x_tri_19_ VSS enable VDD_1V8 input_x[19] output_x[19] BTHHDLLX2
Xoutput_x_tri_17_ VSS enable VDD_1V8 input_x[17] output_x[17] BTHHDLLX2
Xoutput_x_tri_16_ VSS enable VDD_1V8 input_x[16] output_x[16] BTHHDLLX2
Xoutput_x_tri_15_ VSS enable VDD_1V8 input_x[15] output_x[15] BTHHDLLX2
Xoutput_x_tri_14_ VSS enable VDD_1V8 input_x[14] output_x[14] BTHHDLLX2
Xoutput_x_tri_13_ VSS enable VDD_1V8 input_x[13] output_x[13] BTHHDLLX2
Xoutput_x_tri_12_ VSS enable VDD_1V8 input_x[12] output_x[12] BTHHDLLX2
Xoutput_x_tri_11_ VSS enable VDD_1V8 input_x[11] output_x[11] BTHHDLLX2
Xoutput_x_tri_10_ VSS enable VDD_1V8 input_x[10] output_x[10] BTHHDLLX2
Xoutput_x_tri_9_ VSS enable VDD_1V8 input_x[9] output_x[9] BTHHDLLX2
Xoutput_x_tri_7_ VSS enable VDD_1V8 input_x[7] output_x[7] BTHHDLLX2
Xoutput_x_tri_6_ VSS enable VDD_1V8 input_x[6] output_x[6] BTHHDLLX2
Xoutput_x_tri_5_ VSS enable VDD_1V8 input_x[5] output_x[5] BTHHDLLX2
Xoutput_x_tri_4_ VSS enable VDD_1V8 input_x[4] output_x[4] BTHHDLLX2
Xoutput_x_tri_2_ VSS enable VDD_1V8 input_x[2] output_x[2] BTHHDLLX2
Xoutput_x_tri_1_ VSS enable VDD_1V8 input_x[1] output_x[1] BTHHDLLX2
.ENDS

.SUBCKT tristate_buffer_2 input_x[31] input_x[30] input_x[29] input_x[28] input_x[27]
+ input_x[26] input_x[25] input_x[24] input_x[23] input_x[22] input_x[21] input_x[20]
+ input_x[19] input_x[18] input_x[17] input_x[16] input_x[15] input_x[14] input_x[13]
+ input_x[12] input_x[11] input_x[10] input_x[9] input_x[8] input_x[7] input_x[6]
+ input_x[5] input_x[4] input_x[3] input_x[2] input_x[1] input_x[0] enable output_x[31]
+ output_x[30] output_x[29] output_x[28] output_x[27] output_x[26] output_x[25]
+ output_x[24] output_x[23] output_x[22] output_x[21] output_x[20] output_x[19]
+ output_x[18] output_x[17] output_x[16] output_x[15] output_x[14] output_x[13]
+ output_x[12] output_x[11] output_x[10] output_x[9] output_x[8] output_x[7] output_x[6]
+ output_x[5] output_x[4] output_x[3] output_x[2] output_x[1] output_x[0] VSS VDD_1V8
Xoutput_x_tri_31_ VSS enable VDD_1V8 input_x[31] output_x[31] BTHHDLLX2
Xoutput_x_tri_29_ VSS enable VDD_1V8 input_x[29] output_x[29] BTHHDLLX2
Xoutput_x_tri_27_ VSS enable VDD_1V8 input_x[27] output_x[27] BTHHDLLX2
Xoutput_x_tri_25_ VSS enable VDD_1V8 input_x[25] output_x[25] BTHHDLLX2
Xoutput_x_tri_24_ VSS enable VDD_1V8 input_x[24] output_x[24] BTHHDLLX2
Xoutput_x_tri_22_ VSS enable VDD_1V8 input_x[22] output_x[22] BTHHDLLX2
Xoutput_x_tri_20_ VSS enable VDD_1V8 input_x[20] output_x[20] BTHHDLLX2
Xoutput_x_tri_18_ VSS enable VDD_1V8 input_x[18] output_x[18] BTHHDLLX2
Xoutput_x_tri_3_ VSS enable VDD_1V8 input_x[3] output_x[3] BTHHDLLX2
Xoutput_x_tri_0_ VSS enable VDD_1V8 input_x[0] output_x[0] BTHHDLLX2
Xoutput_x_tri_30_ VSS enable VDD_1V8 input_x[30] output_x[30] BTHHDLLX2
Xoutput_x_tri_26_ VSS enable VDD_1V8 input_x[26] output_x[26] BTHHDLLX2
Xoutput_x_tri_23_ VSS enable VDD_1V8 input_x[23] output_x[23] BTHHDLLX2
Xoutput_x_tri_21_ VSS enable VDD_1V8 input_x[21] output_x[21] BTHHDLLX2
Xoutput_x_tri_19_ VSS enable VDD_1V8 input_x[19] output_x[19] BTHHDLLX2
Xoutput_x_tri_17_ VSS enable VDD_1V8 input_x[17] output_x[17] BTHHDLLX2
Xoutput_x_tri_16_ VSS enable VDD_1V8 input_x[16] output_x[16] BTHHDLLX2
Xoutput_x_tri_15_ VSS enable VDD_1V8 input_x[15] output_x[15] BTHHDLLX2
Xoutput_x_tri_14_ VSS enable VDD_1V8 input_x[14] output_x[14] BTHHDLLX2
Xoutput_x_tri_13_ VSS enable VDD_1V8 input_x[13] output_x[13] BTHHDLLX2
Xoutput_x_tri_12_ VSS enable VDD_1V8 input_x[12] output_x[12] BTHHDLLX2
Xoutput_x_tri_11_ VSS enable VDD_1V8 input_x[11] output_x[11] BTHHDLLX2
Xoutput_x_tri_10_ VSS enable VDD_1V8 input_x[10] output_x[10] BTHHDLLX2
Xoutput_x_tri_9_ VSS enable VDD_1V8 input_x[9] output_x[9] BTHHDLLX2
Xoutput_x_tri_7_ VSS enable VDD_1V8 input_x[7] output_x[7] BTHHDLLX2
Xoutput_x_tri_6_ VSS enable VDD_1V8 input_x[6] output_x[6] BTHHDLLX2
Xoutput_x_tri_5_ VSS enable VDD_1V8 input_x[5] output_x[5] BTHHDLLX2
Xoutput_x_tri_4_ VSS enable VDD_1V8 input_x[4] output_x[4] BTHHDLLX2
Xoutput_x_tri_2_ VSS enable VDD_1V8 input_x[2] output_x[2] BTHHDLLX2
Xoutput_x_tri_1_ VSS enable VDD_1V8 input_x[1] output_x[1] BTHHDLLX2
Xoutput_x_tri_28_ VSS enable VDD_1V8 input_x[28] output_x[28] BTHHDLLX2
Xoutput_x_tri_8_ VSS enable VDD_1V8 input_x[8] output_x[8] BTHHDLLX2
.ENDS

.SUBCKT tristate_buffer_1 input_x[31] input_x[30] input_x[29] input_x[28] input_x[27]
+ input_x[26] input_x[25] input_x[24] input_x[23] input_x[22] input_x[21] input_x[20]
+ input_x[19] input_x[18] input_x[17] input_x[16] input_x[15] input_x[14] input_x[13]
+ input_x[12] input_x[11] input_x[10] input_x[9] input_x[8] input_x[7] input_x[6]
+ input_x[5] input_x[4] input_x[3] input_x[2] input_x[1] input_x[0] enable output_x[31]
+ output_x[30] output_x[29] output_x[28] output_x[27] output_x[26] output_x[25]
+ output_x[24] output_x[23] output_x[22] output_x[21] output_x[20] output_x[19]
+ output_x[18] output_x[17] output_x[16] output_x[15] output_x[14] output_x[13]
+ output_x[12] output_x[11] output_x[10] output_x[9] output_x[8] output_x[7] output_x[6]
+ output_x[5] output_x[4] output_x[3] output_x[2] output_x[1] output_x[0] VSS VDD_1V8
Xoutput_x_tri_28_ VSS enable VDD_1V8 input_x[28] output_x[28] BTHHDLLX2
Xoutput_x_tri_8_ VSS enable VDD_1V8 input_x[8] output_x[8] BTHHDLLX2
Xoutput_x_tri_31_ VSS enable VDD_1V8 input_x[31] output_x[31] BTHHDLLX2
Xoutput_x_tri_29_ VSS enable VDD_1V8 input_x[29] output_x[29] BTHHDLLX2
Xoutput_x_tri_27_ VSS enable VDD_1V8 input_x[27] output_x[27] BTHHDLLX2
Xoutput_x_tri_25_ VSS enable VDD_1V8 input_x[25] output_x[25] BTHHDLLX2
Xoutput_x_tri_24_ VSS enable VDD_1V8 input_x[24] output_x[24] BTHHDLLX2
Xoutput_x_tri_22_ VSS enable VDD_1V8 input_x[22] output_x[22] BTHHDLLX2
Xoutput_x_tri_20_ VSS enable VDD_1V8 input_x[20] output_x[20] BTHHDLLX2
Xoutput_x_tri_18_ VSS enable VDD_1V8 input_x[18] output_x[18] BTHHDLLX2
Xoutput_x_tri_3_ VSS enable VDD_1V8 input_x[3] output_x[3] BTHHDLLX2
Xoutput_x_tri_0_ VSS enable VDD_1V8 input_x[0] output_x[0] BTHHDLLX2
Xoutput_x_tri_30_ VSS enable VDD_1V8 input_x[30] output_x[30] BTHHDLLX2
Xoutput_x_tri_26_ VSS enable VDD_1V8 input_x[26] output_x[26] BTHHDLLX2
Xoutput_x_tri_23_ VSS enable VDD_1V8 input_x[23] output_x[23] BTHHDLLX2
Xoutput_x_tri_21_ VSS enable VDD_1V8 input_x[21] output_x[21] BTHHDLLX2
Xoutput_x_tri_19_ VSS enable VDD_1V8 input_x[19] output_x[19] BTHHDLLX2
Xoutput_x_tri_17_ VSS enable VDD_1V8 input_x[17] output_x[17] BTHHDLLX2
Xoutput_x_tri_16_ VSS enable VDD_1V8 input_x[16] output_x[16] BTHHDLLX2
Xoutput_x_tri_15_ VSS enable VDD_1V8 input_x[15] output_x[15] BTHHDLLX2
Xoutput_x_tri_14_ VSS enable VDD_1V8 input_x[14] output_x[14] BTHHDLLX2
Xoutput_x_tri_13_ VSS enable VDD_1V8 input_x[13] output_x[13] BTHHDLLX2
Xoutput_x_tri_12_ VSS enable VDD_1V8 input_x[12] output_x[12] BTHHDLLX2
Xoutput_x_tri_11_ VSS enable VDD_1V8 input_x[11] output_x[11] BTHHDLLX2
Xoutput_x_tri_10_ VSS enable VDD_1V8 input_x[10] output_x[10] BTHHDLLX2
Xoutput_x_tri_9_ VSS enable VDD_1V8 input_x[9] output_x[9] BTHHDLLX2
Xoutput_x_tri_7_ VSS enable VDD_1V8 input_x[7] output_x[7] BTHHDLLX2
Xoutput_x_tri_6_ VSS enable VDD_1V8 input_x[6] output_x[6] BTHHDLLX2
Xoutput_x_tri_5_ VSS enable VDD_1V8 input_x[5] output_x[5] BTHHDLLX2
Xoutput_x_tri_4_ VSS enable VDD_1V8 input_x[4] output_x[4] BTHHDLLX2
Xoutput_x_tri_2_ VSS enable VDD_1V8 input_x[2] output_x[2] BTHHDLLX2
Xoutput_x_tri_1_ VSS enable VDD_1V8 input_x[1] output_x[1] BTHHDLLX2
.ENDS

.SUBCKT tristate_buffer_0 input_x[31] input_x[30] input_x[29] input_x[28] input_x[27]
+ input_x[26] input_x[25] input_x[24] input_x[23] input_x[22] input_x[21] input_x[20]
+ input_x[19] input_x[18] input_x[17] input_x[16] input_x[15] input_x[14] input_x[13]
+ input_x[12] input_x[11] input_x[10] input_x[9] input_x[8] input_x[7] input_x[6]
+ input_x[5] input_x[4] input_x[3] input_x[2] input_x[1] input_x[0] enable output_x[31]
+ output_x[30] output_x[29] output_x[28] output_x[27] output_x[26] output_x[25]
+ output_x[24] output_x[23] output_x[22] output_x[21] output_x[20] output_x[19]
+ output_x[18] output_x[17] output_x[16] output_x[15] output_x[14] output_x[13]
+ output_x[12] output_x[11] output_x[10] output_x[9] output_x[8] output_x[7] output_x[6]
+ output_x[5] output_x[4] output_x[3] output_x[2] output_x[1] output_x[0] VSS VDD_1V8
Xoutput_x_tri_31_ VSS enable VDD_1V8 input_x[31] output_x[31] BTHHDLLX2
Xoutput_x_tri_29_ VSS enable VDD_1V8 input_x[29] output_x[29] BTHHDLLX2
Xoutput_x_tri_27_ VSS enable VDD_1V8 input_x[27] output_x[27] BTHHDLLX2
Xoutput_x_tri_25_ VSS enable VDD_1V8 input_x[25] output_x[25] BTHHDLLX2
Xoutput_x_tri_24_ VSS enable VDD_1V8 input_x[24] output_x[24] BTHHDLLX2
Xoutput_x_tri_22_ VSS enable VDD_1V8 input_x[22] output_x[22] BTHHDLLX2
Xoutput_x_tri_20_ VSS enable VDD_1V8 input_x[20] output_x[20] BTHHDLLX2
Xoutput_x_tri_18_ VSS enable VDD_1V8 input_x[18] output_x[18] BTHHDLLX2
Xoutput_x_tri_3_ VSS enable VDD_1V8 input_x[3] output_x[3] BTHHDLLX2
Xoutput_x_tri_0_ VSS enable VDD_1V8 input_x[0] output_x[0] BTHHDLLX2
Xoutput_x_tri_30_ VSS enable VDD_1V8 input_x[30] output_x[30] BTHHDLLX2
Xoutput_x_tri_26_ VSS enable VDD_1V8 input_x[26] output_x[26] BTHHDLLX2
Xoutput_x_tri_23_ VSS enable VDD_1V8 input_x[23] output_x[23] BTHHDLLX2
Xoutput_x_tri_21_ VSS enable VDD_1V8 input_x[21] output_x[21] BTHHDLLX2
Xoutput_x_tri_19_ VSS enable VDD_1V8 input_x[19] output_x[19] BTHHDLLX2
Xoutput_x_tri_17_ VSS enable VDD_1V8 input_x[17] output_x[17] BTHHDLLX2
Xoutput_x_tri_16_ VSS enable VDD_1V8 input_x[16] output_x[16] BTHHDLLX2
Xoutput_x_tri_15_ VSS enable VDD_1V8 input_x[15] output_x[15] BTHHDLLX2
Xoutput_x_tri_14_ VSS enable VDD_1V8 input_x[14] output_x[14] BTHHDLLX2
Xoutput_x_tri_13_ VSS enable VDD_1V8 input_x[13] output_x[13] BTHHDLLX2
Xoutput_x_tri_12_ VSS enable VDD_1V8 input_x[12] output_x[12] BTHHDLLX2
Xoutput_x_tri_11_ VSS enable VDD_1V8 input_x[11] output_x[11] BTHHDLLX2
Xoutput_x_tri_10_ VSS enable VDD_1V8 input_x[10] output_x[10] BTHHDLLX2
Xoutput_x_tri_9_ VSS enable VDD_1V8 input_x[9] output_x[9] BTHHDLLX2
Xoutput_x_tri_7_ VSS enable VDD_1V8 input_x[7] output_x[7] BTHHDLLX2
Xoutput_x_tri_6_ VSS enable VDD_1V8 input_x[6] output_x[6] BTHHDLLX2
Xoutput_x_tri_5_ VSS enable VDD_1V8 input_x[5] output_x[5] BTHHDLLX2
Xoutput_x_tri_4_ VSS enable VDD_1V8 input_x[4] output_x[4] BTHHDLLX2
Xoutput_x_tri_2_ VSS enable VDD_1V8 input_x[2] output_x[2] BTHHDLLX2
Xoutput_x_tri_1_ VSS enable VDD_1V8 input_x[1] output_x[1] BTHHDLLX2
Xoutput_x_tri_28_ VSS enable VDD_1V8 input_x[28] output_x[28] BTHHDLLX2
Xoutput_x_tri_8_ VSS enable VDD_1V8 input_x[8] output_x[8] BTHHDLLX2
.ENDS

.SUBCKT Decodificador_width32_2 addres_in[4] addres_in[3] addres_in[2] addres_in[1]
+ addres_in[0] out[31] out[30] out[29] out[28] out[27] out[26] out[25] out[24] out[23]
+ out[22] out[21] out[20] out[19] out[18] out[17] out[16] out[15] out[14] out[13]
+ out[12] out[11] out[10] out[9] out[8] out[7] out[6] out[5] out[4] out[3] out[2]
+ out[1] out[0] VSS VDD_1V8
XU43 VSS out[31] n14 n11 VDD_1V8 NO2HDLLX0
XU51 VSS out[25] n17 n16 VDD_1V8 NO2HDLLX0
XU50 VSS out[26] n15 n16 VDD_1V8 NO2HDLLX0
XU49 VSS out[27] n14 n16 VDD_1V8 NO2HDLLX0
XU48 VSS out[24] n13 n16 VDD_1V8 NO2HDLLX2
XU46 VSS out[30] n15 n11 VDD_1V8 NO2HDLLX0
XU45 VSS out[23] n14 n10 VDD_1V8 NO2HDLLX0
XU44 VSS out[29] n17 n11 VDD_1V8 NO2HDLLX0
XU42 VSS out[28] n13 n11 VDD_1V8 NO2HDLLX2
XU40 VSS out[9] n9 n17 VDD_1V8 NO2HDLLX0
XU39 VSS out[8] n9 n13 VDD_1V8 NO2HDLLX0
XU38 VSS out[7] n14 n8 VDD_1V8 NO2HDLLX0
XU37 VSS out[6] n8 n15 VDD_1V8 NO2HDLLX0
XU36 VSS out[12] n13 n7 VDD_1V8 NO2HDLLX4
XU35 VSS out[11] n9 n14 VDD_1V8 NO2HDLLX0
XU34 VSS out[10] n9 n15 VDD_1V8 NO2HDLLX0
XU32 VSS out[3] n14 n5 VDD_1V8 NO2HDLLX0
XU31 VSS out[2] n15 n5 VDD_1V8 NO2HDLLX0
XU30 VSS out[1] n17 n5 VDD_1V8 NO2HDLLX2
XU29 VSS out[5] n17 n8 VDD_1V8 NO2HDLLX0
XU28 VSS out[4] n13 n8 VDD_1V8 NO2HDLLX0
XU26 VSS out[21] n17 n10 VDD_1V8 NO2HDLLX0
XU25 VSS out[20] n13 n10 VDD_1V8 NO2HDLLX0
XU24 VSS out[19] n14 n3 VDD_1V8 NO2HDLLX0
XU23 VSS out[18] n15 n3 VDD_1V8 NO2HDLLX0
XU22 VSS out[22] n15 n10 VDD_1V8 NO2HDLLX0
XU20 VSS out[15] n14 n7 VDD_1V8 NO2HDLLX0
XU18 VSS out[14] n15 n7 VDD_1V8 NO2HDLLX0
XU16 VSS out[13] n17 n7 VDD_1V8 NO2HDLLX0
XU14 VSS out[17] n17 n3 VDD_1V8 NO2HDLLX0
XU12 VSS out[16] n13 n3 VDD_1V8 NO2HDLLX0
XU10 VSS out[0] n13 n5 VDD_1V8 NO2HDLLX2
XU47 n16 VSS addres_in[4] n12 VDD_1V8 addres_in[3] NA3HDLLX0
XU41 n11 VSS addres_in[3] addres_in[4] VDD_1V8 addres_in[2] NA3HDLLX0
XU33 n9 VSS n6 addres_in[3] VDD_1V8 n12 NA3HDLLX0
XU27 n8 VSS n6 addres_in[2] VDD_1V8 n4 NA3HDLLX0
XU21 n10 VSS addres_in[4] n4 VDD_1V8 addres_in[2] NA3HDLLX0
XU19 VSS addres_in[0] addres_in[1] VDD_1V8 n14 NA2HDLLX0
XU17 VSS addres_in[1] n2 VDD_1V8 n15 NA2HDLLX0
XU15 n7 VSS addres_in[2] n6 VDD_1V8 addres_in[3] NA3HDLLX0
XU13 VSS addres_in[0] n1 VDD_1V8 n17 NA2HDLLX0
XU11 n3 VSS n12 n4 VDD_1V8 addres_in[4] NA3HDLLX0
XU9 n5 VSS n6 n12 VDD_1V8 n4 NA3HDLLX0
XU8 n12 VSS VDD_1V8 addres_in[2] INHDLLX0
XU7 n6 VSS VDD_1V8 addres_in[4] INHDLLX0
XU6 n4 VSS VDD_1V8 addres_in[3] INHDLLX0
XU5 VSS n2 n1 VDD_1V8 n13 NA2HDLLX0
XU4 n1 VSS VDD_1V8 addres_in[1] INHDLLX0
XU3 n2 VSS VDD_1V8 addres_in[0] INHDLLX0
.ENDS

.SUBCKT Decodificador_width32_1 addres_in[4] addres_in[3] addres_in[2] addres_in[1]
+ addres_in[0] out[31] out[30] out[29] out[28] out[27] out[26] out[25] out[24] out[23]
+ out[22] out[21] out[20] out[19] out[18] out[17] out[16] out[15] out[14] out[13]
+ out[12] out[11] out[10] out[9] out[8] out[7] out[6] out[5] out[4] out[3] out[2]
+ out[1] out[0] VSS VDD_1V8
XU43 VSS out[31] n15 n10 VDD_1V8 NO2HDLLX0
XU51 VSS out[25] n17 n16 VDD_1V8 NO2HDLLX0
XU50 VSS out[27] n15 n16 VDD_1V8 NO2HDLLX0
XU49 VSS out[24] n14 n16 VDD_1V8 NO2HDLLX2
XU48 VSS out[26] n13 n16 VDD_1V8 NO2HDLLX0
XU46 VSS out[23] n15 n11 VDD_1V8 NO2HDLLX0
XU45 VSS out[29] n17 n10 VDD_1V8 NO2HDLLX0
XU44 VSS out[30] n13 n10 VDD_1V8 NO2HDLLX0
XU42 VSS out[28] n14 n10 VDD_1V8 NO2HDLLX2
XU40 VSS out[9] n9 n17 VDD_1V8 NO2HDLLX0
XU39 VSS out[8] n9 n14 VDD_1V8 NO2HDLLX0
XU38 VSS out[7] n15 n8 VDD_1V8 NO2HDLLX0
XU37 VSS out[6] n8 n13 VDD_1V8 NO2HDLLX0
XU36 VSS out[12] n14 n7 VDD_1V8 NO2HDLLX2
XU35 VSS out[11] n9 n15 VDD_1V8 NO2HDLLX0
XU34 VSS out[10] n9 n13 VDD_1V8 NO2HDLLX0
XU32 VSS out[3] n15 n5 VDD_1V8 NO2HDLLX0
XU31 VSS out[2] n13 n5 VDD_1V8 NO2HDLLX1
XU30 VSS out[1] n17 n5 VDD_1V8 NO2HDLLX2
XU29 VSS out[5] n17 n8 VDD_1V8 NO2HDLLX0
XU28 VSS out[4] n14 n8 VDD_1V8 NO2HDLLX0
XU26 VSS out[21] n17 n11 VDD_1V8 NO2HDLLX0
XU25 VSS out[20] n14 n11 VDD_1V8 NO2HDLLX0
XU24 VSS out[19] n15 n3 VDD_1V8 NO2HDLLX0
XU23 VSS out[18] n13 n3 VDD_1V8 NO2HDLLX0
XU22 VSS out[22] n13 n11 VDD_1V8 NO2HDLLX0
XU20 VSS out[15] n15 n7 VDD_1V8 NO2HDLLX0
XU18 VSS out[14] n13 n7 VDD_1V8 NO2HDLLX0
XU16 VSS out[13] n17 n7 VDD_1V8 NO2HDLLX0
XU14 VSS out[17] n17 n3 VDD_1V8 NO2HDLLX0
XU12 VSS out[16] n14 n3 VDD_1V8 NO2HDLLX0
XU10 VSS out[0] n14 n5 VDD_1V8 NO2HDLLX2
XU47 n16 VSS addres_in[4] n12 VDD_1V8 addres_in[3] NA3HDLLX0
XU41 n10 VSS addres_in[3] addres_in[4] VDD_1V8 addres_in[2] NA3HDLLX0
XU33 n9 VSS n6 addres_in[3] VDD_1V8 n12 NA3HDLLX0
XU27 n8 VSS n6 addres_in[2] VDD_1V8 n4 NA3HDLLX0
XU21 n11 VSS addres_in[4] n4 VDD_1V8 addres_in[2] NA3HDLLX0
XU19 VSS addres_in[0] addres_in[1] VDD_1V8 n15 NA2HDLLX0
XU17 VSS addres_in[1] n2 VDD_1V8 n13 NA2HDLLX0
XU15 n7 VSS addres_in[2] n6 VDD_1V8 addres_in[3] NA3HDLLX0
XU13 VSS addres_in[0] n1 VDD_1V8 n17 NA2HDLLX0
XU11 n3 VSS n12 n4 VDD_1V8 addres_in[4] NA3HDLLX0
XU9 n5 VSS n6 n12 VDD_1V8 n4 NA3HDLLX0
XU8 n12 VSS VDD_1V8 addres_in[2] INHDLLX0
XU7 n6 VSS VDD_1V8 addres_in[4] INHDLLX0
XU6 n4 VSS VDD_1V8 addres_in[3] INHDLLX0
XU5 VSS n2 n1 VDD_1V8 n14 NA2HDLLX0
XU4 n1 VSS VDD_1V8 addres_in[1] INHDLLX0
XU3 n2 VSS VDD_1V8 addres_in[0] INHDLLX0
.ENDS

.SUBCKT Decodificador_width32_0 addres_in[4] addres_in[3] addres_in[2] addres_in[1]
+ addres_in[0] out[31] out[30] out[29] out[28] out[27] out[26] out[25] out[24] out[23]
+ out[22] out[21] out[20] out[19] out[18] out[17] out[16] out[15] out[14] out[13]
+ out[12] out[11] out[10] out[9] out[8] out[7] out[6] out[5] out[4] out[3] out[2]
+ out[1] out[0] VSS VDD_1V8
XU50 VSS out[10] n17 n16 VDD_1V8 NO2HDLLX0
XU49 VSS out[11] n17 n15 VDD_1V8 NO2HDLLX0
XU48 VSS out[12] n14 n13 VDD_1V8 NO2HDLLX0
XU47 VSS out[13] n12 n13 VDD_1V8 NO2HDLLX0
XU46 VSS out[14] n16 n13 VDD_1V8 NO2HDLLX0
XU45 VSS out[15] n15 n13 VDD_1V8 NO2HDLLX0
XU44 n13 VSS addres_in[3] n11 VDD_1V8 addres_in[2] NA3HDLLX0
XU43 VSS out[16] n14 n10 VDD_1V8 NO2HDLLX0
XU42 VSS out[17] n12 n10 VDD_1V8 NO2HDLLX0
XU41 VSS out[18] n16 n10 VDD_1V8 NO2HDLLX0
XU40 VSS out[19] n15 n10 VDD_1V8 NO2HDLLX0
XU39 n10 VSS n9 n8 VDD_1V8 addres_in[4] NA3HDLLX0
XU38 VSS out[1] n12 n7 VDD_1V8 NO2HDLLX0
XU37 VSS out[20] n14 n6 VDD_1V8 NO2HDLLX0
XU36 VSS out[21] n12 n6 VDD_1V8 NO2HDLLX0
XU35 VSS out[22] n16 n6 VDD_1V8 NO2HDLLX0
XU34 VSS out[23] n15 n6 VDD_1V8 NO2HDLLX0
XU33 n6 VSS addres_in[2] n8 VDD_1V8 addres_in[4] NA3HDLLX0
XU32 VSS out[24] n14 n5 VDD_1V8 NO2HDLLX0
XU31 VSS out[25] n12 n5 VDD_1V8 NO2HDLLX0
XU30 VSS out[26] n16 n5 VDD_1V8 NO2HDLLX0
XU29 VSS out[27] n15 n5 VDD_1V8 NO2HDLLX0
XU28 n5 VSS addres_in[3] n9 VDD_1V8 addres_in[4] NA3HDLLX0
XU27 VSS out[28] n14 n4 VDD_1V8 NO2HDLLX0
XU26 VSS out[29] n12 n4 VDD_1V8 NO2HDLLX0
XU25 VSS out[2] n16 n7 VDD_1V8 NO2HDLLX0
XU24 VSS out[30] n16 n4 VDD_1V8 NO2HDLLX0
XU23 VSS out[31] n15 n4 VDD_1V8 NO2HDLLX0
XU22 n4 VSS addres_in[4] addres_in[3] VDD_1V8 addres_in[2] NA3HDLLX0
XU21 VSS out[3] n15 n7 VDD_1V8 NO2HDLLX0
XU20 n7 VSS n8 n9 VDD_1V8 n11 NA3HDLLX0
XU19 VSS out[4] n14 n3 VDD_1V8 NO2HDLLX0
XU18 VSS out[5] n12 n3 VDD_1V8 NO2HDLLX0
XU17 VSS out[6] n3 n16 VDD_1V8 NO2HDLLX0
XU16 VSS addres_in[1] n2 VDD_1V8 n16 NA2HDLLX0
XU15 VSS out[7] n15 n3 VDD_1V8 NO2HDLLX0
XU14 n3 VSS n8 addres_in[2] VDD_1V8 n11 NA3HDLLX0
XU13 n8 VSS VDD_1V8 addres_in[3] INHDLLX0
XU12 VSS addres_in[0] addres_in[1] VDD_1V8 n15 NA2HDLLX0
XU11 VSS out[8] n17 n14 VDD_1V8 NO2HDLLX0
XU10 VSS n2 n1 VDD_1V8 n14 NA2HDLLX0
XU9 n2 VSS VDD_1V8 addres_in[0] INHDLLX0
XU8 VSS out[9] n17 n12 VDD_1V8 NO2HDLLX0
XU7 VSS addres_in[0] n1 VDD_1V8 n12 NA2HDLLX0
XU6 n1 VSS VDD_1V8 addres_in[1] INHDLLX0
XU5 n17 VSS n11 addres_in[3] VDD_1V8 n9 NA3HDLLX0
XU4 n11 VSS VDD_1V8 addres_in[4] INHDLLX0
XU3 n9 VSS VDD_1V8 addres_in[2] INHDLLX0
.ENDS

.SUBCKT latchtriestado_991 In Out1 Out2 En1 En2 Write rst VSS VDD_1V8
XOut1_tri VSS En1 VDD_1V8 q Out1 BTHHDLLX1
XOut2_tri VSS En2 VDD_1V8 q Out2 BTHHDLLX1
Xq_reg q VSS rst VDD_1V8 In Write DLHRQHDLLX0
.ENDS

.SUBCKT latchtriestado_990 In Out1 Out2 En1 En2 Write rst VSS VDD_1V8
XOut1_tri VSS En1 VDD_1V8 q Out1 BTHHDLLX1
XOut2_tri VSS En2 VDD_1V8 q Out2 BTHHDLLX1
Xq_reg q VSS rst VDD_1V8 In Write DLHRQHDLLX0
.ENDS

.SUBCKT latchtriestado_989 In Out1 Out2 En1 En2 Write rst VSS VDD_1V8
XOut1_tri VSS En1 VDD_1V8 q Out1 BTHHDLLX1
XOut2_tri VSS En2 VDD_1V8 q Out2 BTHHDLLX1
Xq_reg q VSS rst VDD_1V8 In Write DLHRQHDLLX0
.ENDS

.SUBCKT latchtriestado_988 In Out1 Out2 En1 En2 Write rst VSS VDD_1V8
XOut1_tri VSS En1 VDD_1V8 q Out1 BTHHDLLX1
XOut2_tri VSS En2 VDD_1V8 q Out2 BTHHDLLX1
Xq_reg q VSS rst VDD_1V8 In Write DLHRQHDLLX0
.ENDS

.SUBCKT latchtriestado_987 In Out1 Out2 En1 En2 Write rst VSS VDD_1V8
XOut1_tri VSS En1 VDD_1V8 q Out1 BTHHDLLX1
XOut2_tri VSS En2 VDD_1V8 q Out2 BTHHDLLX1
Xq_reg q VSS rst VDD_1V8 In Write DLHRQHDLLX0
.ENDS

.SUBCKT latchtriestado_986 In Out1 Out2 En1 En2 Write rst VSS VDD_1V8
XOut1_tri VSS En1 VDD_1V8 q Out1 BTHHDLLX1
XOut2_tri VSS En2 VDD_1V8 q Out2 BTHHDLLX1
Xq_reg q VSS rst VDD_1V8 In Write DLHRQHDLLX0
.ENDS

.SUBCKT latchtriestado_985 In Out1 Out2 En1 En2 Write rst VSS VDD_1V8
XOut1_tri VSS En1 VDD_1V8 q Out1 BTHHDLLX1
XOut2_tri VSS En2 VDD_1V8 q Out2 BTHHDLLX1
Xq_reg q VSS rst VDD_1V8 In Write DLHRQHDLLX0
.ENDS

.SUBCKT latchtriestado_984 In Out1 Out2 En1 En2 Write rst VSS VDD_1V8
XOut1_tri VSS En1 VDD_1V8 q Out1 BTHHDLLX1
XOut2_tri VSS En2 VDD_1V8 q Out2 BTHHDLLX1
Xq_reg q VSS rst VDD_1V8 In Write DLHRQHDLLX0
.ENDS

.SUBCKT latchtriestado_983 In Out1 Out2 En1 En2 Write rst VSS VDD_1V8
XOut1_tri VSS En1 VDD_1V8 q Out1 BTHHDLLX1
XOut2_tri VSS En2 VDD_1V8 q Out2 BTHHDLLX1
Xq_reg q VSS rst VDD_1V8 In Write DLHRQHDLLX0
.ENDS

.SUBCKT latchtriestado_982 In Out1 Out2 En1 En2 Write rst VSS VDD_1V8
XOut1_tri VSS En1 VDD_1V8 q Out1 BTHHDLLX1
XOut2_tri VSS En2 VDD_1V8 q Out2 BTHHDLLX1
Xq_reg q VSS rst VDD_1V8 In Write DLHRQHDLLX0
.ENDS

.SUBCKT latchtriestado_981 In Out1 Out2 En1 En2 Write rst VSS VDD_1V8
XOut2_tri VSS En2 VDD_1V8 q Out2 BTHHDLLX1
XOut1_tri VSS En1 VDD_1V8 q Out1 BTHHDLLX1
Xq_reg q VSS rst VDD_1V8 In Write DLHRQHDLLX0
.ENDS

.SUBCKT latchtriestado_980 In Out1 Out2 En1 En2 Write rst VSS VDD_1V8
XOut1_tri VSS En1 VDD_1V8 q Out1 BTHHDLLX1
XOut2_tri VSS En2 VDD_1V8 q Out2 BTHHDLLX1
Xq_reg q VSS rst VDD_1V8 In Write DLHRQHDLLX0
.ENDS

.SUBCKT latchtriestado_979 In Out1 Out2 En1 En2 Write rst VSS VDD_1V8
XOut2_tri VSS En2 VDD_1V8 q Out2 BTHHDLLX1
XOut1_tri VSS En1 VDD_1V8 q Out1 BTHHDLLX1
Xq_reg q VSS rst VDD_1V8 In Write DLHRQHDLLX0
.ENDS

.SUBCKT latchtriestado_978 In Out1 Out2 En1 En2 Write rst VSS VDD_1V8
XOut2_tri VSS En2 VDD_1V8 q Out2 BTHHDLLX1
XOut1_tri VSS En1 VDD_1V8 q Out1 BTHHDLLX1
Xq_reg q VSS rst VDD_1V8 In Write DLHRQHDLLX0
.ENDS

.SUBCKT latchtriestado_977 In Out1 Out2 En1 En2 Write rst VSS VDD_1V8
XOut2_tri VSS En2 VDD_1V8 q Out2 BTHHDLLX1
XOut1_tri VSS En1 VDD_1V8 q Out1 BTHHDLLX1
Xq_reg q VSS rst VDD_1V8 In Write DLHRQHDLLX0
.ENDS

.SUBCKT latchtriestado_976 In Out1 Out2 En1 En2 Write rst VSS VDD_1V8
XOut2_tri VSS En2 VDD_1V8 q Out2 BTHHDLLX1
XOut1_tri VSS En1 VDD_1V8 q Out1 BTHHDLLX1
Xq_reg q VSS rst VDD_1V8 In Write DLHRQHDLLX0
.ENDS

.SUBCKT latchtriestado_975 In Out1 Out2 En1 En2 Write rst VSS VDD_1V8
XOut2_tri VSS En2 VDD_1V8 q Out2 BTHHDLLX1
XOut1_tri VSS En1 VDD_1V8 q Out1 BTHHDLLX1
Xq_reg q VSS rst VDD_1V8 In Write DLHRQHDLLX0
.ENDS

.SUBCKT latchtriestado_974 In Out1 Out2 En1 En2 Write rst VSS VDD_1V8
Xq_reg q VSS rst VDD_1V8 In Write DLHRQHDLLX0
XOut1_tri VSS En1 VDD_1V8 q Out1 BTHHDLLX1
XOut2_tri VSS En2 VDD_1V8 q Out2 BTHHDLLX1
.ENDS

.SUBCKT latchtriestado_973 In Out1 Out2 En1 En2 Write rst VSS VDD_1V8
Xq_reg q VSS rst VDD_1V8 In Write DLHRQHDLLX0
XOut1_tri VSS En1 VDD_1V8 q Out1 BTHHDLLX1
XOut2_tri VSS En2 VDD_1V8 q Out2 BTHHDLLX1
.ENDS

.SUBCKT latchtriestado_972 In Out1 Out2 En1 En2 Write rst VSS VDD_1V8
Xq_reg q VSS rst VDD_1V8 In Write DLHRQHDLLX0
XOut1_tri VSS En1 VDD_1V8 q Out1 BTHHDLLX1
XOut2_tri VSS En2 VDD_1V8 q Out2 BTHHDLLX1
.ENDS

.SUBCKT latchtriestado_971 In Out1 Out2 En1 En2 Write rst VSS VDD_1V8
Xq_reg q VSS rst VDD_1V8 In Write DLHRQHDLLX0
XOut1_tri VSS En1 VDD_1V8 q Out1 BTHHDLLX1
XOut2_tri VSS En2 VDD_1V8 q Out2 BTHHDLLX1
.ENDS

.SUBCKT latchtriestado_970 In Out1 Out2 En1 En2 Write rst VSS VDD_1V8
Xq_reg q VSS rst VDD_1V8 In Write DLHRQHDLLX0
XOut1_tri VSS En1 VDD_1V8 q Out1 BTHHDLLX1
XOut2_tri VSS En2 VDD_1V8 q Out2 BTHHDLLX1
.ENDS

.SUBCKT latchtriestado_969 In Out1 Out2 En1 En2 Write rst VSS VDD_1V8
XOut2_tri VSS En2 VDD_1V8 q Out2 BTHHDLLX1
XOut1_tri VSS En1 VDD_1V8 q Out1 BTHHDLLX1
Xq_reg q VSS rst VDD_1V8 In Write DLHRQHDLLX0
.ENDS

.SUBCKT latchtriestado_968 In Out1 Out2 En1 En2 Write rst VSS VDD_1V8
XOut1_tri VSS En1 VDD_1V8 q Out1 BTHHDLLX1
XOut2_tri VSS En2 VDD_1V8 q Out2 BTHHDLLX1
Xq_reg q VSS rst VDD_1V8 In Write DLHRQHDLLX0
.ENDS

.SUBCKT latchtriestado_967 In Out1 Out2 En1 En2 Write rst VSS VDD_1V8
XOut2_tri VSS En2 VDD_1V8 q Out2 BTHHDLLX1
XOut1_tri VSS En1 VDD_1V8 q Out1 BTHHDLLX1
Xq_reg q VSS rst VDD_1V8 In Write DLHRQHDLLX0
.ENDS

.SUBCKT latchtriestado_966 In Out1 Out2 En1 En2 Write rst VSS VDD_1V8
XOut1_tri VSS En1 VDD_1V8 q Out1 BTHHDLLX1
XOut2_tri VSS En2 VDD_1V8 q Out2 BTHHDLLX1
Xq_reg q VSS rst VDD_1V8 In Write DLHRQHDLLX0
.ENDS

.SUBCKT latchtriestado_965 In Out1 Out2 En1 En2 Write rst VSS VDD_1V8
XOut2_tri VSS En2 VDD_1V8 q Out2 BTHHDLLX1
XOut1_tri VSS En1 VDD_1V8 q Out1 BTHHDLLX1
Xq_reg q VSS rst VDD_1V8 In Write DLHRQHDLLX0
.ENDS

.SUBCKT latchtriestado_964 In Out1 Out2 En1 En2 Write rst VSS VDD_1V8
XOut2_tri VSS En2 VDD_1V8 q Out2 BTHHDLLX1
XOut1_tri VSS En1 VDD_1V8 q Out1 BTHHDLLX1
Xq_reg q VSS rst VDD_1V8 In Write DLHRQHDLLX0
.ENDS

.SUBCKT latchtriestado_963 In Out1 Out2 En1 En2 Write rst VSS VDD_1V8
XOut2_tri VSS En2 VDD_1V8 q Out2 BTHHDLLX1
XOut1_tri VSS En1 VDD_1V8 q Out1 BTHHDLLX1
Xq_reg q VSS rst VDD_1V8 In Write DLHRQHDLLX0
.ENDS

.SUBCKT latchtriestado_962 In Out1 Out2 En1 En2 Write rst VSS VDD_1V8
XOut2_tri VSS En2 VDD_1V8 q Out2 BTHHDLLX1
XOut1_tri VSS En1 VDD_1V8 q Out1 BTHHDLLX1
Xq_reg q VSS rst VDD_1V8 In Write DLHRQHDLLX0
.ENDS

.SUBCKT latchtriestado_961 In Out1 Out2 En1 En2 Write rst VSS VDD_1V8
XOut1_tri VSS En1 VDD_1V8 q Out1 BTHHDLLX1
XOut2_tri VSS En2 VDD_1V8 q Out2 BTHHDLLX1
Xq_reg q VSS rst VDD_1V8 In Write DLHRQHDLLX0
.ENDS

.SUBCKT latchtriestado_960 In Out1 Out2 En1 En2 Write rst VSS VDD_1V8
XOut2_tri VSS En2 VDD_1V8 q Out2 BTHHDLLX1
XOut1_tri VSS En1 VDD_1V8 q Out1 BTHHDLLX1
Xq_reg q VSS rst VDD_1V8 In Write DLHRQHDLLX0
.ENDS

.SUBCKT latchtriestado_959 In Out1 Out2 En1 En2 Write rst VSS VDD_1V8
XOut1_tri VSS En1 VDD_1V8 q Out1 BTHHDLLX1
XOut2_tri VSS En2 VDD_1V8 q Out2 BTHHDLLX1
Xq_reg q VSS rst VDD_1V8 In Write DLHRQHDLLX0
.ENDS

.SUBCKT latchtriestado_958 In Out1 Out2 En1 En2 Write rst VSS VDD_1V8
XOut1_tri VSS En1 VDD_1V8 q Out1 BTHHDLLX1
XOut2_tri VSS En2 VDD_1V8 q Out2 BTHHDLLX1
Xq_reg q VSS rst VDD_1V8 In Write DLHRQHDLLX0
.ENDS

.SUBCKT latchtriestado_957 In Out1 Out2 En1 En2 Write rst VSS VDD_1V8
XOut1_tri VSS En1 VDD_1V8 q Out1 BTHHDLLX1
XOut2_tri VSS En2 VDD_1V8 q Out2 BTHHDLLX1
Xq_reg q VSS rst VDD_1V8 In Write DLHRQHDLLX0
.ENDS

.SUBCKT latchtriestado_956 In Out1 Out2 En1 En2 Write rst VSS VDD_1V8
XOut1_tri VSS En1 VDD_1V8 q Out1 BTHHDLLX1
XOut2_tri VSS En2 VDD_1V8 q Out2 BTHHDLLX1
Xq_reg q VSS rst VDD_1V8 In Write DLHRQHDLLX0
.ENDS

.SUBCKT latchtriestado_955 In Out1 Out2 En1 En2 Write rst VSS VDD_1V8
XOut1_tri VSS En1 VDD_1V8 q Out1 BTHHDLLX1
XOut2_tri VSS En2 VDD_1V8 q Out2 BTHHDLLX1
Xq_reg q VSS rst VDD_1V8 In Write DLHRQHDLLX0
.ENDS

.SUBCKT latchtriestado_954 In Out1 Out2 En1 En2 Write rst VSS VDD_1V8
XOut1_tri VSS En1 VDD_1V8 q Out1 BTHHDLLX1
XOut2_tri VSS En2 VDD_1V8 q Out2 BTHHDLLX1
Xq_reg q VSS rst VDD_1V8 In Write DLHRQHDLLX0
.ENDS

.SUBCKT latchtriestado_953 In Out1 Out2 En1 En2 Write rst VSS VDD_1V8
XOut1_tri VSS En1 VDD_1V8 q Out1 BTHHDLLX1
XOut2_tri VSS En2 VDD_1V8 q Out2 BTHHDLLX1
Xq_reg q VSS rst VDD_1V8 In Write DLHRQHDLLX0
.ENDS

.SUBCKT latchtriestado_952 In Out1 Out2 En1 En2 Write rst VSS VDD_1V8
XOut1_tri VSS En1 VDD_1V8 q Out1 BTHHDLLX1
XOut2_tri VSS En2 VDD_1V8 q Out2 BTHHDLLX1
Xq_reg q VSS rst VDD_1V8 In Write DLHRQHDLLX0
.ENDS

.SUBCKT latchtriestado_951 In Out1 Out2 En1 En2 Write rst VSS VDD_1V8
XOut1_tri VSS En1 VDD_1V8 q Out1 BTHHDLLX1
XOut2_tri VSS En2 VDD_1V8 q Out2 BTHHDLLX1
Xq_reg q VSS rst VDD_1V8 In Write DLHRQHDLLX0
.ENDS

.SUBCKT latchtriestado_950 In Out1 Out2 En1 En2 Write rst VSS VDD_1V8
XOut2_tri VSS En2 VDD_1V8 q Out2 BTHHDLLX1
XOut1_tri VSS En1 VDD_1V8 q Out1 BTHHDLLX1
Xq_reg q VSS rst VDD_1V8 In Write DLHRQHDLLX0
.ENDS

.SUBCKT latchtriestado_949 In Out1 Out2 En1 En2 Write rst VSS VDD_1V8
XOut2_tri VSS En2 VDD_1V8 q Out2 BTHHDLLX1
XOut1_tri VSS En1 VDD_1V8 q Out1 BTHHDLLX1
Xq_reg q VSS rst VDD_1V8 In Write DLHRQHDLLX0
.ENDS

.SUBCKT latchtriestado_948 In Out1 Out2 En1 En2 Write rst VSS VDD_1V8
XOut2_tri VSS En2 VDD_1V8 q Out2 BTHHDLLX1
XOut1_tri VSS En1 VDD_1V8 q Out1 BTHHDLLX1
Xq_reg q VSS rst VDD_1V8 In Write DLHRQHDLLX0
.ENDS

.SUBCKT latchtriestado_947 In Out1 Out2 En1 En2 Write rst VSS VDD_1V8
XOut2_tri VSS En2 VDD_1V8 q Out2 BTHHDLLX1
XOut1_tri VSS En1 VDD_1V8 q Out1 BTHHDLLX1
Xq_reg q VSS rst VDD_1V8 In Write DLHRQHDLLX0
.ENDS

.SUBCKT latchtriestado_946 In Out1 Out2 En1 En2 Write rst VSS VDD_1V8
XOut2_tri VSS En2 VDD_1V8 q Out2 BTHHDLLX1
XOut1_tri VSS En1 VDD_1V8 q Out1 BTHHDLLX1
Xq_reg q VSS rst VDD_1V8 In Write DLHRQHDLLX0
.ENDS

.SUBCKT latchtriestado_945 In Out1 Out2 En1 En2 Write rst VSS VDD_1V8
XOut2_tri VSS En2 VDD_1V8 q Out2 BTHHDLLX1
XOut1_tri VSS En1 VDD_1V8 q Out1 BTHHDLLX1
Xq_reg q VSS rst VDD_1V8 In Write DLHRQHDLLX0
.ENDS

.SUBCKT latchtriestado_944 In Out1 Out2 En1 En2 Write rst VSS VDD_1V8
XOut2_tri VSS En2 VDD_1V8 q Out2 BTHHDLLX1
XOut1_tri VSS En1 VDD_1V8 q Out1 BTHHDLLX1
Xq_reg q VSS rst VDD_1V8 In Write DLHRQHDLLX0
.ENDS

.SUBCKT latchtriestado_943 In Out1 Out2 En1 En2 Write rst VSS VDD_1V8
XOut1_tri VSS En1 VDD_1V8 q Out1 BTHHDLLX1
XOut2_tri VSS En2 VDD_1V8 q Out2 BTHHDLLX1
Xq_reg q VSS rst VDD_1V8 In Write DLHRQHDLLX0
.ENDS

.SUBCKT latchtriestado_942 In Out1 Out2 En1 En2 Write rst VSS VDD_1V8
Xq_reg q VSS rst VDD_1V8 In Write DLHRQHDLLX0
XOut1_tri VSS En1 VDD_1V8 q Out1 BTHHDLLX1
XOut2_tri VSS En2 VDD_1V8 q Out2 BTHHDLLX1
.ENDS

.SUBCKT latchtriestado_941 In Out1 Out2 En1 En2 Write rst VSS VDD_1V8
Xq_reg q VSS rst VDD_1V8 In Write DLHRQHDLLX0
XOut1_tri VSS En1 VDD_1V8 q Out1 BTHHDLLX1
XOut2_tri VSS En2 VDD_1V8 q Out2 BTHHDLLX1
.ENDS

.SUBCKT latchtriestado_940 In Out1 Out2 En1 En2 Write rst VSS VDD_1V8
Xq_reg q VSS rst VDD_1V8 In Write DLHRQHDLLX0
XOut1_tri VSS En1 VDD_1V8 q Out1 BTHHDLLX1
XOut2_tri VSS En2 VDD_1V8 q Out2 BTHHDLLX1
.ENDS

.SUBCKT latchtriestado_939 In Out1 Out2 En1 En2 Write rst VSS VDD_1V8
Xq_reg q VSS rst VDD_1V8 In Write DLHRQHDLLX0
XOut2_tri VSS En2 VDD_1V8 q Out2 BTHHDLLX1
XOut1_tri VSS En1 VDD_1V8 q Out1 BTHHDLLX1
.ENDS

.SUBCKT latchtriestado_938 In Out1 Out2 En1 En2 Write rst VSS VDD_1V8
Xq_reg q VSS rst VDD_1V8 In Write DLHRQHDLLX0
XOut2_tri VSS En2 VDD_1V8 q Out2 BTHHDLLX1
XOut1_tri VSS En1 VDD_1V8 q Out1 BTHHDLLX1
.ENDS

.SUBCKT latchtriestado_937 In Out1 Out2 En1 En2 Write rst VSS VDD_1V8
XOut1_tri VSS En1 VDD_1V8 q Out1 BTHHDLLX1
XOut2_tri VSS En2 VDD_1V8 q Out2 BTHHDLLX1
Xq_reg q VSS rst VDD_1V8 In Write DLHRQHDLLX0
.ENDS

.SUBCKT latchtriestado_936 In Out1 Out2 En1 En2 Write rst VSS VDD_1V8
XOut2_tri VSS En2 VDD_1V8 q Out2 BTHHDLLX1
XOut1_tri VSS En1 VDD_1V8 q Out1 BTHHDLLX1
Xq_reg q VSS rst VDD_1V8 In Write DLHRQHDLLX0
.ENDS

.SUBCKT latchtriestado_935 In Out1 Out2 En1 En2 Write rst VSS VDD_1V8
XOut2_tri VSS En2 VDD_1V8 q Out2 BTHHDLLX1
XOut1_tri VSS En1 VDD_1V8 q Out1 BTHHDLLX1
Xq_reg q VSS rst VDD_1V8 In Write DLHRQHDLLX0
.ENDS

.SUBCKT latchtriestado_934 In Out1 Out2 En1 En2 Write rst VSS VDD_1V8
XOut1_tri VSS En1 VDD_1V8 q Out1 BTHHDLLX1
XOut2_tri VSS En2 VDD_1V8 q Out2 BTHHDLLX1
Xq_reg q VSS rst VDD_1V8 In Write DLHRQHDLLX0
.ENDS

.SUBCKT latchtriestado_933 In Out1 Out2 En1 En2 Write rst VSS VDD_1V8
XOut1_tri VSS En1 VDD_1V8 q Out1 BTHHDLLX1
XOut2_tri VSS En2 VDD_1V8 q Out2 BTHHDLLX1
Xq_reg q VSS rst VDD_1V8 In Write DLHRQHDLLX0
.ENDS

.SUBCKT latchtriestado_932 In Out1 Out2 En1 En2 Write rst VSS VDD_1V8
XOut1_tri VSS En1 VDD_1V8 q Out1 BTHHDLLX1
XOut2_tri VSS En2 VDD_1V8 q Out2 BTHHDLLX1
Xq_reg q VSS rst VDD_1V8 In Write DLHRQHDLLX0
.ENDS

.SUBCKT latchtriestado_931 In Out1 Out2 En1 En2 Write rst VSS VDD_1V8
XOut1_tri VSS En1 VDD_1V8 q Out1 BTHHDLLX1
XOut2_tri VSS En2 VDD_1V8 q Out2 BTHHDLLX1
Xq_reg q VSS rst VDD_1V8 In Write DLHRQHDLLX0
.ENDS

.SUBCKT latchtriestado_930 In Out1 Out2 En1 En2 Write rst VSS VDD_1V8
XOut1_tri VSS En1 VDD_1V8 q Out1 BTHHDLLX1
XOut2_tri VSS En2 VDD_1V8 q Out2 BTHHDLLX1
Xq_reg q VSS rst VDD_1V8 In Write DLHRQHDLLX0
.ENDS

.SUBCKT latchtriestado_929 In Out1 Out2 En1 En2 Write rst VSS VDD_1V8
XOut1_tri VSS En1 VDD_1V8 q Out1 BTHHDLLX1
XOut2_tri VSS En2 VDD_1V8 q Out2 BTHHDLLX1
Xq_reg q VSS rst VDD_1V8 In Write DLHRQHDLLX0
.ENDS

.SUBCKT latchtriestado_928 In Out1 Out2 En1 En2 Write rst VSS VDD_1V8
XOut2_tri VSS En2 VDD_1V8 q Out2 BTHHDLLX1
XOut1_tri VSS En1 VDD_1V8 q Out1 BTHHDLLX1
Xq_reg q VSS rst VDD_1V8 In Write DLHRQHDLLX0
.ENDS

.SUBCKT latchtriestado_927 In Out1 Out2 En1 En2 Write rst VSS VDD_1V8
XOut1_tri VSS En1 VDD_1V8 q Out1 BTHHDLLX1
XOut2_tri VSS En2 VDD_1V8 q Out2 BTHHDLLX1
Xq_reg q VSS rst VDD_1V8 In Write DLHRQHDLLX0
.ENDS

.SUBCKT latchtriestado_926 In Out1 Out2 En1 En2 Write rst VSS VDD_1V8
XOut1_tri VSS En1 VDD_1V8 q Out1 BTHHDLLX1
XOut2_tri VSS En2 VDD_1V8 q Out2 BTHHDLLX1
Xq_reg q VSS rst VDD_1V8 In Write DLHRQHDLLX0
.ENDS

.SUBCKT latchtriestado_925 In Out1 Out2 En1 En2 Write rst VSS VDD_1V8
XOut1_tri VSS En1 VDD_1V8 q Out1 BTHHDLLX1
XOut2_tri VSS En2 VDD_1V8 q Out2 BTHHDLLX1
Xq_reg q VSS rst VDD_1V8 In Write DLHRQHDLLX0
.ENDS

.SUBCKT latchtriestado_924 In Out1 Out2 En1 En2 Write rst VSS VDD_1V8
XOut1_tri VSS En1 VDD_1V8 q Out1 BTHHDLLX1
XOut2_tri VSS En2 VDD_1V8 q Out2 BTHHDLLX1
Xq_reg q VSS rst VDD_1V8 In Write DLHRQHDLLX0
.ENDS

.SUBCKT latchtriestado_923 In Out1 Out2 En1 En2 Write rst VSS VDD_1V8
XOut1_tri VSS En1 VDD_1V8 q Out1 BTHHDLLX1
XOut2_tri VSS En2 VDD_1V8 q Out2 BTHHDLLX1
Xq_reg q VSS rst VDD_1V8 In Write DLHRQHDLLX0
.ENDS

.SUBCKT latchtriestado_922 In Out1 Out2 En1 En2 Write rst VSS VDD_1V8
XOut1_tri VSS En1 VDD_1V8 q Out1 BTHHDLLX1
XOut2_tri VSS En2 VDD_1V8 q Out2 BTHHDLLX1
Xq_reg q VSS rst VDD_1V8 In Write DLHRQHDLLX0
.ENDS

.SUBCKT latchtriestado_921 In Out1 Out2 En1 En2 Write rst VSS VDD_1V8
XOut1_tri VSS En1 VDD_1V8 q Out1 BTHHDLLX1
XOut2_tri VSS En2 VDD_1V8 q Out2 BTHHDLLX1
Xq_reg q VSS rst VDD_1V8 In Write DLHRQHDLLX0
.ENDS

.SUBCKT latchtriestado_920 In Out1 Out2 En1 En2 Write rst VSS VDD_1V8
XOut1_tri VSS En1 VDD_1V8 q Out1 BTHHDLLX1
XOut2_tri VSS En2 VDD_1V8 q Out2 BTHHDLLX1
Xq_reg q VSS rst VDD_1V8 In Write DLHRQHDLLX0
.ENDS

.SUBCKT latchtriestado_919 In Out1 Out2 En1 En2 Write rst VSS VDD_1V8
XOut1_tri VSS En1 VDD_1V8 q Out1 BTHHDLLX1
XOut2_tri VSS En2 VDD_1V8 q Out2 BTHHDLLX1
Xq_reg q VSS rst VDD_1V8 In Write DLHRQHDLLX0
.ENDS

.SUBCKT latchtriestado_918 In Out1 Out2 En1 En2 Write rst VSS VDD_1V8
XOut2_tri VSS En2 VDD_1V8 q Out2 BTHHDLLX1
XOut1_tri VSS En1 VDD_1V8 q Out1 BTHHDLLX1
Xq_reg q VSS rst VDD_1V8 In Write DLHRQHDLLX0
.ENDS

.SUBCKT latchtriestado_917 In Out1 Out2 En1 En2 Write rst VSS VDD_1V8
XOut1_tri VSS En1 VDD_1V8 q Out1 BTHHDLLX1
XOut2_tri VSS En2 VDD_1V8 q Out2 BTHHDLLX1
Xq_reg q VSS rst VDD_1V8 In Write DLHRQHDLLX0
.ENDS

.SUBCKT latchtriestado_916 In Out1 Out2 En1 En2 Write rst VSS VDD_1V8
XOut2_tri VSS En2 VDD_1V8 q Out2 BTHHDLLX1
XOut1_tri VSS En1 VDD_1V8 q Out1 BTHHDLLX1
Xq_reg q VSS rst VDD_1V8 In Write DLHRQHDLLX0
.ENDS

.SUBCKT latchtriestado_915 In Out1 Out2 En1 En2 Write rst VSS VDD_1V8
XOut2_tri VSS En2 VDD_1V8 q Out2 BTHHDLLX1
XOut1_tri VSS En1 VDD_1V8 q Out1 BTHHDLLX1
Xq_reg q VSS rst VDD_1V8 In Write DLHRQHDLLX0
.ENDS

.SUBCKT latchtriestado_914 In Out1 Out2 En1 En2 Write rst VSS VDD_1V8
XOut2_tri VSS En2 VDD_1V8 q Out2 BTHHDLLX1
XOut1_tri VSS En1 VDD_1V8 q Out1 BTHHDLLX1
Xq_reg q VSS rst VDD_1V8 In Write DLHRQHDLLX0
.ENDS

.SUBCKT latchtriestado_913 In Out1 Out2 En1 En2 Write rst VSS VDD_1V8
XOut2_tri VSS En2 VDD_1V8 q Out2 BTHHDLLX1
XOut1_tri VSS En1 VDD_1V8 q Out1 BTHHDLLX1
Xq_reg q VSS rst VDD_1V8 In Write DLHRQHDLLX0
.ENDS

.SUBCKT latchtriestado_912 In Out1 Out2 En1 En2 Write rst VSS VDD_1V8
XOut2_tri VSS En2 VDD_1V8 q Out2 BTHHDLLX1
XOut1_tri VSS En1 VDD_1V8 q Out1 BTHHDLLX1
Xq_reg q VSS rst VDD_1V8 In Write DLHRQHDLLX0
.ENDS

.SUBCKT latchtriestado_911 In Out1 Out2 En1 En2 Write rst VSS VDD_1V8
XOut1_tri VSS En1 VDD_1V8 q Out1 BTHHDLLX1
XOut2_tri VSS En2 VDD_1V8 q Out2 BTHHDLLX1
Xq_reg q VSS rst VDD_1V8 In Write DLHRQHDLLX0
.ENDS

.SUBCKT latchtriestado_910 In Out1 Out2 En1 En2 Write rst VSS VDD_1V8
Xq_reg q VSS rst VDD_1V8 In Write DLHRQHDLLX0
XOut1_tri VSS En1 VDD_1V8 q Out1 BTHHDLLX1
XOut2_tri VSS En2 VDD_1V8 q Out2 BTHHDLLX1
.ENDS

.SUBCKT latchtriestado_909 In Out1 Out2 En1 En2 Write rst VSS VDD_1V8
Xq_reg q VSS rst VDD_1V8 In Write DLHRQHDLLX0
XOut1_tri VSS En1 VDD_1V8 q Out1 BTHHDLLX1
XOut2_tri VSS En2 VDD_1V8 q Out2 BTHHDLLX1
.ENDS

.SUBCKT latchtriestado_908 In Out1 Out2 En1 En2 Write rst VSS VDD_1V8
Xq_reg q VSS rst VDD_1V8 In Write DLHRQHDLLX0
XOut1_tri VSS En1 VDD_1V8 q Out1 BTHHDLLX1
XOut2_tri VSS En2 VDD_1V8 q Out2 BTHHDLLX1
.ENDS

.SUBCKT latchtriestado_907 In Out1 Out2 En1 En2 Write rst VSS VDD_1V8
Xq_reg q VSS rst VDD_1V8 In Write DLHRQHDLLX0
XOut1_tri VSS En1 VDD_1V8 q Out1 BTHHDLLX1
XOut2_tri VSS En2 VDD_1V8 q Out2 BTHHDLLX1
.ENDS

.SUBCKT latchtriestado_906 In Out1 Out2 En1 En2 Write rst VSS VDD_1V8
Xq_reg q VSS rst VDD_1V8 In Write DLHRQHDLLX0
XOut1_tri VSS En1 VDD_1V8 q Out1 BTHHDLLX1
XOut2_tri VSS En2 VDD_1V8 q Out2 BTHHDLLX1
.ENDS

.SUBCKT latchtriestado_905 In Out1 Out2 En1 En2 Write rst VSS VDD_1V8
XOut2_tri VSS En2 VDD_1V8 q Out2 BTHHDLLX1
XOut1_tri VSS En1 VDD_1V8 q Out1 BTHHDLLX1
Xq_reg q VSS rst VDD_1V8 In Write DLHRQHDLLX0
.ENDS

.SUBCKT latchtriestado_904 In Out1 Out2 En1 En2 Write rst VSS VDD_1V8
XOut1_tri VSS En1 VDD_1V8 q Out1 BTHHDLLX1
XOut2_tri VSS En2 VDD_1V8 q Out2 BTHHDLLX1
Xq_reg q VSS rst VDD_1V8 In Write DLHRQHDLLX0
.ENDS

.SUBCKT latchtriestado_903 In Out1 Out2 En1 En2 Write rst VSS VDD_1V8
XOut2_tri VSS En2 VDD_1V8 q Out2 BTHHDLLX1
XOut1_tri VSS En1 VDD_1V8 q Out1 BTHHDLLX1
Xq_reg q VSS rst VDD_1V8 In Write DLHRQHDLLX0
.ENDS

.SUBCKT latchtriestado_902 In Out1 Out2 En1 En2 Write rst VSS VDD_1V8
XOut2_tri VSS En2 VDD_1V8 q Out2 BTHHDLLX1
XOut1_tri VSS En1 VDD_1V8 q Out1 BTHHDLLX1
Xq_reg q VSS rst VDD_1V8 In Write DLHRQHDLLX0
.ENDS

.SUBCKT latchtriestado_901 In Out1 Out2 En1 En2 Write rst VSS VDD_1V8
XOut2_tri VSS En2 VDD_1V8 q Out2 BTHHDLLX1
XOut1_tri VSS En1 VDD_1V8 q Out1 BTHHDLLX1
Xq_reg q VSS rst VDD_1V8 In Write DLHRQHDLLX0
.ENDS

.SUBCKT latchtriestado_900 In Out1 Out2 En1 En2 Write rst VSS VDD_1V8
XOut2_tri VSS En2 VDD_1V8 q Out2 BTHHDLLX1
XOut1_tri VSS En1 VDD_1V8 q Out1 BTHHDLLX1
Xq_reg q VSS rst VDD_1V8 In Write DLHRQHDLLX0
.ENDS

.SUBCKT latchtriestado_899 In Out1 Out2 En1 En2 Write rst VSS VDD_1V8
XOut1_tri VSS En1 VDD_1V8 q Out1 BTHHDLLX1
XOut2_tri VSS En2 VDD_1V8 q Out2 BTHHDLLX1
Xq_reg q VSS rst VDD_1V8 In Write DLHRQHDLLX0
.ENDS

.SUBCKT latchtriestado_898 In Out1 Out2 En1 En2 Write rst VSS VDD_1V8
XOut1_tri VSS En1 VDD_1V8 q Out1 BTHHDLLX1
XOut2_tri VSS En2 VDD_1V8 q Out2 BTHHDLLX1
Xq_reg q VSS rst VDD_1V8 In Write DLHRQHDLLX0
.ENDS

.SUBCKT latchtriestado_897 In Out1 Out2 En1 En2 Write rst VSS VDD_1V8
XOut1_tri VSS En1 VDD_1V8 q Out1 BTHHDLLX1
XOut2_tri VSS En2 VDD_1V8 q Out2 BTHHDLLX1
Xq_reg q VSS rst VDD_1V8 In Write DLHRQHDLLX0
.ENDS

.SUBCKT latchtriestado_896 In Out1 Out2 En1 En2 Write rst VSS VDD_1V8
XOut1_tri VSS En1 VDD_1V8 q Out1 BTHHDLLX1
XOut2_tri VSS En2 VDD_1V8 q Out2 BTHHDLLX1
Xq_reg q VSS rst VDD_1V8 In Write DLHRQHDLLX0
.ENDS

.SUBCKT latchtriestado_895 In Out1 Out2 En1 En2 Write rst VSS VDD_1V8
XOut1_tri VSS En1 VDD_1V8 q Out1 BTHHDLLX1
XOut2_tri VSS En2 VDD_1V8 q Out2 BTHHDLLX1
Xq_reg q VSS rst VDD_1V8 In Write DLHRQHDLLX0
.ENDS

.SUBCKT latchtriestado_894 In Out1 Out2 En1 En2 Write rst VSS VDD_1V8
XOut1_tri VSS En1 VDD_1V8 q Out1 BTHHDLLX1
XOut2_tri VSS En2 VDD_1V8 q Out2 BTHHDLLX1
Xq_reg q VSS rst VDD_1V8 In Write DLHRQHDLLX0
.ENDS

.SUBCKT latchtriestado_893 In Out1 Out2 En1 En2 Write rst VSS VDD_1V8
XOut1_tri VSS En1 VDD_1V8 q Out1 BTHHDLLX1
XOut2_tri VSS En2 VDD_1V8 q Out2 BTHHDLLX1
Xq_reg q VSS rst VDD_1V8 In Write DLHRQHDLLX0
.ENDS

.SUBCKT latchtriestado_892 In Out1 Out2 En1 En2 Write rst VSS VDD_1V8
XOut1_tri VSS En1 VDD_1V8 q Out1 BTHHDLLX1
XOut2_tri VSS En2 VDD_1V8 q Out2 BTHHDLLX1
Xq_reg q VSS rst VDD_1V8 In Write DLHRQHDLLX0
.ENDS

.SUBCKT latchtriestado_891 In Out1 Out2 En1 En2 Write rst VSS VDD_1V8
XOut1_tri VSS En1 VDD_1V8 q Out1 BTHHDLLX1
XOut2_tri VSS En2 VDD_1V8 q Out2 BTHHDLLX1
Xq_reg q VSS rst VDD_1V8 In Write DLHRQHDLLX0
.ENDS

.SUBCKT latchtriestado_890 In Out1 Out2 En1 En2 Write rst VSS VDD_1V8
XOut1_tri VSS En1 VDD_1V8 q Out1 BTHHDLLX1
XOut2_tri VSS En2 VDD_1V8 q Out2 BTHHDLLX1
Xq_reg q VSS rst VDD_1V8 In Write DLHRQHDLLX0
.ENDS

.SUBCKT latchtriestado_889 In Out1 Out2 En1 En2 Write rst VSS VDD_1V8
XOut1_tri VSS En1 VDD_1V8 q Out1 BTHHDLLX1
XOut2_tri VSS En2 VDD_1V8 q Out2 BTHHDLLX1
Xq_reg q VSS rst VDD_1V8 In Write DLHRQHDLLX0
.ENDS

.SUBCKT latchtriestado_888 In Out1 Out2 En1 En2 Write rst VSS VDD_1V8
XOut1_tri VSS En1 VDD_1V8 q Out1 BTHHDLLX1
XOut2_tri VSS En2 VDD_1V8 q Out2 BTHHDLLX1
Xq_reg q VSS rst VDD_1V8 In Write DLHRQHDLLX0
.ENDS

.SUBCKT latchtriestado_887 In Out1 Out2 En1 En2 Write rst VSS VDD_1V8
XOut1_tri VSS En1 VDD_1V8 q Out1 BTHHDLLX1
XOut2_tri VSS En2 VDD_1V8 q Out2 BTHHDLLX1
Xq_reg q VSS rst VDD_1V8 In Write DLHRQHDLLX0
.ENDS

.SUBCKT latchtriestado_886 In Out1 Out2 En1 En2 Write rst VSS VDD_1V8
XOut1_tri VSS En1 VDD_1V8 q Out1 BTHHDLLX1
XOut2_tri VSS En2 VDD_1V8 q Out2 BTHHDLLX1
Xq_reg q VSS rst VDD_1V8 In Write DLHRQHDLLX0
.ENDS

.SUBCKT latchtriestado_885 In Out1 Out2 En1 En2 Write rst VSS VDD_1V8
XOut2_tri VSS En2 VDD_1V8 q Out2 BTHHDLLX1
XOut1_tri VSS En1 VDD_1V8 q Out1 BTHHDLLX1
Xq_reg q VSS rst VDD_1V8 In Write DLHRQHDLLX0
.ENDS

.SUBCKT latchtriestado_884 In Out1 Out2 En1 En2 Write rst VSS VDD_1V8
XOut2_tri VSS En2 VDD_1V8 q Out2 BTHHDLLX1
XOut1_tri VSS En1 VDD_1V8 q Out1 BTHHDLLX1
Xq_reg q VSS rst VDD_1V8 In Write DLHRQHDLLX0
.ENDS

.SUBCKT latchtriestado_883 In Out1 Out2 En1 En2 Write rst VSS VDD_1V8
XOut1_tri VSS En1 VDD_1V8 q Out1 BTHHDLLX1
XOut2_tri VSS En2 VDD_1V8 q Out2 BTHHDLLX1
Xq_reg q VSS rst VDD_1V8 In Write DLHRQHDLLX0
.ENDS

.SUBCKT latchtriestado_882 In Out1 Out2 En1 En2 Write rst VSS VDD_1V8
XOut2_tri VSS En2 VDD_1V8 q Out2 BTHHDLLX1
XOut1_tri VSS En1 VDD_1V8 q Out1 BTHHDLLX1
Xq_reg q VSS rst VDD_1V8 In Write DLHRQHDLLX0
.ENDS

.SUBCKT latchtriestado_881 In Out1 Out2 En1 En2 Write rst VSS VDD_1V8
XOut1_tri VSS En1 VDD_1V8 q Out1 BTHHDLLX1
XOut2_tri VSS En2 VDD_1V8 q Out2 BTHHDLLX1
Xq_reg q VSS rst VDD_1V8 In Write DLHRQHDLLX0
.ENDS

.SUBCKT latchtriestado_880 In Out1 Out2 En1 En2 Write rst VSS VDD_1V8
XOut1_tri VSS En1 VDD_1V8 q Out1 BTHHDLLX1
XOut2_tri VSS En2 VDD_1V8 q Out2 BTHHDLLX1
Xq_reg q VSS rst VDD_1V8 In Write DLHRQHDLLX0
.ENDS

.SUBCKT latchtriestado_879 In Out1 Out2 En1 En2 Write rst VSS VDD_1V8
XOut1_tri VSS En1 VDD_1V8 q Out1 BTHHDLLX1
XOut2_tri VSS En2 VDD_1V8 q Out2 BTHHDLLX1
Xq_reg q VSS rst VDD_1V8 In Write DLHRQHDLLX0
.ENDS

.SUBCKT latchtriestado_878 In Out1 Out2 En1 En2 Write rst VSS VDD_1V8
Xq_reg q VSS rst VDD_1V8 In Write DLHRQHDLLX0
XOut1_tri VSS En1 VDD_1V8 q Out1 BTHHDLLX1
XOut2_tri VSS En2 VDD_1V8 q Out2 BTHHDLLX1
.ENDS

.SUBCKT latchtriestado_877 In Out1 Out2 En1 En2 Write rst VSS VDD_1V8
Xq_reg q VSS rst VDD_1V8 In Write DLHRQHDLLX0
XOut1_tri VSS En1 VDD_1V8 q Out1 BTHHDLLX1
XOut2_tri VSS En2 VDD_1V8 q Out2 BTHHDLLX1
.ENDS

.SUBCKT latchtriestado_876 In Out1 Out2 En1 En2 Write rst VSS VDD_1V8
Xq_reg q VSS rst VDD_1V8 In Write DLHRQHDLLX0
XOut1_tri VSS En1 VDD_1V8 q Out1 BTHHDLLX1
XOut2_tri VSS En2 VDD_1V8 q Out2 BTHHDLLX1
.ENDS

.SUBCKT latchtriestado_875 In Out1 Out2 En1 En2 Write rst VSS VDD_1V8
Xq_reg q VSS rst VDD_1V8 In Write DLHRQHDLLX0
XOut1_tri VSS En1 VDD_1V8 q Out1 BTHHDLLX1
XOut2_tri VSS En2 VDD_1V8 q Out2 BTHHDLLX1
.ENDS

.SUBCKT latchtriestado_874 In Out1 Out2 En1 En2 Write rst VSS VDD_1V8
Xq_reg q VSS rst VDD_1V8 In Write DLHRQHDLLX0
XOut1_tri VSS En1 VDD_1V8 q Out1 BTHHDLLX1
XOut2_tri VSS En2 VDD_1V8 q Out2 BTHHDLLX1
.ENDS

.SUBCKT latchtriestado_873 In Out1 Out2 En1 En2 Write rst VSS VDD_1V8
XOut1_tri VSS En1 VDD_1V8 q Out1 BTHHDLLX1
XOut2_tri VSS En2 VDD_1V8 q Out2 BTHHDLLX1
Xq_reg q VSS rst VDD_1V8 In Write DLHRQHDLLX0
.ENDS

.SUBCKT latchtriestado_872 In Out1 Out2 En1 En2 Write rst VSS VDD_1V8
XOut2_tri VSS En2 VDD_1V8 q Out2 BTHHDLLX1
XOut1_tri VSS En1 VDD_1V8 q Out1 BTHHDLLX1
Xq_reg q VSS rst VDD_1V8 In Write DLHRQHDLLX0
.ENDS

.SUBCKT latchtriestado_871 In Out1 Out2 En1 En2 Write rst VSS VDD_1V8
XOut2_tri VSS En2 VDD_1V8 q Out2 BTHHDLLX1
XOut1_tri VSS En1 VDD_1V8 q Out1 BTHHDLLX1
Xq_reg q VSS rst VDD_1V8 In Write DLHRQHDLLX0
.ENDS

.SUBCKT latchtriestado_870 In Out1 Out2 En1 En2 Write rst VSS VDD_1V8
XOut1_tri VSS En1 VDD_1V8 q Out1 BTHHDLLX1
XOut2_tri VSS En2 VDD_1V8 q Out2 BTHHDLLX1
Xq_reg q VSS rst VDD_1V8 In Write DLHRQHDLLX0
.ENDS

.SUBCKT latchtriestado_869 In Out1 Out2 En1 En2 Write rst VSS VDD_1V8
XOut2_tri VSS En2 VDD_1V8 q Out2 BTHHDLLX1
XOut1_tri VSS En1 VDD_1V8 q Out1 BTHHDLLX1
Xq_reg q VSS rst VDD_1V8 In Write DLHRQHDLLX0
.ENDS

.SUBCKT latchtriestado_868 In Out1 Out2 En1 En2 Write rst VSS VDD_1V8
XOut2_tri VSS En2 VDD_1V8 q Out2 BTHHDLLX1
XOut1_tri VSS En1 VDD_1V8 q Out1 BTHHDLLX1
Xq_reg q VSS rst VDD_1V8 In Write DLHRQHDLLX0
.ENDS

.SUBCKT latchtriestado_867 In Out1 Out2 En1 En2 Write rst VSS VDD_1V8
XOut2_tri VSS En2 VDD_1V8 q Out2 BTHHDLLX1
XOut1_tri VSS En1 VDD_1V8 q Out1 BTHHDLLX1
Xq_reg q VSS rst VDD_1V8 In Write DLHRQHDLLX0
.ENDS

.SUBCKT latchtriestado_866 In Out1 Out2 En1 En2 Write rst VSS VDD_1V8
XOut2_tri VSS En2 VDD_1V8 q Out2 BTHHDLLX1
XOut1_tri VSS En1 VDD_1V8 q Out1 BTHHDLLX1
Xq_reg q VSS rst VDD_1V8 In Write DLHRQHDLLX0
.ENDS

.SUBCKT latchtriestado_865 In Out1 Out2 En1 En2 Write rst VSS VDD_1V8
XOut2_tri VSS En2 VDD_1V8 q Out2 BTHHDLLX1
XOut1_tri VSS En1 VDD_1V8 q Out1 BTHHDLLX1
Xq_reg q VSS rst VDD_1V8 In Write DLHRQHDLLX0
.ENDS

.SUBCKT latchtriestado_864 In Out1 Out2 En1 En2 Write rst VSS VDD_1V8
XOut1_tri VSS En1 VDD_1V8 q Out1 BTHHDLLX1
XOut2_tri VSS En2 VDD_1V8 q Out2 BTHHDLLX1
Xq_reg q VSS rst VDD_1V8 In Write DLHRQHDLLX0
.ENDS

.SUBCKT latchtriestado_863 In Out1 Out2 En1 En2 Write rst VSS VDD_1V8
XOut1_tri VSS En1 VDD_1V8 q Out1 BTHHDLLX1
XOut2_tri VSS En2 VDD_1V8 q Out2 BTHHDLLX1
Xq_reg q VSS rst VDD_1V8 In Write DLHRQHDLLX0
.ENDS

.SUBCKT latchtriestado_862 In Out1 Out2 En1 En2 Write rst VSS VDD_1V8
XOut1_tri VSS En1 VDD_1V8 q Out1 BTHHDLLX1
XOut2_tri VSS En2 VDD_1V8 q Out2 BTHHDLLX1
Xq_reg q VSS rst VDD_1V8 In Write DLHRQHDLLX0
.ENDS

.SUBCKT latchtriestado_861 In Out1 Out2 En1 En2 Write rst VSS VDD_1V8
XOut1_tri VSS En1 VDD_1V8 q Out1 BTHHDLLX1
XOut2_tri VSS En2 VDD_1V8 q Out2 BTHHDLLX1
Xq_reg q VSS rst VDD_1V8 In Write DLHRQHDLLX0
.ENDS

.SUBCKT latchtriestado_860 In Out1 Out2 En1 En2 Write rst VSS VDD_1V8
XOut1_tri VSS En1 VDD_1V8 q Out1 BTHHDLLX1
XOut2_tri VSS En2 VDD_1V8 q Out2 BTHHDLLX1
Xq_reg q VSS rst VDD_1V8 In Write DLHRQHDLLX0
.ENDS

.SUBCKT latchtriestado_859 In Out1 Out2 En1 En2 Write rst VSS VDD_1V8
XOut1_tri VSS En1 VDD_1V8 q Out1 BTHHDLLX1
XOut2_tri VSS En2 VDD_1V8 q Out2 BTHHDLLX1
Xq_reg q VSS rst VDD_1V8 In Write DLHRQHDLLX0
.ENDS

.SUBCKT latchtriestado_858 In Out1 Out2 En1 En2 Write rst VSS VDD_1V8
XOut1_tri VSS En1 VDD_1V8 q Out1 BTHHDLLX1
XOut2_tri VSS En2 VDD_1V8 q Out2 BTHHDLLX1
Xq_reg q VSS rst VDD_1V8 In Write DLHRQHDLLX0
.ENDS

.SUBCKT latchtriestado_857 In Out1 Out2 En1 En2 Write rst VSS VDD_1V8
XOut1_tri VSS En1 VDD_1V8 q Out1 BTHHDLLX1
XOut2_tri VSS En2 VDD_1V8 q Out2 BTHHDLLX1
Xq_reg q VSS rst VDD_1V8 In Write DLHRQHDLLX0
.ENDS

.SUBCKT latchtriestado_856 In Out1 Out2 En1 En2 Write rst VSS VDD_1V8
XOut1_tri VSS En1 VDD_1V8 q Out1 BTHHDLLX1
XOut2_tri VSS En2 VDD_1V8 q Out2 BTHHDLLX1
Xq_reg q VSS rst VDD_1V8 In Write DLHRQHDLLX0
.ENDS

.SUBCKT latchtriestado_855 In Out1 Out2 En1 En2 Write rst VSS VDD_1V8
XOut1_tri VSS En1 VDD_1V8 q Out1 BTHHDLLX1
XOut2_tri VSS En2 VDD_1V8 q Out2 BTHHDLLX1
Xq_reg q VSS rst VDD_1V8 In Write DLHRQHDLLX0
.ENDS

.SUBCKT latchtriestado_854 In Out1 Out2 En1 En2 Write rst VSS VDD_1V8
XOut1_tri VSS En1 VDD_1V8 q Out1 BTHHDLLX1
XOut2_tri VSS En2 VDD_1V8 q Out2 BTHHDLLX1
Xq_reg q VSS rst VDD_1V8 In Write DLHRQHDLLX0
.ENDS

.SUBCKT latchtriestado_853 In Out1 Out2 En1 En2 Write rst VSS VDD_1V8
XOut2_tri VSS En2 VDD_1V8 q Out2 BTHHDLLX1
XOut1_tri VSS En1 VDD_1V8 q Out1 BTHHDLLX1
Xq_reg q VSS rst VDD_1V8 In Write DLHRQHDLLX0
.ENDS

.SUBCKT latchtriestado_852 In Out1 Out2 En1 En2 Write rst VSS VDD_1V8
XOut2_tri VSS En2 VDD_1V8 q Out2 BTHHDLLX1
XOut1_tri VSS En1 VDD_1V8 q Out1 BTHHDLLX1
Xq_reg q VSS rst VDD_1V8 In Write DLHRQHDLLX0
.ENDS

.SUBCKT latchtriestado_851 In Out1 Out2 En1 En2 Write rst VSS VDD_1V8
XOut1_tri VSS En1 VDD_1V8 q Out1 BTHHDLLX1
XOut2_tri VSS En2 VDD_1V8 q Out2 BTHHDLLX1
Xq_reg q VSS rst VDD_1V8 In Write DLHRQHDLLX0
.ENDS

.SUBCKT latchtriestado_850 In Out1 Out2 En1 En2 Write rst VSS VDD_1V8
XOut1_tri VSS En1 VDD_1V8 q Out1 BTHHDLLX1
XOut2_tri VSS En2 VDD_1V8 q Out2 BTHHDLLX1
Xq_reg q VSS rst VDD_1V8 In Write DLHRQHDLLX0
.ENDS

.SUBCKT latchtriestado_849 In Out1 Out2 En1 En2 Write rst VSS VDD_1V8
XOut1_tri VSS En1 VDD_1V8 q Out1 BTHHDLLX1
XOut2_tri VSS En2 VDD_1V8 q Out2 BTHHDLLX1
Xq_reg q VSS rst VDD_1V8 In Write DLHRQHDLLX0
.ENDS

.SUBCKT latchtriestado_848 In Out1 Out2 En1 En2 Write rst VSS VDD_1V8
XOut1_tri VSS En1 VDD_1V8 q Out1 BTHHDLLX1
XOut2_tri VSS En2 VDD_1V8 q Out2 BTHHDLLX1
Xq_reg q VSS rst VDD_1V8 In Write DLHRQHDLLX0
.ENDS

.SUBCKT latchtriestado_847 In Out1 Out2 En1 En2 Write rst VSS VDD_1V8
XOut1_tri VSS En1 VDD_1V8 q Out1 BTHHDLLX1
XOut2_tri VSS En2 VDD_1V8 q Out2 BTHHDLLX1
Xq_reg q VSS rst VDD_1V8 In Write DLHRQHDLLX0
.ENDS

.SUBCKT latchtriestado_846 In Out1 Out2 En1 En2 Write rst VSS VDD_1V8
Xq_reg q VSS rst VDD_1V8 In Write DLHRQHDLLX0
XOut1_tri VSS En1 VDD_1V8 q Out1 BTHHDLLX1
XOut2_tri VSS En2 VDD_1V8 q Out2 BTHHDLLX1
.ENDS

.SUBCKT latchtriestado_845 In Out1 Out2 En1 En2 Write rst VSS VDD_1V8
Xq_reg q VSS rst VDD_1V8 In Write DLHRQHDLLX0
XOut1_tri VSS En1 VDD_1V8 q Out1 BTHHDLLX1
XOut2_tri VSS En2 VDD_1V8 q Out2 BTHHDLLX1
.ENDS

.SUBCKT latchtriestado_844 In Out1 Out2 En1 En2 Write rst VSS VDD_1V8
Xq_reg q VSS rst VDD_1V8 In Write DLHRQHDLLX0
XOut1_tri VSS En1 VDD_1V8 q Out1 BTHHDLLX1
XOut2_tri VSS En2 VDD_1V8 q Out2 BTHHDLLX1
.ENDS

.SUBCKT latchtriestado_843 In Out1 Out2 En1 En2 Write rst VSS VDD_1V8
Xq_reg q VSS rst VDD_1V8 In Write DLHRQHDLLX0
XOut1_tri VSS En1 VDD_1V8 q Out1 BTHHDLLX1
XOut2_tri VSS En2 VDD_1V8 q Out2 BTHHDLLX1
.ENDS

.SUBCKT latchtriestado_842 In Out1 Out2 En1 En2 Write rst VSS VDD_1V8
Xq_reg q VSS rst VDD_1V8 In Write DLHRQHDLLX0
XOut1_tri VSS En1 VDD_1V8 q Out1 BTHHDLLX1
XOut2_tri VSS En2 VDD_1V8 q Out2 BTHHDLLX1
.ENDS

.SUBCKT latchtriestado_841 In Out1 Out2 En1 En2 Write rst VSS VDD_1V8
XOut2_tri VSS En2 VDD_1V8 q Out2 BTHHDLLX1
XOut1_tri VSS En1 VDD_1V8 q Out1 BTHHDLLX1
Xq_reg q VSS rst VDD_1V8 In Write DLHRQHDLLX0
.ENDS

.SUBCKT latchtriestado_840 In Out1 Out2 En1 En2 Write rst VSS VDD_1V8
XOut2_tri VSS En2 VDD_1V8 q Out2 BTHHDLLX1
XOut1_tri VSS En1 VDD_1V8 q Out1 BTHHDLLX1
Xq_reg q VSS rst VDD_1V8 In Write DLHRQHDLLX0
.ENDS

.SUBCKT latchtriestado_839 In Out1 Out2 En1 En2 Write rst VSS VDD_1V8
XOut1_tri VSS En1 VDD_1V8 q Out1 BTHHDLLX1
XOut2_tri VSS En2 VDD_1V8 q Out2 BTHHDLLX1
Xq_reg q VSS rst VDD_1V8 In Write DLHRQHDLLX0
.ENDS

.SUBCKT latchtriestado_838 In Out1 Out2 En1 En2 Write rst VSS VDD_1V8
XOut1_tri VSS En1 VDD_1V8 q Out1 BTHHDLLX1
XOut2_tri VSS En2 VDD_1V8 q Out2 BTHHDLLX1
Xq_reg q VSS rst VDD_1V8 In Write DLHRQHDLLX0
.ENDS

.SUBCKT latchtriestado_837 In Out1 Out2 En1 En2 Write rst VSS VDD_1V8
XOut1_tri VSS En1 VDD_1V8 q Out1 BTHHDLLX1
XOut2_tri VSS En2 VDD_1V8 q Out2 BTHHDLLX1
Xq_reg q VSS rst VDD_1V8 In Write DLHRQHDLLX0
.ENDS

.SUBCKT latchtriestado_836 In Out1 Out2 En1 En2 Write rst VSS VDD_1V8
XOut1_tri VSS En1 VDD_1V8 q Out1 BTHHDLLX1
XOut2_tri VSS En2 VDD_1V8 q Out2 BTHHDLLX1
Xq_reg q VSS rst VDD_1V8 In Write DLHRQHDLLX0
.ENDS

.SUBCKT latchtriestado_835 In Out1 Out2 En1 En2 Write rst VSS VDD_1V8
XOut2_tri VSS En2 VDD_1V8 q Out2 BTHHDLLX1
XOut1_tri VSS En1 VDD_1V8 q Out1 BTHHDLLX1
Xq_reg q VSS rst VDD_1V8 In Write DLHRQHDLLX0
.ENDS

.SUBCKT latchtriestado_834 In Out1 Out2 En1 En2 Write rst VSS VDD_1V8
XOut2_tri VSS En2 VDD_1V8 q Out2 BTHHDLLX1
XOut1_tri VSS En1 VDD_1V8 q Out1 BTHHDLLX1
Xq_reg q VSS rst VDD_1V8 In Write DLHRQHDLLX0
.ENDS

.SUBCKT latchtriestado_833 In Out1 Out2 En1 En2 Write rst VSS VDD_1V8
XOut1_tri VSS En1 VDD_1V8 q Out1 BTHHDLLX1
XOut2_tri VSS En2 VDD_1V8 q Out2 BTHHDLLX1
Xq_reg q VSS rst VDD_1V8 In Write DLHRQHDLLX0
.ENDS

.SUBCKT latchtriestado_832 In Out1 Out2 En1 En2 Write rst VSS VDD_1V8
XOut1_tri VSS En1 VDD_1V8 q Out1 BTHHDLLX1
XOut2_tri VSS En2 VDD_1V8 q Out2 BTHHDLLX1
Xq_reg q VSS rst VDD_1V8 In Write DLHRQHDLLX0
.ENDS

.SUBCKT latchtriestado_831 In Out1 Out2 En1 En2 Write rst VSS VDD_1V8
XOut1_tri VSS En1 VDD_1V8 q Out1 BTHHDLLX1
XOut2_tri VSS En2 VDD_1V8 q Out2 BTHHDLLX1
Xq_reg q VSS rst VDD_1V8 In Write DLHRQHDLLX0
.ENDS

.SUBCKT latchtriestado_830 In Out1 Out2 En1 En2 Write rst VSS VDD_1V8
XOut1_tri VSS En1 VDD_1V8 q Out1 BTHHDLLX1
XOut2_tri VSS En2 VDD_1V8 q Out2 BTHHDLLX1
Xq_reg q VSS rst VDD_1V8 In Write DLHRQHDLLX0
.ENDS

.SUBCKT latchtriestado_829 In Out1 Out2 En1 En2 Write rst VSS VDD_1V8
XOut1_tri VSS En1 VDD_1V8 q Out1 BTHHDLLX1
XOut2_tri VSS En2 VDD_1V8 q Out2 BTHHDLLX1
Xq_reg q VSS rst VDD_1V8 In Write DLHRQHDLLX0
.ENDS

.SUBCKT latchtriestado_828 In Out1 Out2 En1 En2 Write rst VSS VDD_1V8
XOut1_tri VSS En1 VDD_1V8 q Out1 BTHHDLLX1
XOut2_tri VSS En2 VDD_1V8 q Out2 BTHHDLLX1
Xq_reg q VSS rst VDD_1V8 In Write DLHRQHDLLX0
.ENDS

.SUBCKT latchtriestado_827 In Out1 Out2 En1 En2 Write rst VSS VDD_1V8
XOut1_tri VSS En1 VDD_1V8 q Out1 BTHHDLLX1
XOut2_tri VSS En2 VDD_1V8 q Out2 BTHHDLLX1
Xq_reg q VSS rst VDD_1V8 In Write DLHRQHDLLX0
.ENDS

.SUBCKT latchtriestado_826 In Out1 Out2 En1 En2 Write rst VSS VDD_1V8
XOut1_tri VSS En1 VDD_1V8 q Out1 BTHHDLLX1
XOut2_tri VSS En2 VDD_1V8 q Out2 BTHHDLLX1
Xq_reg q VSS rst VDD_1V8 In Write DLHRQHDLLX0
.ENDS

.SUBCKT latchtriestado_825 In Out1 Out2 En1 En2 Write rst VSS VDD_1V8
XOut1_tri VSS En1 VDD_1V8 q Out1 BTHHDLLX1
XOut2_tri VSS En2 VDD_1V8 q Out2 BTHHDLLX1
Xq_reg q VSS rst VDD_1V8 In Write DLHRQHDLLX0
.ENDS

.SUBCKT latchtriestado_824 In Out1 Out2 En1 En2 Write rst VSS VDD_1V8
XOut1_tri VSS En1 VDD_1V8 q Out1 BTHHDLLX1
XOut2_tri VSS En2 VDD_1V8 q Out2 BTHHDLLX1
Xq_reg q VSS rst VDD_1V8 In Write DLHRQHDLLX0
.ENDS

.SUBCKT latchtriestado_823 In Out1 Out2 En1 En2 Write rst VSS VDD_1V8
XOut1_tri VSS En1 VDD_1V8 q Out1 BTHHDLLX1
XOut2_tri VSS En2 VDD_1V8 q Out2 BTHHDLLX1
Xq_reg q VSS rst VDD_1V8 In Write DLHRQHDLLX0
.ENDS

.SUBCKT latchtriestado_822 In Out1 Out2 En1 En2 Write rst VSS VDD_1V8
XOut1_tri VSS En1 VDD_1V8 q Out1 BTHHDLLX1
XOut2_tri VSS En2 VDD_1V8 q Out2 BTHHDLLX1
Xq_reg q VSS rst VDD_1V8 In Write DLHRQHDLLX0
.ENDS

.SUBCKT latchtriestado_821 In Out1 Out2 En1 En2 Write rst VSS VDD_1V8
XOut2_tri VSS En2 VDD_1V8 q Out2 BTHHDLLX1
XOut1_tri VSS En1 VDD_1V8 q Out1 BTHHDLLX1
Xq_reg q VSS rst VDD_1V8 In Write DLHRQHDLLX0
.ENDS

.SUBCKT latchtriestado_820 In Out1 Out2 En1 En2 Write rst VSS VDD_1V8
XOut2_tri VSS En2 VDD_1V8 q Out2 BTHHDLLX1
XOut1_tri VSS En1 VDD_1V8 q Out1 BTHHDLLX1
Xq_reg q VSS rst VDD_1V8 In Write DLHRQHDLLX0
.ENDS

.SUBCKT latchtriestado_819 In Out1 Out2 En1 En2 Write rst VSS VDD_1V8
XOut1_tri VSS En1 VDD_1V8 q Out1 BTHHDLLX1
XOut2_tri VSS En2 VDD_1V8 q Out2 BTHHDLLX1
Xq_reg q VSS rst VDD_1V8 In Write DLHRQHDLLX0
.ENDS

.SUBCKT latchtriestado_818 In Out1 Out2 En1 En2 Write rst VSS VDD_1V8
XOut1_tri VSS En1 VDD_1V8 q Out1 BTHHDLLX1
XOut2_tri VSS En2 VDD_1V8 q Out2 BTHHDLLX1
Xq_reg q VSS rst VDD_1V8 In Write DLHRQHDLLX0
.ENDS

.SUBCKT latchtriestado_817 In Out1 Out2 En1 En2 Write rst VSS VDD_1V8
XOut1_tri VSS En1 VDD_1V8 q Out1 BTHHDLLX1
XOut2_tri VSS En2 VDD_1V8 q Out2 BTHHDLLX1
Xq_reg q VSS rst VDD_1V8 In Write DLHRQHDLLX0
.ENDS

.SUBCKT latchtriestado_816 In Out1 Out2 En1 En2 Write rst VSS VDD_1V8
XOut1_tri VSS En1 VDD_1V8 q Out1 BTHHDLLX1
XOut2_tri VSS En2 VDD_1V8 q Out2 BTHHDLLX1
Xq_reg q VSS rst VDD_1V8 In Write DLHRQHDLLX0
.ENDS

.SUBCKT latchtriestado_815 In Out1 Out2 En1 En2 Write rst VSS VDD_1V8
XOut1_tri VSS En1 VDD_1V8 q Out1 BTHHDLLX1
XOut2_tri VSS En2 VDD_1V8 q Out2 BTHHDLLX1
Xq_reg q VSS rst VDD_1V8 In Write DLHRQHDLLX0
.ENDS

.SUBCKT latchtriestado_814 In Out1 Out2 En1 En2 Write rst VSS VDD_1V8
Xq_reg q VSS rst VDD_1V8 In Write DLHRQHDLLX0
XOut1_tri VSS En1 VDD_1V8 q Out1 BTHHDLLX1
XOut2_tri VSS En2 VDD_1V8 q Out2 BTHHDLLX1
.ENDS

.SUBCKT latchtriestado_813 In Out1 Out2 En1 En2 Write rst VSS VDD_1V8
Xq_reg q VSS rst VDD_1V8 In Write DLHRQHDLLX0
XOut1_tri VSS En1 VDD_1V8 q Out1 BTHHDLLX1
XOut2_tri VSS En2 VDD_1V8 q Out2 BTHHDLLX1
.ENDS

.SUBCKT latchtriestado_812 In Out1 Out2 En1 En2 Write rst VSS VDD_1V8
Xq_reg q VSS rst VDD_1V8 In Write DLHRQHDLLX0
XOut2_tri VSS En2 VDD_1V8 q Out2 BTHHDLLX1
XOut1_tri VSS En1 VDD_1V8 q Out1 BTHHDLLX1
.ENDS

.SUBCKT latchtriestado_811 In Out1 Out2 En1 En2 Write rst VSS VDD_1V8
Xq_reg q VSS rst VDD_1V8 In Write DLHRQHDLLX0
XOut1_tri VSS En1 VDD_1V8 q Out1 BTHHDLLX1
XOut2_tri VSS En2 VDD_1V8 q Out2 BTHHDLLX1
.ENDS

.SUBCKT latchtriestado_810 In Out1 Out2 En1 En2 Write rst VSS VDD_1V8
Xq_reg q VSS rst VDD_1V8 In Write DLHRQHDLLX0
XOut1_tri VSS En1 VDD_1V8 q Out1 BTHHDLLX1
XOut2_tri VSS En2 VDD_1V8 q Out2 BTHHDLLX1
.ENDS

.SUBCKT latchtriestado_809 In Out1 Out2 En1 En2 Write rst VSS VDD_1V8
XOut2_tri VSS En2 VDD_1V8 q Out2 BTHHDLLX1
XOut1_tri VSS En1 VDD_1V8 q Out1 BTHHDLLX1
Xq_reg q VSS rst VDD_1V8 In Write DLHRQHDLLX0
.ENDS

.SUBCKT latchtriestado_808 In Out1 Out2 En1 En2 Write rst VSS VDD_1V8
XOut1_tri VSS En1 VDD_1V8 q Out1 BTHHDLLX1
XOut2_tri VSS En2 VDD_1V8 q Out2 BTHHDLLX1
Xq_reg q VSS rst VDD_1V8 In Write DLHRQHDLLX0
.ENDS

.SUBCKT latchtriestado_807 In Out1 Out2 En1 En2 Write rst VSS VDD_1V8
XOut1_tri VSS En1 VDD_1V8 q Out1 BTHHDLLX1
XOut2_tri VSS En2 VDD_1V8 q Out2 BTHHDLLX1
Xq_reg q VSS rst VDD_1V8 In Write DLHRQHDLLX0
.ENDS

.SUBCKT latchtriestado_806 In Out1 Out2 En1 En2 Write rst VSS VDD_1V8
XOut2_tri VSS En2 VDD_1V8 q Out2 BTHHDLLX1
XOut1_tri VSS En1 VDD_1V8 q Out1 BTHHDLLX1
Xq_reg q VSS rst VDD_1V8 In Write DLHRQHDLLX0
.ENDS

.SUBCKT latchtriestado_805 In Out1 Out2 En1 En2 Write rst VSS VDD_1V8
XOut1_tri VSS En1 VDD_1V8 q Out1 BTHHDLLX1
XOut2_tri VSS En2 VDD_1V8 q Out2 BTHHDLLX1
Xq_reg q VSS rst VDD_1V8 In Write DLHRQHDLLX0
.ENDS

.SUBCKT latchtriestado_804 In Out1 Out2 En1 En2 Write rst VSS VDD_1V8
XOut1_tri VSS En1 VDD_1V8 q Out1 BTHHDLLX1
XOut2_tri VSS En2 VDD_1V8 q Out2 BTHHDLLX1
Xq_reg q VSS rst VDD_1V8 In Write DLHRQHDLLX0
.ENDS

.SUBCKT latchtriestado_803 In Out1 Out2 En1 En2 Write rst VSS VDD_1V8
XOut1_tri VSS En1 VDD_1V8 q Out1 BTHHDLLX1
XOut2_tri VSS En2 VDD_1V8 q Out2 BTHHDLLX1
Xq_reg q VSS rst VDD_1V8 In Write DLHRQHDLLX0
.ENDS

.SUBCKT latchtriestado_802 In Out1 Out2 En1 En2 Write rst VSS VDD_1V8
XOut1_tri VSS En1 VDD_1V8 q Out1 BTHHDLLX1
XOut2_tri VSS En2 VDD_1V8 q Out2 BTHHDLLX1
Xq_reg q VSS rst VDD_1V8 In Write DLHRQHDLLX0
.ENDS

.SUBCKT latchtriestado_801 In Out1 Out2 En1 En2 Write rst VSS VDD_1V8
XOut1_tri VSS En1 VDD_1V8 q Out1 BTHHDLLX1
XOut2_tri VSS En2 VDD_1V8 q Out2 BTHHDLLX1
Xq_reg q VSS rst VDD_1V8 In Write DLHRQHDLLX0
.ENDS

.SUBCKT latchtriestado_800 In Out1 Out2 En1 En2 Write rst VSS VDD_1V8
XOut1_tri VSS En1 VDD_1V8 q Out1 BTHHDLLX1
XOut2_tri VSS En2 VDD_1V8 q Out2 BTHHDLLX1
Xq_reg q VSS rst VDD_1V8 In Write DLHRQHDLLX0
.ENDS

.SUBCKT latchtriestado_799 In Out1 Out2 En1 En2 Write rst VSS VDD_1V8
XOut1_tri VSS En1 VDD_1V8 q Out1 BTHHDLLX1
XOut2_tri VSS En2 VDD_1V8 q Out2 BTHHDLLX1
Xq_reg q VSS rst VDD_1V8 In Write DLHRQHDLLX0
.ENDS

.SUBCKT latchtriestado_798 In Out1 Out2 En1 En2 Write rst VSS VDD_1V8
XOut1_tri VSS En1 VDD_1V8 q Out1 BTHHDLLX1
XOut2_tri VSS En2 VDD_1V8 q Out2 BTHHDLLX1
Xq_reg q VSS rst VDD_1V8 In Write DLHRQHDLLX0
.ENDS

.SUBCKT latchtriestado_797 In Out1 Out2 En1 En2 Write rst VSS VDD_1V8
XOut1_tri VSS En1 VDD_1V8 q Out1 BTHHDLLX1
XOut2_tri VSS En2 VDD_1V8 q Out2 BTHHDLLX1
Xq_reg q VSS rst VDD_1V8 In Write DLHRQHDLLX0
.ENDS

.SUBCKT latchtriestado_796 In Out1 Out2 En1 En2 Write rst VSS VDD_1V8
XOut1_tri VSS En1 VDD_1V8 q Out1 BTHHDLLX1
XOut2_tri VSS En2 VDD_1V8 q Out2 BTHHDLLX1
Xq_reg q VSS rst VDD_1V8 In Write DLHRQHDLLX0
.ENDS

.SUBCKT latchtriestado_795 In Out1 Out2 En1 En2 Write rst VSS VDD_1V8
XOut1_tri VSS En1 VDD_1V8 q Out1 BTHHDLLX1
XOut2_tri VSS En2 VDD_1V8 q Out2 BTHHDLLX1
Xq_reg q VSS rst VDD_1V8 In Write DLHRQHDLLX0
.ENDS

.SUBCKT latchtriestado_794 In Out1 Out2 En1 En2 Write rst VSS VDD_1V8
XOut1_tri VSS En1 VDD_1V8 q Out1 BTHHDLLX1
XOut2_tri VSS En2 VDD_1V8 q Out2 BTHHDLLX1
Xq_reg q VSS rst VDD_1V8 In Write DLHRQHDLLX0
.ENDS

.SUBCKT latchtriestado_793 In Out1 Out2 En1 En2 Write rst VSS VDD_1V8
XOut1_tri VSS En1 VDD_1V8 q Out1 BTHHDLLX1
XOut2_tri VSS En2 VDD_1V8 q Out2 BTHHDLLX1
Xq_reg q VSS rst VDD_1V8 In Write DLHRQHDLLX0
.ENDS

.SUBCKT latchtriestado_792 In Out1 Out2 En1 En2 Write rst VSS VDD_1V8
XOut1_tri VSS En1 VDD_1V8 q Out1 BTHHDLLX1
XOut2_tri VSS En2 VDD_1V8 q Out2 BTHHDLLX1
Xq_reg q VSS rst VDD_1V8 In Write DLHRQHDLLX0
.ENDS

.SUBCKT latchtriestado_791 In Out1 Out2 En1 En2 Write rst VSS VDD_1V8
XOut1_tri VSS En1 VDD_1V8 q Out1 BTHHDLLX1
XOut2_tri VSS En2 VDD_1V8 q Out2 BTHHDLLX1
Xq_reg q VSS rst VDD_1V8 In Write DLHRQHDLLX0
.ENDS

.SUBCKT latchtriestado_790 In Out1 Out2 En1 En2 Write rst VSS VDD_1V8
XOut1_tri VSS En1 VDD_1V8 q Out1 BTHHDLLX1
XOut2_tri VSS En2 VDD_1V8 q Out2 BTHHDLLX1
Xq_reg q VSS rst VDD_1V8 In Write DLHRQHDLLX0
.ENDS

.SUBCKT latchtriestado_789 In Out1 Out2 En1 En2 Write rst VSS VDD_1V8
XOut1_tri VSS En1 VDD_1V8 q Out1 BTHHDLLX1
XOut2_tri VSS En2 VDD_1V8 q Out2 BTHHDLLX1
Xq_reg q VSS rst VDD_1V8 In Write DLHRQHDLLX0
.ENDS

.SUBCKT latchtriestado_788 In Out1 Out2 En1 En2 Write rst VSS VDD_1V8
XOut1_tri VSS En1 VDD_1V8 q Out1 BTHHDLLX1
XOut2_tri VSS En2 VDD_1V8 q Out2 BTHHDLLX1
Xq_reg q VSS rst VDD_1V8 In Write DLHRQHDLLX0
.ENDS

.SUBCKT latchtriestado_787 In Out1 Out2 En1 En2 Write rst VSS VDD_1V8
XOut1_tri VSS En1 VDD_1V8 q Out1 BTHHDLLX1
XOut2_tri VSS En2 VDD_1V8 q Out2 BTHHDLLX1
Xq_reg q VSS rst VDD_1V8 In Write DLHRQHDLLX0
.ENDS

.SUBCKT latchtriestado_786 In Out1 Out2 En1 En2 Write rst VSS VDD_1V8
XOut1_tri VSS En1 VDD_1V8 q Out1 BTHHDLLX1
XOut2_tri VSS En2 VDD_1V8 q Out2 BTHHDLLX1
Xq_reg q VSS rst VDD_1V8 In Write DLHRQHDLLX0
.ENDS

.SUBCKT latchtriestado_785 In Out1 Out2 En1 En2 Write rst VSS VDD_1V8
XOut1_tri VSS En1 VDD_1V8 q Out1 BTHHDLLX1
XOut2_tri VSS En2 VDD_1V8 q Out2 BTHHDLLX1
Xq_reg q VSS rst VDD_1V8 In Write DLHRQHDLLX0
.ENDS

.SUBCKT latchtriestado_784 In Out1 Out2 En1 En2 Write rst VSS VDD_1V8
XOut1_tri VSS En1 VDD_1V8 q Out1 BTHHDLLX1
XOut2_tri VSS En2 VDD_1V8 q Out2 BTHHDLLX1
Xq_reg q VSS rst VDD_1V8 In Write DLHRQHDLLX0
.ENDS

.SUBCKT latchtriestado_783 In Out1 Out2 En1 En2 Write rst VSS VDD_1V8
XOut2_tri VSS En2 VDD_1V8 q Out2 BTHHDLLX1
XOut1_tri VSS En1 VDD_1V8 q Out1 BTHHDLLX1
Xq_reg q VSS rst VDD_1V8 In Write DLHRQHDLLX0
.ENDS

.SUBCKT latchtriestado_782 In Out1 Out2 En1 En2 Write rst VSS VDD_1V8
Xq_reg q VSS rst VDD_1V8 In Write DLHRQHDLLX0
XOut2_tri VSS En2 VDD_1V8 q Out2 BTHHDLLX1
XOut1_tri VSS En1 VDD_1V8 q Out1 BTHHDLLX1
.ENDS

.SUBCKT latchtriestado_781 In Out1 Out2 En1 En2 Write rst VSS VDD_1V8
Xq_reg q VSS rst VDD_1V8 In Write DLHRQHDLLX0
XOut2_tri VSS En2 VDD_1V8 q Out2 BTHHDLLX1
XOut1_tri VSS En1 VDD_1V8 q Out1 BTHHDLLX1
.ENDS

.SUBCKT latchtriestado_780 In Out1 Out2 En1 En2 Write rst VSS VDD_1V8
Xq_reg q VSS rst VDD_1V8 In Write DLHRQHDLLX0
XOut2_tri VSS En2 VDD_1V8 q Out2 BTHHDLLX1
XOut1_tri VSS En1 VDD_1V8 q Out1 BTHHDLLX1
.ENDS

.SUBCKT latchtriestado_779 In Out1 Out2 En1 En2 Write rst VSS VDD_1V8
Xq_reg q VSS rst VDD_1V8 In Write DLHRQHDLLX0
XOut1_tri VSS En1 VDD_1V8 q Out1 BTHHDLLX1
XOut2_tri VSS En2 VDD_1V8 q Out2 BTHHDLLX1
.ENDS

.SUBCKT latchtriestado_778 In Out1 Out2 En1 En2 Write rst VSS VDD_1V8
Xq_reg q VSS rst VDD_1V8 In Write DLHRQHDLLX0
XOut2_tri VSS En2 VDD_1V8 q Out2 BTHHDLLX1
XOut1_tri VSS En1 VDD_1V8 q Out1 BTHHDLLX1
.ENDS

.SUBCKT latchtriestado_777 In Out1 Out2 En1 En2 Write rst VSS VDD_1V8
XOut1_tri VSS En1 VDD_1V8 q Out1 BTHHDLLX1
XOut2_tri VSS En2 VDD_1V8 q Out2 BTHHDLLX1
Xq_reg q VSS rst VDD_1V8 In Write DLHRQHDLLX0
.ENDS

.SUBCKT latchtriestado_776 In Out1 Out2 En1 En2 Write rst VSS VDD_1V8
XOut1_tri VSS En1 VDD_1V8 q Out1 BTHHDLLX1
XOut2_tri VSS En2 VDD_1V8 q Out2 BTHHDLLX1
Xq_reg q VSS rst VDD_1V8 In Write DLHRQHDLLX0
.ENDS

.SUBCKT latchtriestado_775 In Out1 Out2 En1 En2 Write rst VSS VDD_1V8
XOut1_tri VSS En1 VDD_1V8 q Out1 BTHHDLLX1
XOut2_tri VSS En2 VDD_1V8 q Out2 BTHHDLLX1
Xq_reg q VSS rst VDD_1V8 In Write DLHRQHDLLX0
.ENDS

.SUBCKT latchtriestado_774 In Out1 Out2 En1 En2 Write rst VSS VDD_1V8
XOut1_tri VSS En1 VDD_1V8 q Out1 BTHHDLLX1
XOut2_tri VSS En2 VDD_1V8 q Out2 BTHHDLLX1
Xq_reg q VSS rst VDD_1V8 In Write DLHRQHDLLX0
.ENDS

.SUBCKT latchtriestado_773 In Out1 Out2 En1 En2 Write rst VSS VDD_1V8
XOut2_tri VSS En2 VDD_1V8 q Out2 BTHHDLLX1
XOut1_tri VSS En1 VDD_1V8 q Out1 BTHHDLLX1
Xq_reg q VSS rst VDD_1V8 In Write DLHRQHDLLX0
.ENDS

.SUBCKT latchtriestado_772 In Out1 Out2 En1 En2 Write rst VSS VDD_1V8
XOut2_tri VSS En2 VDD_1V8 q Out2 BTHHDLLX1
XOut1_tri VSS En1 VDD_1V8 q Out1 BTHHDLLX1
Xq_reg q VSS rst VDD_1V8 In Write DLHRQHDLLX0
.ENDS

.SUBCKT latchtriestado_771 In Out1 Out2 En1 En2 Write rst VSS VDD_1V8
XOut2_tri VSS En2 VDD_1V8 q Out2 BTHHDLLX1
XOut1_tri VSS En1 VDD_1V8 q Out1 BTHHDLLX1
Xq_reg q VSS rst VDD_1V8 In Write DLHRQHDLLX0
.ENDS

.SUBCKT latchtriestado_770 In Out1 Out2 En1 En2 Write rst VSS VDD_1V8
XOut1_tri VSS En1 VDD_1V8 q Out1 BTHHDLLX1
XOut2_tri VSS En2 VDD_1V8 q Out2 BTHHDLLX1
Xq_reg q VSS rst VDD_1V8 In Write DLHRQHDLLX0
.ENDS

.SUBCKT latchtriestado_769 In Out1 Out2 En1 En2 Write rst VSS VDD_1V8
XOut1_tri VSS En1 VDD_1V8 q Out1 BTHHDLLX1
XOut2_tri VSS En2 VDD_1V8 q Out2 BTHHDLLX1
Xq_reg q VSS rst VDD_1V8 In Write DLHRQHDLLX0
.ENDS

.SUBCKT latchtriestado_768 In Out1 Out2 En1 En2 Write rst VSS VDD_1V8
XOut1_tri VSS En1 VDD_1V8 q Out1 BTHHDLLX1
XOut2_tri VSS En2 VDD_1V8 q Out2 BTHHDLLX1
Xq_reg q VSS rst VDD_1V8 In Write DLHRQHDLLX0
.ENDS

.SUBCKT latchtriestado_767 In Out1 Out2 En1 En2 Write rst VSS VDD_1V8
XOut1_tri VSS En1 VDD_1V8 q Out1 BTHHDLLX1
XOut2_tri VSS En2 VDD_1V8 q Out2 BTHHDLLX1
Xq_reg q VSS rst VDD_1V8 In Write DLHRQHDLLX0
.ENDS

.SUBCKT latchtriestado_766 In Out1 Out2 En1 En2 Write rst VSS VDD_1V8
XOut1_tri VSS En1 VDD_1V8 q Out1 BTHHDLLX1
XOut2_tri VSS En2 VDD_1V8 q Out2 BTHHDLLX1
Xq_reg q VSS rst VDD_1V8 In Write DLHRQHDLLX0
.ENDS

.SUBCKT latchtriestado_765 In Out1 Out2 En1 En2 Write rst VSS VDD_1V8
XOut1_tri VSS En1 VDD_1V8 q Out1 BTHHDLLX1
XOut2_tri VSS En2 VDD_1V8 q Out2 BTHHDLLX1
Xq_reg q VSS rst VDD_1V8 In Write DLHRQHDLLX0
.ENDS

.SUBCKT latchtriestado_764 In Out1 Out2 En1 En2 Write rst VSS VDD_1V8
XOut1_tri VSS En1 VDD_1V8 q Out1 BTHHDLLX1
XOut2_tri VSS En2 VDD_1V8 q Out2 BTHHDLLX1
Xq_reg q VSS rst VDD_1V8 In Write DLHRQHDLLX0
.ENDS

.SUBCKT latchtriestado_763 In Out1 Out2 En1 En2 Write rst VSS VDD_1V8
XOut1_tri VSS En1 VDD_1V8 q Out1 BTHHDLLX1
XOut2_tri VSS En2 VDD_1V8 q Out2 BTHHDLLX1
Xq_reg q VSS rst VDD_1V8 In Write DLHRQHDLLX0
.ENDS

.SUBCKT latchtriestado_762 In Out1 Out2 En1 En2 Write rst VSS VDD_1V8
XOut1_tri VSS En1 VDD_1V8 q Out1 BTHHDLLX1
XOut2_tri VSS En2 VDD_1V8 q Out2 BTHHDLLX1
Xq_reg q VSS rst VDD_1V8 In Write DLHRQHDLLX0
.ENDS

.SUBCKT latchtriestado_761 In Out1 Out2 En1 En2 Write rst VSS VDD_1V8
XOut1_tri VSS En1 VDD_1V8 q Out1 BTHHDLLX1
XOut2_tri VSS En2 VDD_1V8 q Out2 BTHHDLLX1
Xq_reg q VSS rst VDD_1V8 In Write DLHRQHDLLX0
.ENDS

.SUBCKT latchtriestado_760 In Out1 Out2 En1 En2 Write rst VSS VDD_1V8
XOut1_tri VSS En1 VDD_1V8 q Out1 BTHHDLLX1
XOut2_tri VSS En2 VDD_1V8 q Out2 BTHHDLLX1
Xq_reg q VSS rst VDD_1V8 In Write DLHRQHDLLX0
.ENDS

.SUBCKT latchtriestado_759 In Out1 Out2 En1 En2 Write rst VSS VDD_1V8
XOut1_tri VSS En1 VDD_1V8 q Out1 BTHHDLLX1
XOut2_tri VSS En2 VDD_1V8 q Out2 BTHHDLLX1
Xq_reg q VSS rst VDD_1V8 In Write DLHRQHDLLX0
.ENDS

.SUBCKT latchtriestado_758 In Out1 Out2 En1 En2 Write rst VSS VDD_1V8
XOut1_tri VSS En1 VDD_1V8 q Out1 BTHHDLLX1
XOut2_tri VSS En2 VDD_1V8 q Out2 BTHHDLLX1
Xq_reg q VSS rst VDD_1V8 In Write DLHRQHDLLX0
.ENDS

.SUBCKT latchtriestado_757 In Out1 Out2 En1 En2 Write rst VSS VDD_1V8
XOut1_tri VSS En1 VDD_1V8 q Out1 BTHHDLLX1
XOut2_tri VSS En2 VDD_1V8 q Out2 BTHHDLLX1
Xq_reg q VSS rst VDD_1V8 In Write DLHRQHDLLX0
.ENDS

.SUBCKT latchtriestado_756 In Out1 Out2 En1 En2 Write rst VSS VDD_1V8
XOut1_tri VSS En1 VDD_1V8 q Out1 BTHHDLLX1
XOut2_tri VSS En2 VDD_1V8 q Out2 BTHHDLLX1
Xq_reg q VSS rst VDD_1V8 In Write DLHRQHDLLX0
.ENDS

.SUBCKT latchtriestado_755 In Out1 Out2 En1 En2 Write rst VSS VDD_1V8
XOut1_tri VSS En1 VDD_1V8 q Out1 BTHHDLLX1
XOut2_tri VSS En2 VDD_1V8 q Out2 BTHHDLLX1
Xq_reg q VSS rst VDD_1V8 In Write DLHRQHDLLX0
.ENDS

.SUBCKT latchtriestado_754 In Out1 Out2 En1 En2 Write rst VSS VDD_1V8
XOut1_tri VSS En1 VDD_1V8 q Out1 BTHHDLLX1
XOut2_tri VSS En2 VDD_1V8 q Out2 BTHHDLLX1
Xq_reg q VSS rst VDD_1V8 In Write DLHRQHDLLX0
.ENDS

.SUBCKT latchtriestado_753 In Out1 Out2 En1 En2 Write rst VSS VDD_1V8
XOut1_tri VSS En1 VDD_1V8 q Out1 BTHHDLLX1
XOut2_tri VSS En2 VDD_1V8 q Out2 BTHHDLLX1
Xq_reg q VSS rst VDD_1V8 In Write DLHRQHDLLX0
.ENDS

.SUBCKT latchtriestado_752 In Out1 Out2 En1 En2 Write rst VSS VDD_1V8
XOut1_tri VSS En1 VDD_1V8 q Out1 BTHHDLLX1
XOut2_tri VSS En2 VDD_1V8 q Out2 BTHHDLLX1
Xq_reg q VSS rst VDD_1V8 In Write DLHRQHDLLX0
.ENDS

.SUBCKT latchtriestado_751 In Out1 Out2 En1 En2 Write rst VSS VDD_1V8
XOut2_tri VSS En2 VDD_1V8 q Out2 BTHHDLLX1
XOut1_tri VSS En1 VDD_1V8 q Out1 BTHHDLLX1
Xq_reg q VSS rst VDD_1V8 In Write DLHRQHDLLX0
.ENDS

.SUBCKT latchtriestado_750 In Out1 Out2 En1 En2 Write rst VSS VDD_1V8
Xq_reg q VSS rst VDD_1V8 In Write DLHRQHDLLX0
XOut2_tri VSS En2 VDD_1V8 q Out2 BTHHDLLX1
XOut1_tri VSS En1 VDD_1V8 q Out1 BTHHDLLX1
.ENDS

.SUBCKT latchtriestado_749 In Out1 Out2 En1 En2 Write rst VSS VDD_1V8
Xq_reg q VSS rst VDD_1V8 In Write DLHRQHDLLX0
XOut2_tri VSS En2 VDD_1V8 q Out2 BTHHDLLX1
XOut1_tri VSS En1 VDD_1V8 q Out1 BTHHDLLX1
.ENDS

.SUBCKT latchtriestado_748 In Out1 Out2 En1 En2 Write rst VSS VDD_1V8
Xq_reg q VSS rst VDD_1V8 In Write DLHRQHDLLX0
XOut2_tri VSS En2 VDD_1V8 q Out2 BTHHDLLX1
XOut1_tri VSS En1 VDD_1V8 q Out1 BTHHDLLX1
.ENDS

.SUBCKT latchtriestado_747 In Out1 Out2 En1 En2 Write rst VSS VDD_1V8
Xq_reg q VSS rst VDD_1V8 In Write DLHRQHDLLX0
XOut2_tri VSS En2 VDD_1V8 q Out2 BTHHDLLX1
XOut1_tri VSS En1 VDD_1V8 q Out1 BTHHDLLX1
.ENDS

.SUBCKT latchtriestado_746 In Out1 Out2 En1 En2 Write rst VSS VDD_1V8
Xq_reg q VSS rst VDD_1V8 In Write DLHRQHDLLX0
XOut1_tri VSS En1 VDD_1V8 q Out1 BTHHDLLX1
XOut2_tri VSS En2 VDD_1V8 q Out2 BTHHDLLX1
.ENDS

.SUBCKT latchtriestado_745 In Out1 Out2 En1 En2 Write rst VSS VDD_1V8
XOut1_tri VSS En1 VDD_1V8 q Out1 BTHHDLLX1
XOut2_tri VSS En2 VDD_1V8 q Out2 BTHHDLLX1
Xq_reg q VSS rst VDD_1V8 In Write DLHRQHDLLX0
.ENDS

.SUBCKT latchtriestado_744 In Out1 Out2 En1 En2 Write rst VSS VDD_1V8
XOut2_tri VSS En2 VDD_1V8 q Out2 BTHHDLLX1
XOut1_tri VSS En1 VDD_1V8 q Out1 BTHHDLLX1
Xq_reg q VSS rst VDD_1V8 In Write DLHRQHDLLX0
.ENDS

.SUBCKT latchtriestado_743 In Out1 Out2 En1 En2 Write rst VSS VDD_1V8
XOut1_tri VSS En1 VDD_1V8 q Out1 BTHHDLLX1
XOut2_tri VSS En2 VDD_1V8 q Out2 BTHHDLLX1
Xq_reg q VSS rst VDD_1V8 In Write DLHRQHDLLX0
.ENDS

.SUBCKT latchtriestado_742 In Out1 Out2 En1 En2 Write rst VSS VDD_1V8
XOut1_tri VSS En1 VDD_1V8 q Out1 BTHHDLLX1
XOut2_tri VSS En2 VDD_1V8 q Out2 BTHHDLLX1
Xq_reg q VSS rst VDD_1V8 In Write DLHRQHDLLX0
.ENDS

.SUBCKT latchtriestado_741 In Out1 Out2 En1 En2 Write rst VSS VDD_1V8
XOut1_tri VSS En1 VDD_1V8 q Out1 BTHHDLLX1
XOut2_tri VSS En2 VDD_1V8 q Out2 BTHHDLLX1
Xq_reg q VSS rst VDD_1V8 In Write DLHRQHDLLX0
.ENDS

.SUBCKT latchtriestado_740 In Out1 Out2 En1 En2 Write rst VSS VDD_1V8
XOut2_tri VSS En2 VDD_1V8 q Out2 BTHHDLLX1
XOut1_tri VSS En1 VDD_1V8 q Out1 BTHHDLLX1
Xq_reg q VSS rst VDD_1V8 In Write DLHRQHDLLX0
.ENDS

.SUBCKT latchtriestado_739 In Out1 Out2 En1 En2 Write rst VSS VDD_1V8
XOut1_tri VSS En1 VDD_1V8 q Out1 BTHHDLLX1
XOut2_tri VSS En2 VDD_1V8 q Out2 BTHHDLLX1
Xq_reg q VSS rst VDD_1V8 In Write DLHRQHDLLX0
.ENDS

.SUBCKT latchtriestado_738 In Out1 Out2 En1 En2 Write rst VSS VDD_1V8
XOut1_tri VSS En1 VDD_1V8 q Out1 BTHHDLLX1
XOut2_tri VSS En2 VDD_1V8 q Out2 BTHHDLLX1
Xq_reg q VSS rst VDD_1V8 In Write DLHRQHDLLX0
.ENDS

.SUBCKT latchtriestado_737 In Out1 Out2 En1 En2 Write rst VSS VDD_1V8
XOut2_tri VSS En2 VDD_1V8 q Out2 BTHHDLLX1
XOut1_tri VSS En1 VDD_1V8 q Out1 BTHHDLLX1
Xq_reg q VSS rst VDD_1V8 In Write DLHRQHDLLX0
.ENDS

.SUBCKT latchtriestado_736 In Out1 Out2 En1 En2 Write rst VSS VDD_1V8
XOut2_tri VSS En2 VDD_1V8 q Out2 BTHHDLLX1
XOut1_tri VSS En1 VDD_1V8 q Out1 BTHHDLLX1
Xq_reg q VSS rst VDD_1V8 In Write DLHRQHDLLX0
.ENDS

.SUBCKT latchtriestado_735 In Out1 Out2 En1 En2 Write rst VSS VDD_1V8
XOut1_tri VSS En1 VDD_1V8 q Out1 BTHHDLLX1
XOut2_tri VSS En2 VDD_1V8 q Out2 BTHHDLLX1
Xq_reg q VSS rst VDD_1V8 In Write DLHRQHDLLX0
.ENDS

.SUBCKT latchtriestado_734 In Out1 Out2 En1 En2 Write rst VSS VDD_1V8
XOut1_tri VSS En1 VDD_1V8 q Out1 BTHHDLLX1
XOut2_tri VSS En2 VDD_1V8 q Out2 BTHHDLLX1
Xq_reg q VSS rst VDD_1V8 In Write DLHRQHDLLX0
.ENDS

.SUBCKT latchtriestado_733 In Out1 Out2 En1 En2 Write rst VSS VDD_1V8
XOut1_tri VSS En1 VDD_1V8 q Out1 BTHHDLLX1
XOut2_tri VSS En2 VDD_1V8 q Out2 BTHHDLLX1
Xq_reg q VSS rst VDD_1V8 In Write DLHRQHDLLX0
.ENDS

.SUBCKT latchtriestado_732 In Out1 Out2 En1 En2 Write rst VSS VDD_1V8
XOut1_tri VSS En1 VDD_1V8 q Out1 BTHHDLLX1
XOut2_tri VSS En2 VDD_1V8 q Out2 BTHHDLLX1
Xq_reg q VSS rst VDD_1V8 In Write DLHRQHDLLX0
.ENDS

.SUBCKT latchtriestado_731 In Out1 Out2 En1 En2 Write rst VSS VDD_1V8
XOut1_tri VSS En1 VDD_1V8 q Out1 BTHHDLLX1
XOut2_tri VSS En2 VDD_1V8 q Out2 BTHHDLLX1
Xq_reg q VSS rst VDD_1V8 In Write DLHRQHDLLX0
.ENDS

.SUBCKT latchtriestado_730 In Out1 Out2 En1 En2 Write rst VSS VDD_1V8
XOut1_tri VSS En1 VDD_1V8 q Out1 BTHHDLLX1
XOut2_tri VSS En2 VDD_1V8 q Out2 BTHHDLLX1
Xq_reg q VSS rst VDD_1V8 In Write DLHRQHDLLX0
.ENDS

.SUBCKT latchtriestado_729 In Out1 Out2 En1 En2 Write rst VSS VDD_1V8
XOut1_tri VSS En1 VDD_1V8 q Out1 BTHHDLLX1
XOut2_tri VSS En2 VDD_1V8 q Out2 BTHHDLLX1
Xq_reg q VSS rst VDD_1V8 In Write DLHRQHDLLX0
.ENDS

.SUBCKT latchtriestado_728 In Out1 Out2 En1 En2 Write rst VSS VDD_1V8
XOut1_tri VSS En1 VDD_1V8 q Out1 BTHHDLLX1
XOut2_tri VSS En2 VDD_1V8 q Out2 BTHHDLLX1
Xq_reg q VSS rst VDD_1V8 In Write DLHRQHDLLX0
.ENDS

.SUBCKT latchtriestado_727 In Out1 Out2 En1 En2 Write rst VSS VDD_1V8
XOut1_tri VSS En1 VDD_1V8 q Out1 BTHHDLLX1
XOut2_tri VSS En2 VDD_1V8 q Out2 BTHHDLLX1
Xq_reg q VSS rst VDD_1V8 In Write DLHRQHDLLX0
.ENDS

.SUBCKT latchtriestado_726 In Out1 Out2 En1 En2 Write rst VSS VDD_1V8
XOut1_tri VSS En1 VDD_1V8 q Out1 BTHHDLLX1
XOut2_tri VSS En2 VDD_1V8 q Out2 BTHHDLLX1
Xq_reg q VSS rst VDD_1V8 In Write DLHRQHDLLX0
.ENDS

.SUBCKT latchtriestado_725 In Out1 Out2 En1 En2 Write rst VSS VDD_1V8
XOut1_tri VSS En1 VDD_1V8 q Out1 BTHHDLLX1
XOut2_tri VSS En2 VDD_1V8 q Out2 BTHHDLLX1
Xq_reg q VSS rst VDD_1V8 In Write DLHRQHDLLX0
.ENDS

.SUBCKT latchtriestado_724 In Out1 Out2 En1 En2 Write rst VSS VDD_1V8
XOut1_tri VSS En1 VDD_1V8 q Out1 BTHHDLLX1
XOut2_tri VSS En2 VDD_1V8 q Out2 BTHHDLLX1
Xq_reg q VSS rst VDD_1V8 In Write DLHRQHDLLX0
.ENDS

.SUBCKT latchtriestado_723 In Out1 Out2 En1 En2 Write rst VSS VDD_1V8
XOut1_tri VSS En1 VDD_1V8 q Out1 BTHHDLLX1
XOut2_tri VSS En2 VDD_1V8 q Out2 BTHHDLLX1
Xq_reg q VSS rst VDD_1V8 In Write DLHRQHDLLX0
.ENDS

.SUBCKT latchtriestado_722 In Out1 Out2 En1 En2 Write rst VSS VDD_1V8
XOut1_tri VSS En1 VDD_1V8 q Out1 BTHHDLLX1
XOut2_tri VSS En2 VDD_1V8 q Out2 BTHHDLLX1
Xq_reg q VSS rst VDD_1V8 In Write DLHRQHDLLX0
.ENDS

.SUBCKT latchtriestado_721 In Out1 Out2 En1 En2 Write rst VSS VDD_1V8
XOut1_tri VSS En1 VDD_1V8 q Out1 BTHHDLLX1
XOut2_tri VSS En2 VDD_1V8 q Out2 BTHHDLLX1
Xq_reg q VSS rst VDD_1V8 In Write DLHRQHDLLX0
.ENDS

.SUBCKT latchtriestado_720 In Out1 Out2 En1 En2 Write rst VSS VDD_1V8
XOut1_tri VSS En1 VDD_1V8 q Out1 BTHHDLLX1
XOut2_tri VSS En2 VDD_1V8 q Out2 BTHHDLLX1
Xq_reg q VSS rst VDD_1V8 In Write DLHRQHDLLX0
.ENDS

.SUBCKT latchtriestado_719 In Out1 Out2 En1 En2 Write rst VSS VDD_1V8
XOut2_tri VSS En2 VDD_1V8 q Out2 BTHHDLLX1
XOut1_tri VSS En1 VDD_1V8 q Out1 BTHHDLLX1
Xq_reg q VSS rst VDD_1V8 In Write DLHRQHDLLX0
.ENDS

.SUBCKT latchtriestado_718 In Out1 Out2 En1 En2 Write rst VSS VDD_1V8
Xq_reg q VSS rst VDD_1V8 In Write DLHRQHDLLX0
XOut2_tri VSS En2 VDD_1V8 q Out2 BTHHDLLX1
XOut1_tri VSS En1 VDD_1V8 q Out1 BTHHDLLX1
.ENDS

.SUBCKT latchtriestado_717 In Out1 Out2 En1 En2 Write rst VSS VDD_1V8
Xq_reg q VSS rst VDD_1V8 In Write DLHRQHDLLX0
XOut2_tri VSS En2 VDD_1V8 q Out2 BTHHDLLX1
XOut1_tri VSS En1 VDD_1V8 q Out1 BTHHDLLX1
.ENDS

.SUBCKT latchtriestado_716 In Out1 Out2 En1 En2 Write rst VSS VDD_1V8
Xq_reg q VSS rst VDD_1V8 In Write DLHRQHDLLX0
XOut2_tri VSS En2 VDD_1V8 q Out2 BTHHDLLX1
XOut1_tri VSS En1 VDD_1V8 q Out1 BTHHDLLX1
.ENDS

.SUBCKT latchtriestado_715 In Out1 Out2 En1 En2 Write rst VSS VDD_1V8
Xq_reg q VSS rst VDD_1V8 In Write DLHRQHDLLX0
XOut2_tri VSS En2 VDD_1V8 q Out2 BTHHDLLX1
XOut1_tri VSS En1 VDD_1V8 q Out1 BTHHDLLX1
.ENDS

.SUBCKT latchtriestado_714 In Out1 Out2 En1 En2 Write rst VSS VDD_1V8
Xq_reg q VSS rst VDD_1V8 In Write DLHRQHDLLX0
XOut2_tri VSS En2 VDD_1V8 q Out2 BTHHDLLX1
XOut1_tri VSS En1 VDD_1V8 q Out1 BTHHDLLX1
.ENDS

.SUBCKT latchtriestado_713 In Out1 Out2 En1 En2 Write rst VSS VDD_1V8
XOut1_tri VSS En1 VDD_1V8 q Out1 BTHHDLLX1
XOut2_tri VSS En2 VDD_1V8 q Out2 BTHHDLLX1
Xq_reg q VSS rst VDD_1V8 In Write DLHRQHDLLX0
.ENDS

.SUBCKT latchtriestado_712 In Out1 Out2 En1 En2 Write rst VSS VDD_1V8
XOut1_tri VSS En1 VDD_1V8 q Out1 BTHHDLLX1
XOut2_tri VSS En2 VDD_1V8 q Out2 BTHHDLLX1
Xq_reg q VSS rst VDD_1V8 In Write DLHRQHDLLX0
.ENDS

.SUBCKT latchtriestado_711 In Out1 Out2 En1 En2 Write rst VSS VDD_1V8
XOut2_tri VSS En2 VDD_1V8 q Out2 BTHHDLLX1
XOut1_tri VSS En1 VDD_1V8 q Out1 BTHHDLLX1
Xq_reg q VSS rst VDD_1V8 In Write DLHRQHDLLX0
.ENDS

.SUBCKT latchtriestado_710 In Out1 Out2 En1 En2 Write rst VSS VDD_1V8
XOut1_tri VSS En1 VDD_1V8 q Out1 BTHHDLLX1
XOut2_tri VSS En2 VDD_1V8 q Out2 BTHHDLLX1
Xq_reg q VSS rst VDD_1V8 In Write DLHRQHDLLX0
.ENDS

.SUBCKT latchtriestado_709 In Out1 Out2 En1 En2 Write rst VSS VDD_1V8
XOut1_tri VSS En1 VDD_1V8 q Out1 BTHHDLLX1
XOut2_tri VSS En2 VDD_1V8 q Out2 BTHHDLLX1
Xq_reg q VSS rst VDD_1V8 In Write DLHRQHDLLX0
.ENDS

.SUBCKT latchtriestado_708 In Out1 Out2 En1 En2 Write rst VSS VDD_1V8
XOut1_tri VSS En1 VDD_1V8 q Out1 BTHHDLLX1
XOut2_tri VSS En2 VDD_1V8 q Out2 BTHHDLLX1
Xq_reg q VSS rst VDD_1V8 In Write DLHRQHDLLX0
.ENDS

.SUBCKT latchtriestado_707 In Out1 Out2 En1 En2 Write rst VSS VDD_1V8
XOut1_tri VSS En1 VDD_1V8 q Out1 BTHHDLLX1
XOut2_tri VSS En2 VDD_1V8 q Out2 BTHHDLLX1
Xq_reg q VSS rst VDD_1V8 In Write DLHRQHDLLX0
.ENDS

.SUBCKT latchtriestado_706 In Out1 Out2 En1 En2 Write rst VSS VDD_1V8
XOut1_tri VSS En1 VDD_1V8 q Out1 BTHHDLLX1
XOut2_tri VSS En2 VDD_1V8 q Out2 BTHHDLLX1
Xq_reg q VSS rst VDD_1V8 In Write DLHRQHDLLX0
.ENDS

.SUBCKT latchtriestado_705 In Out1 Out2 En1 En2 Write rst VSS VDD_1V8
XOut1_tri VSS En1 VDD_1V8 q Out1 BTHHDLLX1
XOut2_tri VSS En2 VDD_1V8 q Out2 BTHHDLLX1
Xq_reg q VSS rst VDD_1V8 In Write DLHRQHDLLX0
.ENDS

.SUBCKT latchtriestado_704 In Out1 Out2 En1 En2 Write rst VSS VDD_1V8
XOut1_tri VSS En1 VDD_1V8 q Out1 BTHHDLLX1
XOut2_tri VSS En2 VDD_1V8 q Out2 BTHHDLLX1
Xq_reg q VSS rst VDD_1V8 In Write DLHRQHDLLX0
.ENDS

.SUBCKT latchtriestado_703 In Out1 Out2 En1 En2 Write rst VSS VDD_1V8
XOut1_tri VSS En1 VDD_1V8 q Out1 BTHHDLLX1
XOut2_tri VSS En2 VDD_1V8 q Out2 BTHHDLLX1
Xq_reg q VSS rst VDD_1V8 In Write DLHRQHDLLX0
.ENDS

.SUBCKT latchtriestado_702 In Out1 Out2 En1 En2 Write rst VSS VDD_1V8
XOut1_tri VSS En1 VDD_1V8 q Out1 BTHHDLLX1
XOut2_tri VSS En2 VDD_1V8 q Out2 BTHHDLLX1
Xq_reg q VSS rst VDD_1V8 In Write DLHRQHDLLX0
.ENDS

.SUBCKT latchtriestado_701 In Out1 Out2 En1 En2 Write rst VSS VDD_1V8
XOut1_tri VSS En1 VDD_1V8 q Out1 BTHHDLLX1
XOut2_tri VSS En2 VDD_1V8 q Out2 BTHHDLLX1
Xq_reg q VSS rst VDD_1V8 In Write DLHRQHDLLX0
.ENDS

.SUBCKT latchtriestado_700 In Out1 Out2 En1 En2 Write rst VSS VDD_1V8
XOut1_tri VSS En1 VDD_1V8 q Out1 BTHHDLLX1
XOut2_tri VSS En2 VDD_1V8 q Out2 BTHHDLLX1
Xq_reg q VSS rst VDD_1V8 In Write DLHRQHDLLX0
.ENDS

.SUBCKT latchtriestado_699 In Out1 Out2 En1 En2 Write rst VSS VDD_1V8
XOut1_tri VSS En1 VDD_1V8 q Out1 BTHHDLLX1
XOut2_tri VSS En2 VDD_1V8 q Out2 BTHHDLLX1
Xq_reg q VSS rst VDD_1V8 In Write DLHRQHDLLX0
.ENDS

.SUBCKT latchtriestado_698 In Out1 Out2 En1 En2 Write rst VSS VDD_1V8
XOut1_tri VSS En1 VDD_1V8 q Out1 BTHHDLLX1
XOut2_tri VSS En2 VDD_1V8 q Out2 BTHHDLLX1
Xq_reg q VSS rst VDD_1V8 In Write DLHRQHDLLX0
.ENDS

.SUBCKT latchtriestado_697 In Out1 Out2 En1 En2 Write rst VSS VDD_1V8
XOut1_tri VSS En1 VDD_1V8 q Out1 BTHHDLLX1
XOut2_tri VSS En2 VDD_1V8 q Out2 BTHHDLLX1
Xq_reg q VSS rst VDD_1V8 In Write DLHRQHDLLX0
.ENDS

.SUBCKT latchtriestado_696 In Out1 Out2 En1 En2 Write rst VSS VDD_1V8
XOut1_tri VSS En1 VDD_1V8 q Out1 BTHHDLLX1
XOut2_tri VSS En2 VDD_1V8 q Out2 BTHHDLLX1
Xq_reg q VSS rst VDD_1V8 In Write DLHRQHDLLX0
.ENDS

.SUBCKT latchtriestado_695 In Out1 Out2 En1 En2 Write rst VSS VDD_1V8
XOut1_tri VSS En1 VDD_1V8 q Out1 BTHHDLLX1
XOut2_tri VSS En2 VDD_1V8 q Out2 BTHHDLLX1
Xq_reg q VSS rst VDD_1V8 In Write DLHRQHDLLX0
.ENDS

.SUBCKT latchtriestado_694 In Out1 Out2 En1 En2 Write rst VSS VDD_1V8
XOut1_tri VSS En1 VDD_1V8 q Out1 BTHHDLLX1
XOut2_tri VSS En2 VDD_1V8 q Out2 BTHHDLLX1
Xq_reg q VSS rst VDD_1V8 In Write DLHRQHDLLX0
.ENDS

.SUBCKT latchtriestado_693 In Out1 Out2 En1 En2 Write rst VSS VDD_1V8
XOut1_tri VSS En1 VDD_1V8 q Out1 BTHHDLLX1
XOut2_tri VSS En2 VDD_1V8 q Out2 BTHHDLLX1
Xq_reg q VSS rst VDD_1V8 In Write DLHRQHDLLX0
.ENDS

.SUBCKT latchtriestado_692 In Out1 Out2 En1 En2 Write rst VSS VDD_1V8
XOut1_tri VSS En1 VDD_1V8 q Out1 BTHHDLLX1
XOut2_tri VSS En2 VDD_1V8 q Out2 BTHHDLLX1
Xq_reg q VSS rst VDD_1V8 In Write DLHRQHDLLX0
.ENDS

.SUBCKT latchtriestado_691 In Out1 Out2 En1 En2 Write rst VSS VDD_1V8
XOut2_tri VSS En2 VDD_1V8 q Out2 BTHHDLLX1
XOut1_tri VSS En1 VDD_1V8 q Out1 BTHHDLLX1
Xq_reg q VSS rst VDD_1V8 In Write DLHRQHDLLX0
.ENDS

.SUBCKT latchtriestado_690 In Out1 Out2 En1 En2 Write rst VSS VDD_1V8
XOut2_tri VSS En2 VDD_1V8 q Out2 BTHHDLLX1
XOut1_tri VSS En1 VDD_1V8 q Out1 BTHHDLLX1
Xq_reg q VSS rst VDD_1V8 In Write DLHRQHDLLX0
.ENDS

.SUBCKT latchtriestado_689 In Out1 Out2 En1 En2 Write rst VSS VDD_1V8
XOut2_tri VSS En2 VDD_1V8 q Out2 BTHHDLLX1
XOut1_tri VSS En1 VDD_1V8 q Out1 BTHHDLLX1
Xq_reg q VSS rst VDD_1V8 In Write DLHRQHDLLX0
.ENDS

.SUBCKT latchtriestado_688 In Out1 Out2 En1 En2 Write rst VSS VDD_1V8
XOut2_tri VSS En2 VDD_1V8 q Out2 BTHHDLLX1
XOut1_tri VSS En1 VDD_1V8 q Out1 BTHHDLLX1
Xq_reg q VSS rst VDD_1V8 In Write DLHRQHDLLX0
.ENDS

.SUBCKT latchtriestado_687 In Out1 Out2 En1 En2 Write rst VSS VDD_1V8
XOut2_tri VSS En2 VDD_1V8 q Out2 BTHHDLLX1
XOut1_tri VSS En1 VDD_1V8 q Out1 BTHHDLLX1
Xq_reg q VSS rst VDD_1V8 In Write DLHRQHDLLX0
.ENDS

.SUBCKT latchtriestado_686 In Out1 Out2 En1 En2 Write rst VSS VDD_1V8
Xq_reg q VSS rst VDD_1V8 In Write DLHRQHDLLX0
XOut2_tri VSS En2 VDD_1V8 q Out2 BTHHDLLX1
XOut1_tri VSS En1 VDD_1V8 q Out1 BTHHDLLX1
.ENDS

.SUBCKT latchtriestado_685 In Out1 Out2 En1 En2 Write rst VSS VDD_1V8
Xq_reg q VSS rst VDD_1V8 In Write DLHRQHDLLX0
XOut2_tri VSS En2 VDD_1V8 q Out2 BTHHDLLX1
XOut1_tri VSS En1 VDD_1V8 q Out1 BTHHDLLX1
.ENDS

.SUBCKT latchtriestado_684 In Out1 Out2 En1 En2 Write rst VSS VDD_1V8
Xq_reg q VSS rst VDD_1V8 In Write DLHRQHDLLX0
XOut2_tri VSS En2 VDD_1V8 q Out2 BTHHDLLX1
XOut1_tri VSS En1 VDD_1V8 q Out1 BTHHDLLX1
.ENDS

.SUBCKT latchtriestado_683 In Out1 Out2 En1 En2 Write rst VSS VDD_1V8
Xq_reg q VSS rst VDD_1V8 In Write DLHRQHDLLX0
XOut1_tri VSS En1 VDD_1V8 q Out1 BTHHDLLX1
XOut2_tri VSS En2 VDD_1V8 q Out2 BTHHDLLX1
.ENDS

.SUBCKT latchtriestado_682 In Out1 Out2 En1 En2 Write rst VSS VDD_1V8
Xq_reg q VSS rst VDD_1V8 In Write DLHRQHDLLX0
XOut1_tri VSS En1 VDD_1V8 q Out1 BTHHDLLX1
XOut2_tri VSS En2 VDD_1V8 q Out2 BTHHDLLX1
.ENDS

.SUBCKT latchtriestado_681 In Out1 Out2 En1 En2 Write rst VSS VDD_1V8
XOut1_tri VSS En1 VDD_1V8 q Out1 BTHHDLLX1
XOut2_tri VSS En2 VDD_1V8 q Out2 BTHHDLLX1
Xq_reg q VSS rst VDD_1V8 In Write DLHRQHDLLX0
.ENDS

.SUBCKT latchtriestado_680 In Out1 Out2 En1 En2 Write rst VSS VDD_1V8
XOut2_tri VSS En2 VDD_1V8 q Out2 BTHHDLLX1
XOut1_tri VSS En1 VDD_1V8 q Out1 BTHHDLLX1
Xq_reg q VSS rst VDD_1V8 In Write DLHRQHDLLX0
.ENDS

.SUBCKT latchtriestado_679 In Out1 Out2 En1 En2 Write rst VSS VDD_1V8
XOut2_tri VSS En2 VDD_1V8 q Out2 BTHHDLLX1
XOut1_tri VSS En1 VDD_1V8 q Out1 BTHHDLLX1
Xq_reg q VSS rst VDD_1V8 In Write DLHRQHDLLX0
.ENDS

.SUBCKT latchtriestado_678 In Out1 Out2 En1 En2 Write rst VSS VDD_1V8
XOut1_tri VSS En1 VDD_1V8 q Out1 BTHHDLLX1
XOut2_tri VSS En2 VDD_1V8 q Out2 BTHHDLLX1
Xq_reg q VSS rst VDD_1V8 In Write DLHRQHDLLX0
.ENDS

.SUBCKT latchtriestado_677 In Out1 Out2 En1 En2 Write rst VSS VDD_1V8
XOut2_tri VSS En2 VDD_1V8 q Out2 BTHHDLLX1
XOut1_tri VSS En1 VDD_1V8 q Out1 BTHHDLLX1
Xq_reg q VSS rst VDD_1V8 In Write DLHRQHDLLX0
.ENDS

.SUBCKT latchtriestado_676 In Out1 Out2 En1 En2 Write rst VSS VDD_1V8
XOut2_tri VSS En2 VDD_1V8 q Out2 BTHHDLLX1
XOut1_tri VSS En1 VDD_1V8 q Out1 BTHHDLLX1
Xq_reg q VSS rst VDD_1V8 In Write DLHRQHDLLX0
.ENDS

.SUBCKT latchtriestado_675 In Out1 Out2 En1 En2 Write rst VSS VDD_1V8
XOut2_tri VSS En2 VDD_1V8 q Out2 BTHHDLLX1
XOut1_tri VSS En1 VDD_1V8 q Out1 BTHHDLLX1
Xq_reg q VSS rst VDD_1V8 In Write DLHRQHDLLX0
.ENDS

.SUBCKT latchtriestado_674 In Out1 Out2 En1 En2 Write rst VSS VDD_1V8
XOut2_tri VSS En2 VDD_1V8 q Out2 BTHHDLLX1
XOut1_tri VSS En1 VDD_1V8 q Out1 BTHHDLLX1
Xq_reg q VSS rst VDD_1V8 In Write DLHRQHDLLX0
.ENDS

.SUBCKT latchtriestado_673 In Out1 Out2 En1 En2 Write rst VSS VDD_1V8
XOut2_tri VSS En2 VDD_1V8 q Out2 BTHHDLLX1
XOut1_tri VSS En1 VDD_1V8 q Out1 BTHHDLLX1
Xq_reg q VSS rst VDD_1V8 In Write DLHRQHDLLX0
.ENDS

.SUBCKT latchtriestado_672 In Out1 Out2 En1 En2 Write rst VSS VDD_1V8
XOut1_tri VSS En1 VDD_1V8 q Out1 BTHHDLLX1
XOut2_tri VSS En2 VDD_1V8 q Out2 BTHHDLLX1
Xq_reg q VSS rst VDD_1V8 In Write DLHRQHDLLX0
.ENDS

.SUBCKT latchtriestado_671 In Out1 Out2 En1 En2 Write rst VSS VDD_1V8
XOut1_tri VSS En1 VDD_1V8 q Out1 BTHHDLLX1
XOut2_tri VSS En2 VDD_1V8 q Out2 BTHHDLLX1
Xq_reg q VSS rst VDD_1V8 In Write DLHRQHDLLX0
.ENDS

.SUBCKT latchtriestado_670 In Out1 Out2 En1 En2 Write rst VSS VDD_1V8
XOut1_tri VSS En1 VDD_1V8 q Out1 BTHHDLLX1
XOut2_tri VSS En2 VDD_1V8 q Out2 BTHHDLLX1
Xq_reg q VSS rst VDD_1V8 In Write DLHRQHDLLX0
.ENDS

.SUBCKT latchtriestado_669 In Out1 Out2 En1 En2 Write rst VSS VDD_1V8
XOut1_tri VSS En1 VDD_1V8 q Out1 BTHHDLLX1
XOut2_tri VSS En2 VDD_1V8 q Out2 BTHHDLLX1
Xq_reg q VSS rst VDD_1V8 In Write DLHRQHDLLX0
.ENDS

.SUBCKT latchtriestado_668 In Out1 Out2 En1 En2 Write rst VSS VDD_1V8
XOut1_tri VSS En1 VDD_1V8 q Out1 BTHHDLLX1
XOut2_tri VSS En2 VDD_1V8 q Out2 BTHHDLLX1
Xq_reg q VSS rst VDD_1V8 In Write DLHRQHDLLX0
.ENDS

.SUBCKT latchtriestado_667 In Out1 Out2 En1 En2 Write rst VSS VDD_1V8
XOut1_tri VSS En1 VDD_1V8 q Out1 BTHHDLLX1
XOut2_tri VSS En2 VDD_1V8 q Out2 BTHHDLLX1
Xq_reg q VSS rst VDD_1V8 In Write DLHRQHDLLX0
.ENDS

.SUBCKT latchtriestado_666 In Out1 Out2 En1 En2 Write rst VSS VDD_1V8
XOut1_tri VSS En1 VDD_1V8 q Out1 BTHHDLLX1
XOut2_tri VSS En2 VDD_1V8 q Out2 BTHHDLLX1
Xq_reg q VSS rst VDD_1V8 In Write DLHRQHDLLX0
.ENDS

.SUBCKT latchtriestado_665 In Out1 Out2 En1 En2 Write rst VSS VDD_1V8
XOut1_tri VSS En1 VDD_1V8 q Out1 BTHHDLLX1
XOut2_tri VSS En2 VDD_1V8 q Out2 BTHHDLLX1
Xq_reg q VSS rst VDD_1V8 In Write DLHRQHDLLX0
.ENDS

.SUBCKT latchtriestado_664 In Out1 Out2 En1 En2 Write rst VSS VDD_1V8
XOut1_tri VSS En1 VDD_1V8 q Out1 BTHHDLLX1
XOut2_tri VSS En2 VDD_1V8 q Out2 BTHHDLLX1
Xq_reg q VSS rst VDD_1V8 In Write DLHRQHDLLX0
.ENDS

.SUBCKT latchtriestado_663 In Out1 Out2 En1 En2 Write rst VSS VDD_1V8
XOut1_tri VSS En1 VDD_1V8 q Out1 BTHHDLLX1
XOut2_tri VSS En2 VDD_1V8 q Out2 BTHHDLLX1
Xq_reg q VSS rst VDD_1V8 In Write DLHRQHDLLX0
.ENDS

.SUBCKT latchtriestado_662 In Out1 Out2 En1 En2 Write rst VSS VDD_1V8
XOut2_tri VSS En2 VDD_1V8 q Out2 BTHHDLLX1
XOut1_tri VSS En1 VDD_1V8 q Out1 BTHHDLLX1
Xq_reg q VSS rst VDD_1V8 In Write DLHRQHDLLX0
.ENDS

.SUBCKT latchtriestado_661 In Out1 Out2 En1 En2 Write rst VSS VDD_1V8
XOut1_tri VSS En1 VDD_1V8 q Out1 BTHHDLLX1
XOut2_tri VSS En2 VDD_1V8 q Out2 BTHHDLLX1
Xq_reg q VSS rst VDD_1V8 In Write DLHRQHDLLX0
.ENDS

.SUBCKT latchtriestado_660 In Out1 Out2 En1 En2 Write rst VSS VDD_1V8
XOut1_tri VSS En1 VDD_1V8 q Out1 BTHHDLLX1
XOut2_tri VSS En2 VDD_1V8 q Out2 BTHHDLLX1
Xq_reg q VSS rst VDD_1V8 In Write DLHRQHDLLX0
.ENDS

.SUBCKT latchtriestado_659 In Out1 Out2 En1 En2 Write rst VSS VDD_1V8
XOut1_tri VSS En1 VDD_1V8 q Out1 BTHHDLLX1
XOut2_tri VSS En2 VDD_1V8 q Out2 BTHHDLLX1
Xq_reg q VSS rst VDD_1V8 In Write DLHRQHDLLX0
.ENDS

.SUBCKT latchtriestado_658 In Out1 Out2 En1 En2 Write rst VSS VDD_1V8
XOut2_tri VSS En2 VDD_1V8 q Out2 BTHHDLLX1
XOut1_tri VSS En1 VDD_1V8 q Out1 BTHHDLLX1
Xq_reg q VSS rst VDD_1V8 In Write DLHRQHDLLX0
.ENDS

.SUBCKT latchtriestado_657 In Out1 Out2 En1 En2 Write rst VSS VDD_1V8
XOut2_tri VSS En2 VDD_1V8 q Out2 BTHHDLLX1
XOut1_tri VSS En1 VDD_1V8 q Out1 BTHHDLLX1
Xq_reg q VSS rst VDD_1V8 In Write DLHRQHDLLX0
.ENDS

.SUBCKT latchtriestado_656 In Out1 Out2 En1 En2 Write rst VSS VDD_1V8
XOut2_tri VSS En2 VDD_1V8 q Out2 BTHHDLLX1
XOut1_tri VSS En1 VDD_1V8 q Out1 BTHHDLLX1
Xq_reg q VSS rst VDD_1V8 In Write DLHRQHDLLX0
.ENDS

.SUBCKT latchtriestado_655 In Out1 Out2 En1 En2 Write rst VSS VDD_1V8
XOut2_tri VSS En2 VDD_1V8 q Out2 BTHHDLLX1
XOut1_tri VSS En1 VDD_1V8 q Out1 BTHHDLLX1
Xq_reg q VSS rst VDD_1V8 In Write DLHRQHDLLX0
.ENDS

.SUBCKT latchtriestado_654 In Out1 Out2 En1 En2 Write rst VSS VDD_1V8
Xq_reg q VSS rst VDD_1V8 In Write DLHRQHDLLX0
XOut2_tri VSS En2 VDD_1V8 q Out2 BTHHDLLX1
XOut1_tri VSS En1 VDD_1V8 q Out1 BTHHDLLX1
.ENDS

.SUBCKT latchtriestado_653 In Out1 Out2 En1 En2 Write rst VSS VDD_1V8
Xq_reg q VSS rst VDD_1V8 In Write DLHRQHDLLX0
XOut2_tri VSS En2 VDD_1V8 q Out2 BTHHDLLX1
XOut1_tri VSS En1 VDD_1V8 q Out1 BTHHDLLX1
.ENDS

.SUBCKT latchtriestado_652 In Out1 Out2 En1 En2 Write rst VSS VDD_1V8
Xq_reg q VSS rst VDD_1V8 In Write DLHRQHDLLX0
XOut2_tri VSS En2 VDD_1V8 q Out2 BTHHDLLX1
XOut1_tri VSS En1 VDD_1V8 q Out1 BTHHDLLX1
.ENDS

.SUBCKT latchtriestado_651 In Out1 Out2 En1 En2 Write rst VSS VDD_1V8
Xq_reg q VSS rst VDD_1V8 In Write DLHRQHDLLX0
XOut2_tri VSS En2 VDD_1V8 q Out2 BTHHDLLX1
XOut1_tri VSS En1 VDD_1V8 q Out1 BTHHDLLX1
.ENDS

.SUBCKT latchtriestado_650 In Out1 Out2 En1 En2 Write rst VSS VDD_1V8
Xq_reg q VSS rst VDD_1V8 In Write DLHRQHDLLX0
XOut1_tri VSS En1 VDD_1V8 q Out1 BTHHDLLX1
XOut2_tri VSS En2 VDD_1V8 q Out2 BTHHDLLX1
.ENDS

.SUBCKT latchtriestado_649 In Out1 Out2 En1 En2 Write rst VSS VDD_1V8
XOut1_tri VSS En1 VDD_1V8 q Out1 BTHHDLLX1
XOut2_tri VSS En2 VDD_1V8 q Out2 BTHHDLLX1
Xq_reg q VSS rst VDD_1V8 In Write DLHRQHDLLX0
.ENDS

.SUBCKT latchtriestado_648 In Out1 Out2 En1 En2 Write rst VSS VDD_1V8
XOut1_tri VSS En1 VDD_1V8 q Out1 BTHHDLLX1
XOut2_tri VSS En2 VDD_1V8 q Out2 BTHHDLLX1
Xq_reg q VSS rst VDD_1V8 In Write DLHRQHDLLX0
.ENDS

.SUBCKT latchtriestado_647 In Out1 Out2 En1 En2 Write rst VSS VDD_1V8
XOut2_tri VSS En2 VDD_1V8 q Out2 BTHHDLLX1
XOut1_tri VSS En1 VDD_1V8 q Out1 BTHHDLLX1
Xq_reg q VSS rst VDD_1V8 In Write DLHRQHDLLX0
.ENDS

.SUBCKT latchtriestado_646 In Out1 Out2 En1 En2 Write rst VSS VDD_1V8
XOut1_tri VSS En1 VDD_1V8 q Out1 BTHHDLLX1
XOut2_tri VSS En2 VDD_1V8 q Out2 BTHHDLLX1
Xq_reg q VSS rst VDD_1V8 In Write DLHRQHDLLX0
.ENDS

.SUBCKT latchtriestado_645 In Out1 Out2 En1 En2 Write rst VSS VDD_1V8
XOut2_tri VSS En2 VDD_1V8 q Out2 BTHHDLLX1
XOut1_tri VSS En1 VDD_1V8 q Out1 BTHHDLLX1
Xq_reg q VSS rst VDD_1V8 In Write DLHRQHDLLX0
.ENDS

.SUBCKT latchtriestado_644 In Out1 Out2 En1 En2 Write rst VSS VDD_1V8
XOut2_tri VSS En2 VDD_1V8 q Out2 BTHHDLLX1
XOut1_tri VSS En1 VDD_1V8 q Out1 BTHHDLLX1
Xq_reg q VSS rst VDD_1V8 In Write DLHRQHDLLX0
.ENDS

.SUBCKT latchtriestado_643 In Out1 Out2 En1 En2 Write rst VSS VDD_1V8
XOut2_tri VSS En2 VDD_1V8 q Out2 BTHHDLLX1
XOut1_tri VSS En1 VDD_1V8 q Out1 BTHHDLLX1
Xq_reg q VSS rst VDD_1V8 In Write DLHRQHDLLX0
.ENDS

.SUBCKT latchtriestado_642 In Out1 Out2 En1 En2 Write rst VSS VDD_1V8
XOut2_tri VSS En2 VDD_1V8 q Out2 BTHHDLLX1
XOut1_tri VSS En1 VDD_1V8 q Out1 BTHHDLLX1
Xq_reg q VSS rst VDD_1V8 In Write DLHRQHDLLX0
.ENDS

.SUBCKT latchtriestado_641 In Out1 Out2 En1 En2 Write rst VSS VDD_1V8
XOut1_tri VSS En1 VDD_1V8 q Out1 BTHHDLLX1
XOut2_tri VSS En2 VDD_1V8 q Out2 BTHHDLLX1
Xq_reg q VSS rst VDD_1V8 In Write DLHRQHDLLX0
.ENDS

.SUBCKT latchtriestado_640 In Out1 Out2 En1 En2 Write rst VSS VDD_1V8
XOut2_tri VSS En2 VDD_1V8 q Out2 BTHHDLLX1
XOut1_tri VSS En1 VDD_1V8 q Out1 BTHHDLLX1
Xq_reg q VSS rst VDD_1V8 In Write DLHRQHDLLX0
.ENDS

.SUBCKT latchtriestado_639 In Out1 Out2 En1 En2 Write rst VSS VDD_1V8
XOut1_tri VSS En1 VDD_1V8 q Out1 BTHHDLLX1
XOut2_tri VSS En2 VDD_1V8 q Out2 BTHHDLLX1
Xq_reg q VSS rst VDD_1V8 In Write DLHRQHDLLX0
.ENDS

.SUBCKT latchtriestado_638 In Out1 Out2 En1 En2 Write rst VSS VDD_1V8
XOut1_tri VSS En1 VDD_1V8 q Out1 BTHHDLLX1
XOut2_tri VSS En2 VDD_1V8 q Out2 BTHHDLLX1
Xq_reg q VSS rst VDD_1V8 In Write DLHRQHDLLX0
.ENDS

.SUBCKT latchtriestado_637 In Out1 Out2 En1 En2 Write rst VSS VDD_1V8
XOut1_tri VSS En1 VDD_1V8 q Out1 BTHHDLLX1
XOut2_tri VSS En2 VDD_1V8 q Out2 BTHHDLLX1
Xq_reg q VSS rst VDD_1V8 In Write DLHRQHDLLX0
.ENDS

.SUBCKT latchtriestado_636 In Out1 Out2 En1 En2 Write rst VSS VDD_1V8
XOut1_tri VSS En1 VDD_1V8 q Out1 BTHHDLLX1
XOut2_tri VSS En2 VDD_1V8 q Out2 BTHHDLLX1
Xq_reg q VSS rst VDD_1V8 In Write DLHRQHDLLX0
.ENDS

.SUBCKT latchtriestado_635 In Out1 Out2 En1 En2 Write rst VSS VDD_1V8
XOut1_tri VSS En1 VDD_1V8 q Out1 BTHHDLLX1
XOut2_tri VSS En2 VDD_1V8 q Out2 BTHHDLLX1
Xq_reg q VSS rst VDD_1V8 In Write DLHRQHDLLX0
.ENDS

.SUBCKT latchtriestado_634 In Out1 Out2 En1 En2 Write rst VSS VDD_1V8
XOut1_tri VSS En1 VDD_1V8 q Out1 BTHHDLLX1
XOut2_tri VSS En2 VDD_1V8 q Out2 BTHHDLLX1
Xq_reg q VSS rst VDD_1V8 In Write DLHRQHDLLX0
.ENDS

.SUBCKT latchtriestado_633 In Out1 Out2 En1 En2 Write rst VSS VDD_1V8
XOut1_tri VSS En1 VDD_1V8 q Out1 BTHHDLLX1
XOut2_tri VSS En2 VDD_1V8 q Out2 BTHHDLLX1
Xq_reg q VSS rst VDD_1V8 In Write DLHRQHDLLX0
.ENDS

.SUBCKT latchtriestado_632 In Out1 Out2 En1 En2 Write rst VSS VDD_1V8
XOut1_tri VSS En1 VDD_1V8 q Out1 BTHHDLLX1
XOut2_tri VSS En2 VDD_1V8 q Out2 BTHHDLLX1
Xq_reg q VSS rst VDD_1V8 In Write DLHRQHDLLX0
.ENDS

.SUBCKT latchtriestado_631 In Out1 Out2 En1 En2 Write rst VSS VDD_1V8
XOut1_tri VSS En1 VDD_1V8 q Out1 BTHHDLLX1
XOut2_tri VSS En2 VDD_1V8 q Out2 BTHHDLLX1
Xq_reg q VSS rst VDD_1V8 In Write DLHRQHDLLX0
.ENDS

.SUBCKT latchtriestado_630 In Out1 Out2 En1 En2 Write rst VSS VDD_1V8
XOut1_tri VSS En1 VDD_1V8 q Out1 BTHHDLLX1
XOut2_tri VSS En2 VDD_1V8 q Out2 BTHHDLLX1
Xq_reg q VSS rst VDD_1V8 In Write DLHRQHDLLX0
.ENDS

.SUBCKT latchtriestado_629 In Out1 Out2 En1 En2 Write rst VSS VDD_1V8
XOut1_tri VSS En1 VDD_1V8 q Out1 BTHHDLLX1
XOut2_tri VSS En2 VDD_1V8 q Out2 BTHHDLLX1
Xq_reg q VSS rst VDD_1V8 In Write DLHRQHDLLX0
.ENDS

.SUBCKT latchtriestado_628 In Out1 Out2 En1 En2 Write rst VSS VDD_1V8
XOut1_tri VSS En1 VDD_1V8 q Out1 BTHHDLLX1
XOut2_tri VSS En2 VDD_1V8 q Out2 BTHHDLLX1
Xq_reg q VSS rst VDD_1V8 In Write DLHRQHDLLX0
.ENDS

.SUBCKT latchtriestado_627 In Out1 Out2 En1 En2 Write rst VSS VDD_1V8
XOut1_tri VSS En1 VDD_1V8 q Out1 BTHHDLLX1
XOut2_tri VSS En2 VDD_1V8 q Out2 BTHHDLLX1
Xq_reg q VSS rst VDD_1V8 In Write DLHRQHDLLX0
.ENDS

.SUBCKT latchtriestado_626 In Out1 Out2 En1 En2 Write rst VSS VDD_1V8
XOut1_tri VSS En1 VDD_1V8 q Out1 BTHHDLLX1
XOut2_tri VSS En2 VDD_1V8 q Out2 BTHHDLLX1
Xq_reg q VSS rst VDD_1V8 In Write DLHRQHDLLX0
.ENDS

.SUBCKT latchtriestado_625 In Out1 Out2 En1 En2 Write rst VSS VDD_1V8
XOut1_tri VSS En1 VDD_1V8 q Out1 BTHHDLLX1
XOut2_tri VSS En2 VDD_1V8 q Out2 BTHHDLLX1
Xq_reg q VSS rst VDD_1V8 In Write DLHRQHDLLX0
.ENDS

.SUBCKT latchtriestado_624 In Out1 Out2 En1 En2 Write rst VSS VDD_1V8
XOut1_tri VSS En1 VDD_1V8 q Out1 BTHHDLLX1
XOut2_tri VSS En2 VDD_1V8 q Out2 BTHHDLLX1
Xq_reg q VSS rst VDD_1V8 In Write DLHRQHDLLX0
.ENDS

.SUBCKT latchtriestado_623 In Out1 Out2 En1 En2 Write rst VSS VDD_1V8
XOut2_tri VSS En2 VDD_1V8 q Out2 BTHHDLLX1
XOut1_tri VSS En1 VDD_1V8 q Out1 BTHHDLLX1
Xq_reg q VSS rst VDD_1V8 In Write DLHRQHDLLX0
.ENDS

.SUBCKT latchtriestado_622 In Out1 Out2 En1 En2 Write rst VSS VDD_1V8
Xq_reg q VSS rst VDD_1V8 In Write DLHRQHDLLX0
XOut2_tri VSS En2 VDD_1V8 q Out2 BTHHDLLX1
XOut1_tri VSS En1 VDD_1V8 q Out1 BTHHDLLX1
.ENDS

.SUBCKT latchtriestado_621 In Out1 Out2 En1 En2 Write rst VSS VDD_1V8
Xq_reg q VSS rst VDD_1V8 In Write DLHRQHDLLX0
XOut2_tri VSS En2 VDD_1V8 q Out2 BTHHDLLX1
XOut1_tri VSS En1 VDD_1V8 q Out1 BTHHDLLX1
.ENDS

.SUBCKT latchtriestado_620 In Out1 Out2 En1 En2 Write rst VSS VDD_1V8
Xq_reg q VSS rst VDD_1V8 In Write DLHRQHDLLX0
XOut2_tri VSS En2 VDD_1V8 q Out2 BTHHDLLX1
XOut1_tri VSS En1 VDD_1V8 q Out1 BTHHDLLX1
.ENDS

.SUBCKT latchtriestado_619 In Out1 Out2 En1 En2 Write rst VSS VDD_1V8
Xq_reg q VSS rst VDD_1V8 In Write DLHRQHDLLX0
XOut1_tri VSS En1 VDD_1V8 q Out1 BTHHDLLX1
XOut2_tri VSS En2 VDD_1V8 q Out2 BTHHDLLX1
.ENDS

.SUBCKT latchtriestado_618 In Out1 Out2 En1 En2 Write rst VSS VDD_1V8
Xq_reg q VSS rst VDD_1V8 In Write DLHRQHDLLX0
XOut1_tri VSS En1 VDD_1V8 q Out1 BTHHDLLX1
XOut2_tri VSS En2 VDD_1V8 q Out2 BTHHDLLX1
.ENDS

.SUBCKT latchtriestado_617 In Out1 Out2 En1 En2 Write rst VSS VDD_1V8
XOut2_tri VSS En2 VDD_1V8 q Out2 BTHHDLLX1
XOut1_tri VSS En1 VDD_1V8 q Out1 BTHHDLLX1
Xq_reg q VSS rst VDD_1V8 In Write DLHRQHDLLX0
.ENDS

.SUBCKT latchtriestado_616 In Out1 Out2 En1 En2 Write rst VSS VDD_1V8
XOut2_tri VSS En2 VDD_1V8 q Out2 BTHHDLLX1
XOut1_tri VSS En1 VDD_1V8 q Out1 BTHHDLLX1
Xq_reg q VSS rst VDD_1V8 In Write DLHRQHDLLX0
.ENDS

.SUBCKT latchtriestado_615 In Out1 Out2 En1 En2 Write rst VSS VDD_1V8
XOut2_tri VSS En2 VDD_1V8 q Out2 BTHHDLLX1
XOut1_tri VSS En1 VDD_1V8 q Out1 BTHHDLLX1
Xq_reg q VSS rst VDD_1V8 In Write DLHRQHDLLX0
.ENDS

.SUBCKT latchtriestado_614 In Out1 Out2 En1 En2 Write rst VSS VDD_1V8
XOut2_tri VSS En2 VDD_1V8 q Out2 BTHHDLLX1
XOut1_tri VSS En1 VDD_1V8 q Out1 BTHHDLLX1
Xq_reg q VSS rst VDD_1V8 In Write DLHRQHDLLX0
.ENDS

.SUBCKT latchtriestado_613 In Out1 Out2 En1 En2 Write rst VSS VDD_1V8
XOut1_tri VSS En1 VDD_1V8 q Out1 BTHHDLLX1
XOut2_tri VSS En2 VDD_1V8 q Out2 BTHHDLLX1
Xq_reg q VSS rst VDD_1V8 In Write DLHRQHDLLX0
.ENDS

.SUBCKT latchtriestado_612 In Out1 Out2 En1 En2 Write rst VSS VDD_1V8
XOut1_tri VSS En1 VDD_1V8 q Out1 BTHHDLLX1
XOut2_tri VSS En2 VDD_1V8 q Out2 BTHHDLLX1
Xq_reg q VSS rst VDD_1V8 In Write DLHRQHDLLX0
.ENDS

.SUBCKT latchtriestado_611 In Out1 Out2 En1 En2 Write rst VSS VDD_1V8
XOut1_tri VSS En1 VDD_1V8 q Out1 BTHHDLLX1
XOut2_tri VSS En2 VDD_1V8 q Out2 BTHHDLLX1
Xq_reg q VSS rst VDD_1V8 In Write DLHRQHDLLX0
.ENDS

.SUBCKT latchtriestado_610 In Out1 Out2 En1 En2 Write rst VSS VDD_1V8
XOut1_tri VSS En1 VDD_1V8 q Out1 BTHHDLLX1
XOut2_tri VSS En2 VDD_1V8 q Out2 BTHHDLLX1
Xq_reg q VSS rst VDD_1V8 In Write DLHRQHDLLX0
.ENDS

.SUBCKT latchtriestado_609 In Out1 Out2 En1 En2 Write rst VSS VDD_1V8
XOut2_tri VSS En2 VDD_1V8 q Out2 BTHHDLLX1
XOut1_tri VSS En1 VDD_1V8 q Out1 BTHHDLLX1
Xq_reg q VSS rst VDD_1V8 In Write DLHRQHDLLX0
.ENDS

.SUBCKT latchtriestado_608 In Out1 Out2 En1 En2 Write rst VSS VDD_1V8
XOut2_tri VSS En2 VDD_1V8 q Out2 BTHHDLLX1
XOut1_tri VSS En1 VDD_1V8 q Out1 BTHHDLLX1
Xq_reg q VSS rst VDD_1V8 In Write DLHRQHDLLX0
.ENDS

.SUBCKT latchtriestado_607 In Out1 Out2 En1 En2 Write rst VSS VDD_1V8
XOut1_tri VSS En1 VDD_1V8 q Out1 BTHHDLLX1
XOut2_tri VSS En2 VDD_1V8 q Out2 BTHHDLLX1
Xq_reg q VSS rst VDD_1V8 In Write DLHRQHDLLX0
.ENDS

.SUBCKT latchtriestado_606 In Out1 Out2 En1 En2 Write rst VSS VDD_1V8
XOut1_tri VSS En1 VDD_1V8 q Out1 BTHHDLLX1
XOut2_tri VSS En2 VDD_1V8 q Out2 BTHHDLLX1
Xq_reg q VSS rst VDD_1V8 In Write DLHRQHDLLX0
.ENDS

.SUBCKT latchtriestado_605 In Out1 Out2 En1 En2 Write rst VSS VDD_1V8
XOut1_tri VSS En1 VDD_1V8 q Out1 BTHHDLLX1
XOut2_tri VSS En2 VDD_1V8 q Out2 BTHHDLLX1
Xq_reg q VSS rst VDD_1V8 In Write DLHRQHDLLX0
.ENDS

.SUBCKT latchtriestado_604 In Out1 Out2 En1 En2 Write rst VSS VDD_1V8
XOut1_tri VSS En1 VDD_1V8 q Out1 BTHHDLLX1
XOut2_tri VSS En2 VDD_1V8 q Out2 BTHHDLLX1
Xq_reg q VSS rst VDD_1V8 In Write DLHRQHDLLX0
.ENDS

.SUBCKT latchtriestado_603 In Out1 Out2 En1 En2 Write rst VSS VDD_1V8
XOut1_tri VSS En1 VDD_1V8 q Out1 BTHHDLLX1
XOut2_tri VSS En2 VDD_1V8 q Out2 BTHHDLLX1
Xq_reg q VSS rst VDD_1V8 In Write DLHRQHDLLX0
.ENDS

.SUBCKT latchtriestado_602 In Out1 Out2 En1 En2 Write rst VSS VDD_1V8
XOut1_tri VSS En1 VDD_1V8 q Out1 BTHHDLLX1
XOut2_tri VSS En2 VDD_1V8 q Out2 BTHHDLLX1
Xq_reg q VSS rst VDD_1V8 In Write DLHRQHDLLX0
.ENDS

.SUBCKT latchtriestado_601 In Out1 Out2 En1 En2 Write rst VSS VDD_1V8
XOut1_tri VSS En1 VDD_1V8 q Out1 BTHHDLLX1
XOut2_tri VSS En2 VDD_1V8 q Out2 BTHHDLLX1
Xq_reg q VSS rst VDD_1V8 In Write DLHRQHDLLX0
.ENDS

.SUBCKT latchtriestado_600 In Out1 Out2 En1 En2 Write rst VSS VDD_1V8
XOut1_tri VSS En1 VDD_1V8 q Out1 BTHHDLLX1
XOut2_tri VSS En2 VDD_1V8 q Out2 BTHHDLLX1
Xq_reg q VSS rst VDD_1V8 In Write DLHRQHDLLX0
.ENDS

.SUBCKT latchtriestado_599 In Out1 Out2 En1 En2 Write rst VSS VDD_1V8
XOut1_tri VSS En1 VDD_1V8 q Out1 BTHHDLLX1
XOut2_tri VSS En2 VDD_1V8 q Out2 BTHHDLLX1
Xq_reg q VSS rst VDD_1V8 In Write DLHRQHDLLX0
.ENDS

.SUBCKT latchtriestado_598 In Out1 Out2 En1 En2 Write rst VSS VDD_1V8
XOut1_tri VSS En1 VDD_1V8 q Out1 BTHHDLLX1
XOut2_tri VSS En2 VDD_1V8 q Out2 BTHHDLLX1
Xq_reg q VSS rst VDD_1V8 In Write DLHRQHDLLX0
.ENDS

.SUBCKT latchtriestado_597 In Out1 Out2 En1 En2 Write rst VSS VDD_1V8
XOut1_tri VSS En1 VDD_1V8 q Out1 BTHHDLLX1
XOut2_tri VSS En2 VDD_1V8 q Out2 BTHHDLLX1
Xq_reg q VSS rst VDD_1V8 In Write DLHRQHDLLX0
.ENDS

.SUBCKT latchtriestado_596 In Out1 Out2 En1 En2 Write rst VSS VDD_1V8
XOut1_tri VSS En1 VDD_1V8 q Out1 BTHHDLLX1
XOut2_tri VSS En2 VDD_1V8 q Out2 BTHHDLLX1
Xq_reg q VSS rst VDD_1V8 In Write DLHRQHDLLX0
.ENDS

.SUBCKT latchtriestado_595 In Out1 Out2 En1 En2 Write rst VSS VDD_1V8
XOut1_tri VSS En1 VDD_1V8 q Out1 BTHHDLLX1
XOut2_tri VSS En2 VDD_1V8 q Out2 BTHHDLLX1
Xq_reg q VSS rst VDD_1V8 In Write DLHRQHDLLX0
.ENDS

.SUBCKT latchtriestado_594 In Out1 Out2 En1 En2 Write rst VSS VDD_1V8
XOut1_tri VSS En1 VDD_1V8 q Out1 BTHHDLLX1
XOut2_tri VSS En2 VDD_1V8 q Out2 BTHHDLLX1
Xq_reg q VSS rst VDD_1V8 In Write DLHRQHDLLX0
.ENDS

.SUBCKT latchtriestado_593 In Out1 Out2 En1 En2 Write rst VSS VDD_1V8
XOut1_tri VSS En1 VDD_1V8 q Out1 BTHHDLLX1
XOut2_tri VSS En2 VDD_1V8 q Out2 BTHHDLLX1
Xq_reg q VSS rst VDD_1V8 In Write DLHRQHDLLX0
.ENDS

.SUBCKT latchtriestado_592 In Out1 Out2 En1 En2 Write rst VSS VDD_1V8
XOut1_tri VSS En1 VDD_1V8 q Out1 BTHHDLLX1
XOut2_tri VSS En2 VDD_1V8 q Out2 BTHHDLLX1
Xq_reg q VSS rst VDD_1V8 In Write DLHRQHDLLX0
.ENDS

.SUBCKT latchtriestado_591 In Out1 Out2 En1 En2 Write rst VSS VDD_1V8
XOut2_tri VSS En2 VDD_1V8 q Out2 BTHHDLLX1
XOut1_tri VSS En1 VDD_1V8 q Out1 BTHHDLLX1
Xq_reg q VSS rst VDD_1V8 In Write DLHRQHDLLX0
.ENDS

.SUBCKT latchtriestado_590 In Out1 Out2 En1 En2 Write rst VSS VDD_1V8
Xq_reg q VSS rst VDD_1V8 In Write DLHRQHDLLX0
XOut2_tri VSS En2 VDD_1V8 q Out2 BTHHDLLX1
XOut1_tri VSS En1 VDD_1V8 q Out1 BTHHDLLX1
.ENDS

.SUBCKT latchtriestado_589 In Out1 Out2 En1 En2 Write rst VSS VDD_1V8
Xq_reg q VSS rst VDD_1V8 In Write DLHRQHDLLX0
XOut2_tri VSS En2 VDD_1V8 q Out2 BTHHDLLX1
XOut1_tri VSS En1 VDD_1V8 q Out1 BTHHDLLX1
.ENDS

.SUBCKT latchtriestado_588 In Out1 Out2 En1 En2 Write rst VSS VDD_1V8
Xq_reg q VSS rst VDD_1V8 In Write DLHRQHDLLX0
XOut2_tri VSS En2 VDD_1V8 q Out2 BTHHDLLX1
XOut1_tri VSS En1 VDD_1V8 q Out1 BTHHDLLX1
.ENDS

.SUBCKT latchtriestado_587 In Out1 Out2 En1 En2 Write rst VSS VDD_1V8
Xq_reg q VSS rst VDD_1V8 In Write DLHRQHDLLX0
XOut2_tri VSS En2 VDD_1V8 q Out2 BTHHDLLX1
XOut1_tri VSS En1 VDD_1V8 q Out1 BTHHDLLX1
.ENDS

.SUBCKT latchtriestado_586 In Out1 Out2 En1 En2 Write rst VSS VDD_1V8
Xq_reg q VSS rst VDD_1V8 In Write DLHRQHDLLX0
XOut2_tri VSS En2 VDD_1V8 q Out2 BTHHDLLX1
XOut1_tri VSS En1 VDD_1V8 q Out1 BTHHDLLX1
.ENDS

.SUBCKT latchtriestado_585 In Out1 Out2 En1 En2 Write rst VSS VDD_1V8
XOut1_tri VSS En1 VDD_1V8 q Out1 BTHHDLLX1
XOut2_tri VSS En2 VDD_1V8 q Out2 BTHHDLLX1
Xq_reg q VSS rst VDD_1V8 In Write DLHRQHDLLX0
.ENDS

.SUBCKT latchtriestado_584 In Out1 Out2 En1 En2 Write rst VSS VDD_1V8
XOut1_tri VSS En1 VDD_1V8 q Out1 BTHHDLLX1
XOut2_tri VSS En2 VDD_1V8 q Out2 BTHHDLLX1
Xq_reg q VSS rst VDD_1V8 In Write DLHRQHDLLX0
.ENDS

.SUBCKT latchtriestado_583 In Out1 Out2 En1 En2 Write rst VSS VDD_1V8
XOut1_tri VSS En1 VDD_1V8 q Out1 BTHHDLLX1
XOut2_tri VSS En2 VDD_1V8 q Out2 BTHHDLLX1
Xq_reg q VSS rst VDD_1V8 In Write DLHRQHDLLX0
.ENDS

.SUBCKT latchtriestado_582 In Out1 Out2 En1 En2 Write rst VSS VDD_1V8
XOut1_tri VSS En1 VDD_1V8 q Out1 BTHHDLLX1
XOut2_tri VSS En2 VDD_1V8 q Out2 BTHHDLLX1
Xq_reg q VSS rst VDD_1V8 In Write DLHRQHDLLX0
.ENDS

.SUBCKT latchtriestado_581 In Out1 Out2 En1 En2 Write rst VSS VDD_1V8
XOut2_tri VSS En2 VDD_1V8 q Out2 BTHHDLLX1
XOut1_tri VSS En1 VDD_1V8 q Out1 BTHHDLLX1
Xq_reg q VSS rst VDD_1V8 In Write DLHRQHDLLX0
.ENDS

.SUBCKT latchtriestado_580 In Out1 Out2 En1 En2 Write rst VSS VDD_1V8
XOut2_tri VSS En2 VDD_1V8 q Out2 BTHHDLLX1
XOut1_tri VSS En1 VDD_1V8 q Out1 BTHHDLLX1
Xq_reg q VSS rst VDD_1V8 In Write DLHRQHDLLX0
.ENDS

.SUBCKT latchtriestado_579 In Out1 Out2 En1 En2 Write rst VSS VDD_1V8
XOut2_tri VSS En2 VDD_1V8 q Out2 BTHHDLLX1
XOut1_tri VSS En1 VDD_1V8 q Out1 BTHHDLLX1
Xq_reg q VSS rst VDD_1V8 In Write DLHRQHDLLX0
.ENDS

.SUBCKT latchtriestado_578 In Out1 Out2 En1 En2 Write rst VSS VDD_1V8
XOut2_tri VSS En2 VDD_1V8 q Out2 BTHHDLLX1
XOut1_tri VSS En1 VDD_1V8 q Out1 BTHHDLLX1
Xq_reg q VSS rst VDD_1V8 In Write DLHRQHDLLX0
.ENDS

.SUBCKT latchtriestado_577 In Out1 Out2 En1 En2 Write rst VSS VDD_1V8
XOut2_tri VSS En2 VDD_1V8 q Out2 BTHHDLLX1
XOut1_tri VSS En1 VDD_1V8 q Out1 BTHHDLLX1
Xq_reg q VSS rst VDD_1V8 In Write DLHRQHDLLX0
.ENDS

.SUBCKT latchtriestado_576 In Out1 Out2 En1 En2 Write rst VSS VDD_1V8
XOut1_tri VSS En1 VDD_1V8 q Out1 BTHHDLLX1
XOut2_tri VSS En2 VDD_1V8 q Out2 BTHHDLLX1
Xq_reg q VSS rst VDD_1V8 In Write DLHRQHDLLX0
.ENDS

.SUBCKT latchtriestado_575 In Out1 Out2 En1 En2 Write rst VSS VDD_1V8
XOut1_tri VSS En1 VDD_1V8 q Out1 BTHHDLLX1
XOut2_tri VSS En2 VDD_1V8 q Out2 BTHHDLLX1
Xq_reg q VSS rst VDD_1V8 In Write DLHRQHDLLX0
.ENDS

.SUBCKT latchtriestado_574 In Out1 Out2 En1 En2 Write rst VSS VDD_1V8
XOut1_tri VSS En1 VDD_1V8 q Out1 BTHHDLLX1
XOut2_tri VSS En2 VDD_1V8 q Out2 BTHHDLLX1
Xq_reg q VSS rst VDD_1V8 In Write DLHRQHDLLX0
.ENDS

.SUBCKT latchtriestado_573 In Out1 Out2 En1 En2 Write rst VSS VDD_1V8
XOut1_tri VSS En1 VDD_1V8 q Out1 BTHHDLLX1
XOut2_tri VSS En2 VDD_1V8 q Out2 BTHHDLLX1
Xq_reg q VSS rst VDD_1V8 In Write DLHRQHDLLX0
.ENDS

.SUBCKT latchtriestado_572 In Out1 Out2 En1 En2 Write rst VSS VDD_1V8
XOut1_tri VSS En1 VDD_1V8 q Out1 BTHHDLLX1
XOut2_tri VSS En2 VDD_1V8 q Out2 BTHHDLLX1
Xq_reg q VSS rst VDD_1V8 In Write DLHRQHDLLX0
.ENDS

.SUBCKT latchtriestado_571 In Out1 Out2 En1 En2 Write rst VSS VDD_1V8
XOut1_tri VSS En1 VDD_1V8 q Out1 BTHHDLLX1
XOut2_tri VSS En2 VDD_1V8 q Out2 BTHHDLLX1
Xq_reg q VSS rst VDD_1V8 In Write DLHRQHDLLX0
.ENDS

.SUBCKT latchtriestado_570 In Out1 Out2 En1 En2 Write rst VSS VDD_1V8
XOut1_tri VSS En1 VDD_1V8 q Out1 BTHHDLLX1
XOut2_tri VSS En2 VDD_1V8 q Out2 BTHHDLLX1
Xq_reg q VSS rst VDD_1V8 In Write DLHRQHDLLX0
.ENDS

.SUBCKT latchtriestado_569 In Out1 Out2 En1 En2 Write rst VSS VDD_1V8
XOut1_tri VSS En1 VDD_1V8 q Out1 BTHHDLLX1
XOut2_tri VSS En2 VDD_1V8 q Out2 BTHHDLLX1
Xq_reg q VSS rst VDD_1V8 In Write DLHRQHDLLX0
.ENDS

.SUBCKT latchtriestado_568 In Out1 Out2 En1 En2 Write rst VSS VDD_1V8
XOut1_tri VSS En1 VDD_1V8 q Out1 BTHHDLLX1
XOut2_tri VSS En2 VDD_1V8 q Out2 BTHHDLLX1
Xq_reg q VSS rst VDD_1V8 In Write DLHRQHDLLX0
.ENDS

.SUBCKT latchtriestado_567 In Out1 Out2 En1 En2 Write rst VSS VDD_1V8
XOut1_tri VSS En1 VDD_1V8 q Out1 BTHHDLLX1
XOut2_tri VSS En2 VDD_1V8 q Out2 BTHHDLLX1
Xq_reg q VSS rst VDD_1V8 In Write DLHRQHDLLX0
.ENDS

.SUBCKT latchtriestado_566 In Out1 Out2 En1 En2 Write rst VSS VDD_1V8
XOut1_tri VSS En1 VDD_1V8 q Out1 BTHHDLLX1
XOut2_tri VSS En2 VDD_1V8 q Out2 BTHHDLLX1
Xq_reg q VSS rst VDD_1V8 In Write DLHRQHDLLX0
.ENDS

.SUBCKT latchtriestado_565 In Out1 Out2 En1 En2 Write rst VSS VDD_1V8
XOut2_tri VSS En2 VDD_1V8 q Out2 BTHHDLLX1
XOut1_tri VSS En1 VDD_1V8 q Out1 BTHHDLLX1
Xq_reg q VSS rst VDD_1V8 In Write DLHRQHDLLX0
.ENDS

.SUBCKT latchtriestado_564 In Out1 Out2 En1 En2 Write rst VSS VDD_1V8
XOut2_tri VSS En2 VDD_1V8 q Out2 BTHHDLLX1
XOut1_tri VSS En1 VDD_1V8 q Out1 BTHHDLLX1
Xq_reg q VSS rst VDD_1V8 In Write DLHRQHDLLX0
.ENDS

.SUBCKT latchtriestado_563 In Out1 Out2 En1 En2 Write rst VSS VDD_1V8
XOut1_tri VSS En1 VDD_1V8 q Out1 BTHHDLLX1
XOut2_tri VSS En2 VDD_1V8 q Out2 BTHHDLLX1
Xq_reg q VSS rst VDD_1V8 In Write DLHRQHDLLX0
.ENDS

.SUBCKT latchtriestado_562 In Out1 Out2 En1 En2 Write rst VSS VDD_1V8
XOut1_tri VSS En1 VDD_1V8 q Out1 BTHHDLLX1
XOut2_tri VSS En2 VDD_1V8 q Out2 BTHHDLLX1
Xq_reg q VSS rst VDD_1V8 In Write DLHRQHDLLX0
.ENDS

.SUBCKT latchtriestado_561 In Out1 Out2 En1 En2 Write rst VSS VDD_1V8
XOut1_tri VSS En1 VDD_1V8 q Out1 BTHHDLLX1
XOut2_tri VSS En2 VDD_1V8 q Out2 BTHHDLLX1
Xq_reg q VSS rst VDD_1V8 In Write DLHRQHDLLX0
.ENDS

.SUBCKT latchtriestado_560 In Out1 Out2 En1 En2 Write rst VSS VDD_1V8
XOut1_tri VSS En1 VDD_1V8 q Out1 BTHHDLLX1
XOut2_tri VSS En2 VDD_1V8 q Out2 BTHHDLLX1
Xq_reg q VSS rst VDD_1V8 In Write DLHRQHDLLX0
.ENDS

.SUBCKT latchtriestado_559 In Out1 Out2 En1 En2 Write rst VSS VDD_1V8
XOut1_tri VSS En1 VDD_1V8 q Out1 BTHHDLLX1
XOut2_tri VSS En2 VDD_1V8 q Out2 BTHHDLLX1
Xq_reg q VSS rst VDD_1V8 In Write DLHRQHDLLX0
.ENDS

.SUBCKT latchtriestado_558 In Out1 Out2 En1 En2 Write rst VSS VDD_1V8
Xq_reg q VSS rst VDD_1V8 In Write DLHRQHDLLX0
XOut1_tri VSS En1 VDD_1V8 q Out1 BTHHDLLX1
XOut2_tri VSS En2 VDD_1V8 q Out2 BTHHDLLX1
.ENDS

.SUBCKT latchtriestado_557 In Out1 Out2 En1 En2 Write rst VSS VDD_1V8
Xq_reg q VSS rst VDD_1V8 In Write DLHRQHDLLX0
XOut1_tri VSS En1 VDD_1V8 q Out1 BTHHDLLX1
XOut2_tri VSS En2 VDD_1V8 q Out2 BTHHDLLX1
.ENDS

.SUBCKT latchtriestado_556 In Out1 Out2 En1 En2 Write rst VSS VDD_1V8
Xq_reg q VSS rst VDD_1V8 In Write DLHRQHDLLX0
XOut2_tri VSS En2 VDD_1V8 q Out2 BTHHDLLX1
XOut1_tri VSS En1 VDD_1V8 q Out1 BTHHDLLX1
.ENDS

.SUBCKT latchtriestado_555 In Out1 Out2 En1 En2 Write rst VSS VDD_1V8
Xq_reg q VSS rst VDD_1V8 In Write DLHRQHDLLX0
XOut2_tri VSS En2 VDD_1V8 q Out2 BTHHDLLX1
XOut1_tri VSS En1 VDD_1V8 q Out1 BTHHDLLX1
.ENDS

.SUBCKT latchtriestado_554 In Out1 Out2 En1 En2 Write rst VSS VDD_1V8
Xq_reg q VSS rst VDD_1V8 In Write DLHRQHDLLX0
XOut1_tri VSS En1 VDD_1V8 q Out1 BTHHDLLX1
XOut2_tri VSS En2 VDD_1V8 q Out2 BTHHDLLX1
.ENDS

.SUBCKT latchtriestado_553 In Out1 Out2 En1 En2 Write rst VSS VDD_1V8
XOut1_tri VSS En1 VDD_1V8 q Out1 BTHHDLLX1
XOut2_tri VSS En2 VDD_1V8 q Out2 BTHHDLLX1
Xq_reg q VSS rst VDD_1V8 In Write DLHRQHDLLX0
.ENDS

.SUBCKT latchtriestado_552 In Out1 Out2 En1 En2 Write rst VSS VDD_1V8
XOut2_tri VSS En2 VDD_1V8 q Out2 BTHHDLLX1
XOut1_tri VSS En1 VDD_1V8 q Out1 BTHHDLLX1
Xq_reg q VSS rst VDD_1V8 In Write DLHRQHDLLX0
.ENDS

.SUBCKT latchtriestado_551 In Out1 Out2 En1 En2 Write rst VSS VDD_1V8
XOut1_tri VSS En1 VDD_1V8 q Out1 BTHHDLLX1
XOut2_tri VSS En2 VDD_1V8 q Out2 BTHHDLLX1
Xq_reg q VSS rst VDD_1V8 In Write DLHRQHDLLX0
.ENDS

.SUBCKT latchtriestado_550 In Out1 Out2 En1 En2 Write rst VSS VDD_1V8
XOut1_tri VSS En1 VDD_1V8 q Out1 BTHHDLLX1
XOut2_tri VSS En2 VDD_1V8 q Out2 BTHHDLLX1
Xq_reg q VSS rst VDD_1V8 In Write DLHRQHDLLX0
.ENDS

.SUBCKT latchtriestado_549 In Out1 Out2 En1 En2 Write rst VSS VDD_1V8
XOut1_tri VSS En1 VDD_1V8 q Out1 BTHHDLLX1
XOut2_tri VSS En2 VDD_1V8 q Out2 BTHHDLLX1
Xq_reg q VSS rst VDD_1V8 In Write DLHRQHDLLX0
.ENDS

.SUBCKT latchtriestado_548 In Out1 Out2 En1 En2 Write rst VSS VDD_1V8
XOut1_tri VSS En1 VDD_1V8 q Out1 BTHHDLLX1
XOut2_tri VSS En2 VDD_1V8 q Out2 BTHHDLLX1
Xq_reg q VSS rst VDD_1V8 In Write DLHRQHDLLX0
.ENDS

.SUBCKT latchtriestado_547 In Out1 Out2 En1 En2 Write rst VSS VDD_1V8
XOut1_tri VSS En1 VDD_1V8 q Out1 BTHHDLLX1
XOut2_tri VSS En2 VDD_1V8 q Out2 BTHHDLLX1
Xq_reg q VSS rst VDD_1V8 In Write DLHRQHDLLX0
.ENDS

.SUBCKT latchtriestado_546 In Out1 Out2 En1 En2 Write rst VSS VDD_1V8
XOut1_tri VSS En1 VDD_1V8 q Out1 BTHHDLLX1
XOut2_tri VSS En2 VDD_1V8 q Out2 BTHHDLLX1
Xq_reg q VSS rst VDD_1V8 In Write DLHRQHDLLX0
.ENDS

.SUBCKT latchtriestado_545 In Out1 Out2 En1 En2 Write rst VSS VDD_1V8
XOut2_tri VSS En2 VDD_1V8 q Out2 BTHHDLLX1
XOut1_tri VSS En1 VDD_1V8 q Out1 BTHHDLLX1
Xq_reg q VSS rst VDD_1V8 In Write DLHRQHDLLX0
.ENDS

.SUBCKT latchtriestado_544 In Out1 Out2 En1 En2 Write rst VSS VDD_1V8
XOut1_tri VSS En1 VDD_1V8 q Out1 BTHHDLLX1
XOut2_tri VSS En2 VDD_1V8 q Out2 BTHHDLLX1
Xq_reg q VSS rst VDD_1V8 In Write DLHRQHDLLX0
.ENDS

.SUBCKT latchtriestado_543 In Out1 Out2 En1 En2 Write rst VSS VDD_1V8
XOut1_tri VSS En1 VDD_1V8 q Out1 BTHHDLLX1
XOut2_tri VSS En2 VDD_1V8 q Out2 BTHHDLLX1
Xq_reg q VSS rst VDD_1V8 In Write DLHRQHDLLX0
.ENDS

.SUBCKT latchtriestado_542 In Out1 Out2 En1 En2 Write rst VSS VDD_1V8
XOut1_tri VSS En1 VDD_1V8 q Out1 BTHHDLLX1
XOut2_tri VSS En2 VDD_1V8 q Out2 BTHHDLLX1
Xq_reg q VSS rst VDD_1V8 In Write DLHRQHDLLX0
.ENDS

.SUBCKT latchtriestado_541 In Out1 Out2 En1 En2 Write rst VSS VDD_1V8
XOut1_tri VSS En1 VDD_1V8 q Out1 BTHHDLLX1
XOut2_tri VSS En2 VDD_1V8 q Out2 BTHHDLLX1
Xq_reg q VSS rst VDD_1V8 In Write DLHRQHDLLX0
.ENDS

.SUBCKT latchtriestado_540 In Out1 Out2 En1 En2 Write rst VSS VDD_1V8
XOut1_tri VSS En1 VDD_1V8 q Out1 BTHHDLLX1
XOut2_tri VSS En2 VDD_1V8 q Out2 BTHHDLLX1
Xq_reg q VSS rst VDD_1V8 In Write DLHRQHDLLX0
.ENDS

.SUBCKT latchtriestado_539 In Out1 Out2 En1 En2 Write rst VSS VDD_1V8
XOut1_tri VSS En1 VDD_1V8 q Out1 BTHHDLLX1
XOut2_tri VSS En2 VDD_1V8 q Out2 BTHHDLLX1
Xq_reg q VSS rst VDD_1V8 In Write DLHRQHDLLX0
.ENDS

.SUBCKT latchtriestado_538 In Out1 Out2 En1 En2 Write rst VSS VDD_1V8
XOut1_tri VSS En1 VDD_1V8 q Out1 BTHHDLLX1
XOut2_tri VSS En2 VDD_1V8 q Out2 BTHHDLLX1
Xq_reg q VSS rst VDD_1V8 In Write DLHRQHDLLX0
.ENDS

.SUBCKT latchtriestado_537 In Out1 Out2 En1 En2 Write rst VSS VDD_1V8
XOut1_tri VSS En1 VDD_1V8 q Out1 BTHHDLLX1
XOut2_tri VSS En2 VDD_1V8 q Out2 BTHHDLLX1
Xq_reg q VSS rst VDD_1V8 In Write DLHRQHDLLX0
.ENDS

.SUBCKT latchtriestado_536 In Out1 Out2 En1 En2 Write rst VSS VDD_1V8
XOut1_tri VSS En1 VDD_1V8 q Out1 BTHHDLLX1
XOut2_tri VSS En2 VDD_1V8 q Out2 BTHHDLLX1
Xq_reg q VSS rst VDD_1V8 In Write DLHRQHDLLX0
.ENDS

.SUBCKT latchtriestado_535 In Out1 Out2 En1 En2 Write rst VSS VDD_1V8
XOut1_tri VSS En1 VDD_1V8 q Out1 BTHHDLLX1
XOut2_tri VSS En2 VDD_1V8 q Out2 BTHHDLLX1
Xq_reg q VSS rst VDD_1V8 In Write DLHRQHDLLX0
.ENDS

.SUBCKT latchtriestado_534 In Out1 Out2 En1 En2 Write rst VSS VDD_1V8
XOut1_tri VSS En1 VDD_1V8 q Out1 BTHHDLLX1
XOut2_tri VSS En2 VDD_1V8 q Out2 BTHHDLLX1
Xq_reg q VSS rst VDD_1V8 In Write DLHRQHDLLX0
.ENDS

.SUBCKT latchtriestado_533 In Out1 Out2 En1 En2 Write rst VSS VDD_1V8
XOut1_tri VSS En1 VDD_1V8 q Out1 BTHHDLLX1
XOut2_tri VSS En2 VDD_1V8 q Out2 BTHHDLLX1
Xq_reg q VSS rst VDD_1V8 In Write DLHRQHDLLX0
.ENDS

.SUBCKT latchtriestado_532 In Out1 Out2 En1 En2 Write rst VSS VDD_1V8
XOut1_tri VSS En1 VDD_1V8 q Out1 BTHHDLLX1
XOut2_tri VSS En2 VDD_1V8 q Out2 BTHHDLLX1
Xq_reg q VSS rst VDD_1V8 In Write DLHRQHDLLX0
.ENDS

.SUBCKT latchtriestado_531 In Out1 Out2 En1 En2 Write rst VSS VDD_1V8
XOut1_tri VSS En1 VDD_1V8 q Out1 BTHHDLLX1
XOut2_tri VSS En2 VDD_1V8 q Out2 BTHHDLLX1
Xq_reg q VSS rst VDD_1V8 In Write DLHRQHDLLX0
.ENDS

.SUBCKT latchtriestado_530 In Out1 Out2 En1 En2 Write rst VSS VDD_1V8
XOut1_tri VSS En1 VDD_1V8 q Out1 BTHHDLLX1
XOut2_tri VSS En2 VDD_1V8 q Out2 BTHHDLLX1
Xq_reg q VSS rst VDD_1V8 In Write DLHRQHDLLX0
.ENDS

.SUBCKT latchtriestado_529 In Out1 Out2 En1 En2 Write rst VSS VDD_1V8
XOut1_tri VSS En1 VDD_1V8 q Out1 BTHHDLLX1
XOut2_tri VSS En2 VDD_1V8 q Out2 BTHHDLLX1
Xq_reg q VSS rst VDD_1V8 In Write DLHRQHDLLX0
.ENDS

.SUBCKT latchtriestado_528 In Out1 Out2 En1 En2 Write rst VSS VDD_1V8
XOut1_tri VSS En1 VDD_1V8 q Out1 BTHHDLLX1
XOut2_tri VSS En2 VDD_1V8 q Out2 BTHHDLLX1
Xq_reg q VSS rst VDD_1V8 In Write DLHRQHDLLX0
.ENDS

.SUBCKT latchtriestado_527 In Out1 Out2 En1 En2 Write rst VSS VDD_1V8
XOut2_tri VSS En2 VDD_1V8 q Out2 BTHHDLLX1
XOut1_tri VSS En1 VDD_1V8 q Out1 BTHHDLLX1
Xq_reg q VSS rst VDD_1V8 In Write DLHRQHDLLX0
.ENDS

.SUBCKT latchtriestado_526 In Out1 Out2 En1 En2 Write rst VSS VDD_1V8
Xq_reg q VSS rst VDD_1V8 In Write DLHRQHDLLX0
XOut2_tri VSS En2 VDD_1V8 q Out2 BTHHDLLX1
XOut1_tri VSS En1 VDD_1V8 q Out1 BTHHDLLX1
.ENDS

.SUBCKT latchtriestado_525 In Out1 Out2 En1 En2 Write rst VSS VDD_1V8
Xq_reg q VSS rst VDD_1V8 In Write DLHRQHDLLX0
XOut2_tri VSS En2 VDD_1V8 q Out2 BTHHDLLX1
XOut1_tri VSS En1 VDD_1V8 q Out1 BTHHDLLX1
.ENDS

.SUBCKT latchtriestado_524 In Out1 Out2 En1 En2 Write rst VSS VDD_1V8
Xq_reg q VSS rst VDD_1V8 In Write DLHRQHDLLX0
XOut2_tri VSS En2 VDD_1V8 q Out2 BTHHDLLX1
XOut1_tri VSS En1 VDD_1V8 q Out1 BTHHDLLX1
.ENDS

.SUBCKT latchtriestado_523 In Out1 Out2 En1 En2 Write rst VSS VDD_1V8
Xq_reg q VSS rst VDD_1V8 In Write DLHRQHDLLX0
XOut1_tri VSS En1 VDD_1V8 q Out1 BTHHDLLX1
XOut2_tri VSS En2 VDD_1V8 q Out2 BTHHDLLX1
.ENDS

.SUBCKT latchtriestado_522 In Out1 Out2 En1 En2 Write rst VSS VDD_1V8
Xq_reg q VSS rst VDD_1V8 In Write DLHRQHDLLX0
XOut1_tri VSS En1 VDD_1V8 q Out1 BTHHDLLX1
XOut2_tri VSS En2 VDD_1V8 q Out2 BTHHDLLX1
.ENDS

.SUBCKT latchtriestado_521 In Out1 Out2 En1 En2 Write rst VSS VDD_1V8
XOut2_tri VSS En2 VDD_1V8 q Out2 BTHHDLLX1
XOut1_tri VSS En1 VDD_1V8 q Out1 BTHHDLLX1
Xq_reg q VSS rst VDD_1V8 In Write DLHRQHDLLX0
.ENDS

.SUBCKT latchtriestado_520 In Out1 Out2 En1 En2 Write rst VSS VDD_1V8
XOut1_tri VSS En1 VDD_1V8 q Out1 BTHHDLLX1
XOut2_tri VSS En2 VDD_1V8 q Out2 BTHHDLLX1
Xq_reg q VSS rst VDD_1V8 In Write DLHRQHDLLX0
.ENDS

.SUBCKT latchtriestado_519 In Out1 Out2 En1 En2 Write rst VSS VDD_1V8
XOut2_tri VSS En2 VDD_1V8 q Out2 BTHHDLLX1
XOut1_tri VSS En1 VDD_1V8 q Out1 BTHHDLLX1
Xq_reg q VSS rst VDD_1V8 In Write DLHRQHDLLX0
.ENDS

.SUBCKT latchtriestado_518 In Out1 Out2 En1 En2 Write rst VSS VDD_1V8
XOut2_tri VSS En2 VDD_1V8 q Out2 BTHHDLLX1
XOut1_tri VSS En1 VDD_1V8 q Out1 BTHHDLLX1
Xq_reg q VSS rst VDD_1V8 In Write DLHRQHDLLX0
.ENDS

.SUBCKT latchtriestado_517 In Out1 Out2 En1 En2 Write rst VSS VDD_1V8
XOut1_tri VSS En1 VDD_1V8 q Out1 BTHHDLLX1
XOut2_tri VSS En2 VDD_1V8 q Out2 BTHHDLLX1
Xq_reg q VSS rst VDD_1V8 In Write DLHRQHDLLX0
.ENDS

.SUBCKT latchtriestado_516 In Out1 Out2 En1 En2 Write rst VSS VDD_1V8
XOut1_tri VSS En1 VDD_1V8 q Out1 BTHHDLLX1
XOut2_tri VSS En2 VDD_1V8 q Out2 BTHHDLLX1
Xq_reg q VSS rst VDD_1V8 In Write DLHRQHDLLX0
.ENDS

.SUBCKT latchtriestado_515 In Out1 Out2 En1 En2 Write rst VSS VDD_1V8
XOut2_tri VSS En2 VDD_1V8 q Out2 BTHHDLLX1
XOut1_tri VSS En1 VDD_1V8 q Out1 BTHHDLLX1
Xq_reg q VSS rst VDD_1V8 In Write DLHRQHDLLX0
.ENDS

.SUBCKT latchtriestado_514 In Out1 Out2 En1 En2 Write rst VSS VDD_1V8
XOut2_tri VSS En2 VDD_1V8 q Out2 BTHHDLLX1
XOut1_tri VSS En1 VDD_1V8 q Out1 BTHHDLLX1
Xq_reg q VSS rst VDD_1V8 In Write DLHRQHDLLX0
.ENDS

.SUBCKT latchtriestado_513 In Out1 Out2 En1 En2 Write rst VSS VDD_1V8
XOut2_tri VSS En2 VDD_1V8 q Out2 BTHHDLLX1
XOut1_tri VSS En1 VDD_1V8 q Out1 BTHHDLLX1
Xq_reg q VSS rst VDD_1V8 In Write DLHRQHDLLX0
.ENDS

.SUBCKT latchtriestado_512 In Out1 Out2 En1 En2 Write rst VSS VDD_1V8
XOut1_tri VSS En1 VDD_1V8 q Out1 BTHHDLLX1
XOut2_tri VSS En2 VDD_1V8 q Out2 BTHHDLLX1
Xq_reg q VSS rst VDD_1V8 In Write DLHRQHDLLX0
.ENDS

.SUBCKT latchtriestado_511 In Out1 Out2 En1 En2 Write rst VSS VDD_1V8
XOut1_tri VSS En1 VDD_1V8 q Out1 BTHHDLLX1
XOut2_tri VSS En2 VDD_1V8 q Out2 BTHHDLLX1
Xq_reg q VSS rst VDD_1V8 In Write DLHRQHDLLX0
.ENDS

.SUBCKT latchtriestado_510 In Out1 Out2 En1 En2 Write rst VSS VDD_1V8
XOut1_tri VSS En1 VDD_1V8 q Out1 BTHHDLLX1
XOut2_tri VSS En2 VDD_1V8 q Out2 BTHHDLLX1
Xq_reg q VSS rst VDD_1V8 In Write DLHRQHDLLX0
.ENDS

.SUBCKT latchtriestado_509 In Out1 Out2 En1 En2 Write rst VSS VDD_1V8
XOut1_tri VSS En1 VDD_1V8 q Out1 BTHHDLLX1
XOut2_tri VSS En2 VDD_1V8 q Out2 BTHHDLLX1
Xq_reg q VSS rst VDD_1V8 In Write DLHRQHDLLX0
.ENDS

.SUBCKT latchtriestado_508 In Out1 Out2 En1 En2 Write rst VSS VDD_1V8
XOut1_tri VSS En1 VDD_1V8 q Out1 BTHHDLLX1
XOut2_tri VSS En2 VDD_1V8 q Out2 BTHHDLLX1
Xq_reg q VSS rst VDD_1V8 In Write DLHRQHDLLX0
.ENDS

.SUBCKT latchtriestado_507 In Out1 Out2 En1 En2 Write rst VSS VDD_1V8
XOut1_tri VSS En1 VDD_1V8 q Out1 BTHHDLLX1
XOut2_tri VSS En2 VDD_1V8 q Out2 BTHHDLLX1
Xq_reg q VSS rst VDD_1V8 In Write DLHRQHDLLX0
.ENDS

.SUBCKT latchtriestado_506 In Out1 Out2 En1 En2 Write rst VSS VDD_1V8
XOut1_tri VSS En1 VDD_1V8 q Out1 BTHHDLLX1
XOut2_tri VSS En2 VDD_1V8 q Out2 BTHHDLLX1
Xq_reg q VSS rst VDD_1V8 In Write DLHRQHDLLX0
.ENDS

.SUBCKT latchtriestado_505 In Out1 Out2 En1 En2 Write rst VSS VDD_1V8
XOut1_tri VSS En1 VDD_1V8 q Out1 BTHHDLLX1
XOut2_tri VSS En2 VDD_1V8 q Out2 BTHHDLLX1
Xq_reg q VSS rst VDD_1V8 In Write DLHRQHDLLX0
.ENDS

.SUBCKT latchtriestado_504 In Out1 Out2 En1 En2 Write rst VSS VDD_1V8
XOut1_tri VSS En1 VDD_1V8 q Out1 BTHHDLLX1
XOut2_tri VSS En2 VDD_1V8 q Out2 BTHHDLLX1
Xq_reg q VSS rst VDD_1V8 In Write DLHRQHDLLX0
.ENDS

.SUBCKT latchtriestado_503 In Out1 Out2 En1 En2 Write rst VSS VDD_1V8
XOut1_tri VSS En1 VDD_1V8 q Out1 BTHHDLLX1
XOut2_tri VSS En2 VDD_1V8 q Out2 BTHHDLLX1
Xq_reg q VSS rst VDD_1V8 In Write DLHRQHDLLX0
.ENDS

.SUBCKT latchtriestado_502 In Out1 Out2 En1 En2 Write rst VSS VDD_1V8
XOut1_tri VSS En1 VDD_1V8 q Out1 BTHHDLLX1
XOut2_tri VSS En2 VDD_1V8 q Out2 BTHHDLLX1
Xq_reg q VSS rst VDD_1V8 In Write DLHRQHDLLX0
.ENDS

.SUBCKT latchtriestado_501 In Out1 Out2 En1 En2 Write rst VSS VDD_1V8
XOut1_tri VSS En1 VDD_1V8 q Out1 BTHHDLLX1
XOut2_tri VSS En2 VDD_1V8 q Out2 BTHHDLLX1
Xq_reg q VSS rst VDD_1V8 In Write DLHRQHDLLX0
.ENDS

.SUBCKT latchtriestado_500 In Out1 Out2 En1 En2 Write rst VSS VDD_1V8
XOut1_tri VSS En1 VDD_1V8 q Out1 BTHHDLLX1
XOut2_tri VSS En2 VDD_1V8 q Out2 BTHHDLLX1
Xq_reg q VSS rst VDD_1V8 In Write DLHRQHDLLX0
.ENDS

.SUBCKT latchtriestado_499 In Out1 Out2 En1 En2 Write rst VSS VDD_1V8
XOut1_tri VSS En1 VDD_1V8 q Out1 BTHHDLLX1
XOut2_tri VSS En2 VDD_1V8 q Out2 BTHHDLLX1
Xq_reg q VSS rst VDD_1V8 In Write DLHRQHDLLX0
.ENDS

.SUBCKT latchtriestado_498 In Out1 Out2 En1 En2 Write rst VSS VDD_1V8
XOut1_tri VSS En1 VDD_1V8 q Out1 BTHHDLLX1
XOut2_tri VSS En2 VDD_1V8 q Out2 BTHHDLLX1
Xq_reg q VSS rst VDD_1V8 In Write DLHRQHDLLX0
.ENDS

.SUBCKT latchtriestado_497 In Out1 Out2 En1 En2 Write rst VSS VDD_1V8
XOut1_tri VSS En1 VDD_1V8 q Out1 BTHHDLLX1
XOut2_tri VSS En2 VDD_1V8 q Out2 BTHHDLLX1
Xq_reg q VSS rst VDD_1V8 In Write DLHRQHDLLX0
.ENDS

.SUBCKT latchtriestado_496 In Out1 Out2 En1 En2 Write rst VSS VDD_1V8
XOut1_tri VSS En1 VDD_1V8 q Out1 BTHHDLLX1
XOut2_tri VSS En2 VDD_1V8 q Out2 BTHHDLLX1
Xq_reg q VSS rst VDD_1V8 In Write DLHRQHDLLX0
.ENDS

.SUBCKT latchtriestado_495 In Out1 Out2 En1 En2 Write rst VSS VDD_1V8
XOut2_tri VSS En2 VDD_1V8 q Out2 BTHHDLLX1
XOut1_tri VSS En1 VDD_1V8 q Out1 BTHHDLLX1
Xq_reg q VSS rst VDD_1V8 In Write DLHRQHDLLX0
.ENDS

.SUBCKT latchtriestado_494 In Out1 Out2 En1 En2 Write rst VSS VDD_1V8
Xq_reg q VSS rst VDD_1V8 In Write DLHRQHDLLX0
XOut2_tri VSS En2 VDD_1V8 q Out2 BTHHDLLX1
XOut1_tri VSS En1 VDD_1V8 q Out1 BTHHDLLX1
.ENDS

.SUBCKT latchtriestado_493 In Out1 Out2 En1 En2 Write rst VSS VDD_1V8
Xq_reg q VSS rst VDD_1V8 In Write DLHRQHDLLX0
XOut2_tri VSS En2 VDD_1V8 q Out2 BTHHDLLX1
XOut1_tri VSS En1 VDD_1V8 q Out1 BTHHDLLX1
.ENDS

.SUBCKT latchtriestado_492 In Out1 Out2 En1 En2 Write rst VSS VDD_1V8
Xq_reg q VSS rst VDD_1V8 In Write DLHRQHDLLX0
XOut2_tri VSS En2 VDD_1V8 q Out2 BTHHDLLX1
XOut1_tri VSS En1 VDD_1V8 q Out1 BTHHDLLX1
.ENDS

.SUBCKT latchtriestado_491 In Out1 Out2 En1 En2 Write rst VSS VDD_1V8
Xq_reg q VSS rst VDD_1V8 In Write DLHRQHDLLX0
XOut2_tri VSS En2 VDD_1V8 q Out2 BTHHDLLX1
XOut1_tri VSS En1 VDD_1V8 q Out1 BTHHDLLX1
.ENDS

.SUBCKT latchtriestado_490 In Out1 Out2 En1 En2 Write rst VSS VDD_1V8
Xq_reg q VSS rst VDD_1V8 In Write DLHRQHDLLX0
XOut2_tri VSS En2 VDD_1V8 q Out2 BTHHDLLX1
XOut1_tri VSS En1 VDD_1V8 q Out1 BTHHDLLX1
.ENDS

.SUBCKT latchtriestado_489 In Out1 Out2 En1 En2 Write rst VSS VDD_1V8
XOut1_tri VSS En1 VDD_1V8 q Out1 BTHHDLLX1
XOut2_tri VSS En2 VDD_1V8 q Out2 BTHHDLLX1
Xq_reg q VSS rst VDD_1V8 In Write DLHRQHDLLX0
.ENDS

.SUBCKT latchtriestado_488 In Out1 Out2 En1 En2 Write rst VSS VDD_1V8
XOut2_tri VSS En2 VDD_1V8 q Out2 BTHHDLLX1
XOut1_tri VSS En1 VDD_1V8 q Out1 BTHHDLLX1
Xq_reg q VSS rst VDD_1V8 In Write DLHRQHDLLX0
.ENDS

.SUBCKT latchtriestado_487 In Out1 Out2 En1 En2 Write rst VSS VDD_1V8
XOut2_tri VSS En2 VDD_1V8 q Out2 BTHHDLLX1
XOut1_tri VSS En1 VDD_1V8 q Out1 BTHHDLLX1
Xq_reg q VSS rst VDD_1V8 In Write DLHRQHDLLX0
.ENDS

.SUBCKT latchtriestado_486 In Out1 Out2 En1 En2 Write rst VSS VDD_1V8
XOut1_tri VSS En1 VDD_1V8 q Out1 BTHHDLLX1
XOut2_tri VSS En2 VDD_1V8 q Out2 BTHHDLLX1
Xq_reg q VSS rst VDD_1V8 In Write DLHRQHDLLX0
.ENDS

.SUBCKT latchtriestado_485 In Out1 Out2 En1 En2 Write rst VSS VDD_1V8
XOut2_tri VSS En2 VDD_1V8 q Out2 BTHHDLLX1
XOut1_tri VSS En1 VDD_1V8 q Out1 BTHHDLLX1
Xq_reg q VSS rst VDD_1V8 In Write DLHRQHDLLX0
.ENDS

.SUBCKT latchtriestado_484 In Out1 Out2 En1 En2 Write rst VSS VDD_1V8
XOut2_tri VSS En2 VDD_1V8 q Out2 BTHHDLLX1
XOut1_tri VSS En1 VDD_1V8 q Out1 BTHHDLLX1
Xq_reg q VSS rst VDD_1V8 In Write DLHRQHDLLX0
.ENDS

.SUBCKT latchtriestado_483 In Out1 Out2 En1 En2 Write rst VSS VDD_1V8
XOut2_tri VSS En2 VDD_1V8 q Out2 BTHHDLLX1
XOut1_tri VSS En1 VDD_1V8 q Out1 BTHHDLLX1
Xq_reg q VSS rst VDD_1V8 In Write DLHRQHDLLX0
.ENDS

.SUBCKT latchtriestado_482 In Out1 Out2 En1 En2 Write rst VSS VDD_1V8
XOut2_tri VSS En2 VDD_1V8 q Out2 BTHHDLLX1
XOut1_tri VSS En1 VDD_1V8 q Out1 BTHHDLLX1
Xq_reg q VSS rst VDD_1V8 In Write DLHRQHDLLX0
.ENDS

.SUBCKT latchtriestado_481 In Out1 Out2 En1 En2 Write rst VSS VDD_1V8
XOut2_tri VSS En2 VDD_1V8 q Out2 BTHHDLLX1
XOut1_tri VSS En1 VDD_1V8 q Out1 BTHHDLLX1
Xq_reg q VSS rst VDD_1V8 In Write DLHRQHDLLX0
.ENDS

.SUBCKT latchtriestado_480 In Out1 Out2 En1 En2 Write rst VSS VDD_1V8
XOut2_tri VSS En2 VDD_1V8 q Out2 BTHHDLLX1
XOut1_tri VSS En1 VDD_1V8 q Out1 BTHHDLLX1
Xq_reg q VSS rst VDD_1V8 In Write DLHRQHDLLX0
.ENDS

.SUBCKT latchtriestado_479 In Out1 Out2 En1 En2 Write rst VSS VDD_1V8
XOut1_tri VSS En1 VDD_1V8 q Out1 BTHHDLLX1
XOut2_tri VSS En2 VDD_1V8 q Out2 BTHHDLLX1
Xq_reg q VSS rst VDD_1V8 In Write DLHRQHDLLX0
.ENDS

.SUBCKT latchtriestado_478 In Out1 Out2 En1 En2 Write rst VSS VDD_1V8
XOut1_tri VSS En1 VDD_1V8 q Out1 BTHHDLLX1
XOut2_tri VSS En2 VDD_1V8 q Out2 BTHHDLLX1
Xq_reg q VSS rst VDD_1V8 In Write DLHRQHDLLX0
.ENDS

.SUBCKT latchtriestado_477 In Out1 Out2 En1 En2 Write rst VSS VDD_1V8
XOut1_tri VSS En1 VDD_1V8 q Out1 BTHHDLLX1
XOut2_tri VSS En2 VDD_1V8 q Out2 BTHHDLLX1
Xq_reg q VSS rst VDD_1V8 In Write DLHRQHDLLX0
.ENDS

.SUBCKT latchtriestado_476 In Out1 Out2 En1 En2 Write rst VSS VDD_1V8
XOut1_tri VSS En1 VDD_1V8 q Out1 BTHHDLLX1
XOut2_tri VSS En2 VDD_1V8 q Out2 BTHHDLLX1
Xq_reg q VSS rst VDD_1V8 In Write DLHRQHDLLX0
.ENDS

.SUBCKT latchtriestado_475 In Out1 Out2 En1 En2 Write rst VSS VDD_1V8
XOut1_tri VSS En1 VDD_1V8 q Out1 BTHHDLLX1
XOut2_tri VSS En2 VDD_1V8 q Out2 BTHHDLLX1
Xq_reg q VSS rst VDD_1V8 In Write DLHRQHDLLX0
.ENDS

.SUBCKT latchtriestado_474 In Out1 Out2 En1 En2 Write rst VSS VDD_1V8
XOut1_tri VSS En1 VDD_1V8 q Out1 BTHHDLLX1
XOut2_tri VSS En2 VDD_1V8 q Out2 BTHHDLLX1
Xq_reg q VSS rst VDD_1V8 In Write DLHRQHDLLX0
.ENDS

.SUBCKT latchtriestado_473 In Out1 Out2 En1 En2 Write rst VSS VDD_1V8
XOut1_tri VSS En1 VDD_1V8 q Out1 BTHHDLLX1
XOut2_tri VSS En2 VDD_1V8 q Out2 BTHHDLLX1
Xq_reg q VSS rst VDD_1V8 In Write DLHRQHDLLX0
.ENDS

.SUBCKT latchtriestado_472 In Out1 Out2 En1 En2 Write rst VSS VDD_1V8
XOut1_tri VSS En1 VDD_1V8 q Out1 BTHHDLLX1
XOut2_tri VSS En2 VDD_1V8 q Out2 BTHHDLLX1
Xq_reg q VSS rst VDD_1V8 In Write DLHRQHDLLX0
.ENDS

.SUBCKT latchtriestado_471 In Out1 Out2 En1 En2 Write rst VSS VDD_1V8
XOut1_tri VSS En1 VDD_1V8 q Out1 BTHHDLLX1
XOut2_tri VSS En2 VDD_1V8 q Out2 BTHHDLLX1
Xq_reg q VSS rst VDD_1V8 In Write DLHRQHDLLX0
.ENDS

.SUBCKT latchtriestado_470 In Out1 Out2 En1 En2 Write rst VSS VDD_1V8
XOut1_tri VSS En1 VDD_1V8 q Out1 BTHHDLLX1
XOut2_tri VSS En2 VDD_1V8 q Out2 BTHHDLLX1
Xq_reg q VSS rst VDD_1V8 In Write DLHRQHDLLX0
.ENDS

.SUBCKT latchtriestado_469 In Out1 Out2 En1 En2 Write rst VSS VDD_1V8
XOut1_tri VSS En1 VDD_1V8 q Out1 BTHHDLLX1
XOut2_tri VSS En2 VDD_1V8 q Out2 BTHHDLLX1
Xq_reg q VSS rst VDD_1V8 In Write DLHRQHDLLX0
.ENDS

.SUBCKT latchtriestado_468 In Out1 Out2 En1 En2 Write rst VSS VDD_1V8
XOut1_tri VSS En1 VDD_1V8 q Out1 BTHHDLLX1
XOut2_tri VSS En2 VDD_1V8 q Out2 BTHHDLLX1
Xq_reg q VSS rst VDD_1V8 In Write DLHRQHDLLX0
.ENDS

.SUBCKT latchtriestado_467 In Out1 Out2 En1 En2 Write rst VSS VDD_1V8
XOut1_tri VSS En1 VDD_1V8 q Out1 BTHHDLLX1
XOut2_tri VSS En2 VDD_1V8 q Out2 BTHHDLLX1
Xq_reg q VSS rst VDD_1V8 In Write DLHRQHDLLX0
.ENDS

.SUBCKT latchtriestado_466 In Out1 Out2 En1 En2 Write rst VSS VDD_1V8
XOut1_tri VSS En1 VDD_1V8 q Out1 BTHHDLLX1
XOut2_tri VSS En2 VDD_1V8 q Out2 BTHHDLLX1
Xq_reg q VSS rst VDD_1V8 In Write DLHRQHDLLX0
.ENDS

.SUBCKT latchtriestado_465 In Out1 Out2 En1 En2 Write rst VSS VDD_1V8
XOut1_tri VSS En1 VDD_1V8 q Out1 BTHHDLLX1
XOut2_tri VSS En2 VDD_1V8 q Out2 BTHHDLLX1
Xq_reg q VSS rst VDD_1V8 In Write DLHRQHDLLX0
.ENDS

.SUBCKT latchtriestado_464 In Out1 Out2 En1 En2 Write rst VSS VDD_1V8
XOut1_tri VSS En1 VDD_1V8 q Out1 BTHHDLLX1
XOut2_tri VSS En2 VDD_1V8 q Out2 BTHHDLLX1
Xq_reg q VSS rst VDD_1V8 In Write DLHRQHDLLX0
.ENDS

.SUBCKT latchtriestado_463 In Out1 Out2 En1 En2 Write rst VSS VDD_1V8
XOut1_tri VSS En1 VDD_1V8 q Out1 BTHHDLLX1
XOut2_tri VSS En2 VDD_1V8 q Out2 BTHHDLLX1
Xq_reg q VSS rst VDD_1V8 In Write DLHRQHDLLX0
.ENDS

.SUBCKT latchtriestado_462 In Out1 Out2 En1 En2 Write rst VSS VDD_1V8
Xq_reg q VSS rst VDD_1V8 In Write DLHRQHDLLX0
XOut2_tri VSS En2 VDD_1V8 q Out2 BTHHDLLX1
XOut1_tri VSS En1 VDD_1V8 q Out1 BTHHDLLX1
.ENDS

.SUBCKT latchtriestado_461 In Out1 Out2 En1 En2 Write rst VSS VDD_1V8
Xq_reg q VSS rst VDD_1V8 In Write DLHRQHDLLX0
XOut1_tri VSS En1 VDD_1V8 q Out1 BTHHDLLX1
XOut2_tri VSS En2 VDD_1V8 q Out2 BTHHDLLX1
.ENDS

.SUBCKT latchtriestado_460 In Out1 Out2 En1 En2 Write rst VSS VDD_1V8
Xq_reg q VSS rst VDD_1V8 In Write DLHRQHDLLX0
XOut1_tri VSS En1 VDD_1V8 q Out1 BTHHDLLX1
XOut2_tri VSS En2 VDD_1V8 q Out2 BTHHDLLX1
.ENDS

.SUBCKT latchtriestado_459 In Out1 Out2 En1 En2 Write rst VSS VDD_1V8
Xq_reg q VSS rst VDD_1V8 In Write DLHRQHDLLX0
XOut1_tri VSS En1 VDD_1V8 q Out1 BTHHDLLX1
XOut2_tri VSS En2 VDD_1V8 q Out2 BTHHDLLX1
.ENDS

.SUBCKT latchtriestado_458 In Out1 Out2 En1 En2 Write rst VSS VDD_1V8
Xq_reg q VSS rst VDD_1V8 In Write DLHRQHDLLX0
XOut1_tri VSS En1 VDD_1V8 q Out1 BTHHDLLX1
XOut2_tri VSS En2 VDD_1V8 q Out2 BTHHDLLX1
.ENDS

.SUBCKT latchtriestado_457 In Out1 Out2 En1 En2 Write rst VSS VDD_1V8
XOut2_tri VSS En2 VDD_1V8 q Out2 BTHHDLLX1
XOut1_tri VSS En1 VDD_1V8 q Out1 BTHHDLLX1
Xq_reg q VSS rst VDD_1V8 In Write DLHRQHDLLX0
.ENDS

.SUBCKT latchtriestado_456 In Out1 Out2 En1 En2 Write rst VSS VDD_1V8
XOut1_tri VSS En1 VDD_1V8 q Out1 BTHHDLLX1
XOut2_tri VSS En2 VDD_1V8 q Out2 BTHHDLLX1
Xq_reg q VSS rst VDD_1V8 In Write DLHRQHDLLX0
.ENDS

.SUBCKT latchtriestado_455 In Out1 Out2 En1 En2 Write rst VSS VDD_1V8
XOut1_tri VSS En1 VDD_1V8 q Out1 BTHHDLLX1
XOut2_tri VSS En2 VDD_1V8 q Out2 BTHHDLLX1
Xq_reg q VSS rst VDD_1V8 In Write DLHRQHDLLX0
.ENDS

.SUBCKT latchtriestado_454 In Out1 Out2 En1 En2 Write rst VSS VDD_1V8
XOut2_tri VSS En2 VDD_1V8 q Out2 BTHHDLLX1
XOut1_tri VSS En1 VDD_1V8 q Out1 BTHHDLLX1
Xq_reg q VSS rst VDD_1V8 In Write DLHRQHDLLX0
.ENDS

.SUBCKT latchtriestado_453 In Out1 Out2 En1 En2 Write rst VSS VDD_1V8
XOut1_tri VSS En1 VDD_1V8 q Out1 BTHHDLLX1
XOut2_tri VSS En2 VDD_1V8 q Out2 BTHHDLLX1
Xq_reg q VSS rst VDD_1V8 In Write DLHRQHDLLX0
.ENDS

.SUBCKT latchtriestado_452 In Out1 Out2 En1 En2 Write rst VSS VDD_1V8
XOut1_tri VSS En1 VDD_1V8 q Out1 BTHHDLLX1
XOut2_tri VSS En2 VDD_1V8 q Out2 BTHHDLLX1
Xq_reg q VSS rst VDD_1V8 In Write DLHRQHDLLX0
.ENDS

.SUBCKT latchtriestado_451 In Out1 Out2 En1 En2 Write rst VSS VDD_1V8
XOut1_tri VSS En1 VDD_1V8 q Out1 BTHHDLLX1
XOut2_tri VSS En2 VDD_1V8 q Out2 BTHHDLLX1
Xq_reg q VSS rst VDD_1V8 In Write DLHRQHDLLX0
.ENDS

.SUBCKT latchtriestado_450 In Out1 Out2 En1 En2 Write rst VSS VDD_1V8
XOut1_tri VSS En1 VDD_1V8 q Out1 BTHHDLLX1
XOut2_tri VSS En2 VDD_1V8 q Out2 BTHHDLLX1
Xq_reg q VSS rst VDD_1V8 In Write DLHRQHDLLX0
.ENDS

.SUBCKT latchtriestado_449 In Out1 Out2 En1 En2 Write rst VSS VDD_1V8
XOut1_tri VSS En1 VDD_1V8 q Out1 BTHHDLLX1
XOut2_tri VSS En2 VDD_1V8 q Out2 BTHHDLLX1
Xq_reg q VSS rst VDD_1V8 In Write DLHRQHDLLX0
.ENDS

.SUBCKT latchtriestado_448 In Out1 Out2 En1 En2 Write rst VSS VDD_1V8
XOut1_tri VSS En1 VDD_1V8 q Out1 BTHHDLLX1
XOut2_tri VSS En2 VDD_1V8 q Out2 BTHHDLLX1
Xq_reg q VSS rst VDD_1V8 In Write DLHRQHDLLX0
.ENDS

.SUBCKT latchtriestado_447 In Out1 Out2 En1 En2 Write rst VSS VDD_1V8
XOut1_tri VSS En1 VDD_1V8 q Out1 BTHHDLLX1
XOut2_tri VSS En2 VDD_1V8 q Out2 BTHHDLLX1
Xq_reg q VSS rst VDD_1V8 In Write DLHRQHDLLX0
.ENDS

.SUBCKT latchtriestado_446 In Out1 Out2 En1 En2 Write rst VSS VDD_1V8
XOut1_tri VSS En1 VDD_1V8 q Out1 BTHHDLLX1
XOut2_tri VSS En2 VDD_1V8 q Out2 BTHHDLLX1
Xq_reg q VSS rst VDD_1V8 In Write DLHRQHDLLX0
.ENDS

.SUBCKT latchtriestado_445 In Out1 Out2 En1 En2 Write rst VSS VDD_1V8
XOut1_tri VSS En1 VDD_1V8 q Out1 BTHHDLLX1
XOut2_tri VSS En2 VDD_1V8 q Out2 BTHHDLLX1
Xq_reg q VSS rst VDD_1V8 In Write DLHRQHDLLX0
.ENDS

.SUBCKT latchtriestado_444 In Out1 Out2 En1 En2 Write rst VSS VDD_1V8
XOut1_tri VSS En1 VDD_1V8 q Out1 BTHHDLLX1
XOut2_tri VSS En2 VDD_1V8 q Out2 BTHHDLLX1
Xq_reg q VSS rst VDD_1V8 In Write DLHRQHDLLX0
.ENDS

.SUBCKT latchtriestado_443 In Out1 Out2 En1 En2 Write rst VSS VDD_1V8
XOut1_tri VSS En1 VDD_1V8 q Out1 BTHHDLLX1
XOut2_tri VSS En2 VDD_1V8 q Out2 BTHHDLLX1
Xq_reg q VSS rst VDD_1V8 In Write DLHRQHDLLX0
.ENDS

.SUBCKT latchtriestado_442 In Out1 Out2 En1 En2 Write rst VSS VDD_1V8
XOut1_tri VSS En1 VDD_1V8 q Out1 BTHHDLLX1
XOut2_tri VSS En2 VDD_1V8 q Out2 BTHHDLLX1
Xq_reg q VSS rst VDD_1V8 In Write DLHRQHDLLX0
.ENDS

.SUBCKT latchtriestado_441 In Out1 Out2 En1 En2 Write rst VSS VDD_1V8
XOut1_tri VSS En1 VDD_1V8 q Out1 BTHHDLLX1
XOut2_tri VSS En2 VDD_1V8 q Out2 BTHHDLLX1
Xq_reg q VSS rst VDD_1V8 In Write DLHRQHDLLX0
.ENDS

.SUBCKT latchtriestado_440 In Out1 Out2 En1 En2 Write rst VSS VDD_1V8
XOut1_tri VSS En1 VDD_1V8 q Out1 BTHHDLLX1
XOut2_tri VSS En2 VDD_1V8 q Out2 BTHHDLLX1
Xq_reg q VSS rst VDD_1V8 In Write DLHRQHDLLX0
.ENDS

.SUBCKT latchtriestado_439 In Out1 Out2 En1 En2 Write rst VSS VDD_1V8
XOut1_tri VSS En1 VDD_1V8 q Out1 BTHHDLLX1
XOut2_tri VSS En2 VDD_1V8 q Out2 BTHHDLLX1
Xq_reg q VSS rst VDD_1V8 In Write DLHRQHDLLX0
.ENDS

.SUBCKT latchtriestado_438 In Out1 Out2 En1 En2 Write rst VSS VDD_1V8
XOut1_tri VSS En1 VDD_1V8 q Out1 BTHHDLLX1
XOut2_tri VSS En2 VDD_1V8 q Out2 BTHHDLLX1
Xq_reg q VSS rst VDD_1V8 In Write DLHRQHDLLX0
.ENDS

.SUBCKT latchtriestado_437 In Out1 Out2 En1 En2 Write rst VSS VDD_1V8
XOut1_tri VSS En1 VDD_1V8 q Out1 BTHHDLLX1
XOut2_tri VSS En2 VDD_1V8 q Out2 BTHHDLLX1
Xq_reg q VSS rst VDD_1V8 In Write DLHRQHDLLX0
.ENDS

.SUBCKT latchtriestado_436 In Out1 Out2 En1 En2 Write rst VSS VDD_1V8
XOut1_tri VSS En1 VDD_1V8 q Out1 BTHHDLLX1
XOut2_tri VSS En2 VDD_1V8 q Out2 BTHHDLLX1
Xq_reg q VSS rst VDD_1V8 In Write DLHRQHDLLX0
.ENDS

.SUBCKT latchtriestado_435 In Out1 Out2 En1 En2 Write rst VSS VDD_1V8
XOut2_tri VSS En2 VDD_1V8 q Out2 BTHHDLLX1
XOut1_tri VSS En1 VDD_1V8 q Out1 BTHHDLLX1
Xq_reg q VSS rst VDD_1V8 In Write DLHRQHDLLX0
.ENDS

.SUBCKT latchtriestado_434 In Out1 Out2 En1 En2 Write rst VSS VDD_1V8
XOut1_tri VSS En1 VDD_1V8 q Out1 BTHHDLLX1
XOut2_tri VSS En2 VDD_1V8 q Out2 BTHHDLLX1
Xq_reg q VSS rst VDD_1V8 In Write DLHRQHDLLX0
.ENDS

.SUBCKT latchtriestado_433 In Out1 Out2 En1 En2 Write rst VSS VDD_1V8
XOut2_tri VSS En2 VDD_1V8 q Out2 BTHHDLLX1
XOut1_tri VSS En1 VDD_1V8 q Out1 BTHHDLLX1
Xq_reg q VSS rst VDD_1V8 In Write DLHRQHDLLX0
.ENDS

.SUBCKT latchtriestado_432 In Out1 Out2 En1 En2 Write rst VSS VDD_1V8
XOut2_tri VSS En2 VDD_1V8 q Out2 BTHHDLLX1
XOut1_tri VSS En1 VDD_1V8 q Out1 BTHHDLLX1
Xq_reg q VSS rst VDD_1V8 In Write DLHRQHDLLX0
.ENDS

.SUBCKT latchtriestado_431 In Out1 Out2 En1 En2 Write rst VSS VDD_1V8
XOut2_tri VSS En2 VDD_1V8 q Out2 BTHHDLLX1
XOut1_tri VSS En1 VDD_1V8 q Out1 BTHHDLLX1
Xq_reg q VSS rst VDD_1V8 In Write DLHRQHDLLX0
.ENDS

.SUBCKT latchtriestado_430 In Out1 Out2 En1 En2 Write rst VSS VDD_1V8
Xq_reg q VSS rst VDD_1V8 In Write DLHRQHDLLX0
XOut2_tri VSS En2 VDD_1V8 q Out2 BTHHDLLX1
XOut1_tri VSS En1 VDD_1V8 q Out1 BTHHDLLX1
.ENDS

.SUBCKT latchtriestado_429 In Out1 Out2 En1 En2 Write rst VSS VDD_1V8
Xq_reg q VSS rst VDD_1V8 In Write DLHRQHDLLX0
XOut2_tri VSS En2 VDD_1V8 q Out2 BTHHDLLX1
XOut1_tri VSS En1 VDD_1V8 q Out1 BTHHDLLX1
.ENDS

.SUBCKT latchtriestado_428 In Out1 Out2 En1 En2 Write rst VSS VDD_1V8
Xq_reg q VSS rst VDD_1V8 In Write DLHRQHDLLX0
XOut2_tri VSS En2 VDD_1V8 q Out2 BTHHDLLX1
XOut1_tri VSS En1 VDD_1V8 q Out1 BTHHDLLX1
.ENDS

.SUBCKT latchtriestado_427 In Out1 Out2 En1 En2 Write rst VSS VDD_1V8
Xq_reg q VSS rst VDD_1V8 In Write DLHRQHDLLX0
XOut2_tri VSS En2 VDD_1V8 q Out2 BTHHDLLX1
XOut1_tri VSS En1 VDD_1V8 q Out1 BTHHDLLX1
.ENDS

.SUBCKT latchtriestado_426 In Out1 Out2 En1 En2 Write rst VSS VDD_1V8
Xq_reg q VSS rst VDD_1V8 In Write DLHRQHDLLX0
XOut2_tri VSS En2 VDD_1V8 q Out2 BTHHDLLX1
XOut1_tri VSS En1 VDD_1V8 q Out1 BTHHDLLX1
.ENDS

.SUBCKT latchtriestado_425 In Out1 Out2 En1 En2 Write rst VSS VDD_1V8
XOut1_tri VSS En1 VDD_1V8 q Out1 BTHHDLLX1
XOut2_tri VSS En2 VDD_1V8 q Out2 BTHHDLLX1
Xq_reg q VSS rst VDD_1V8 In Write DLHRQHDLLX0
.ENDS

.SUBCKT latchtriestado_424 In Out1 Out2 En1 En2 Write rst VSS VDD_1V8
XOut2_tri VSS En2 VDD_1V8 q Out2 BTHHDLLX1
XOut1_tri VSS En1 VDD_1V8 q Out1 BTHHDLLX1
Xq_reg q VSS rst VDD_1V8 In Write DLHRQHDLLX0
.ENDS

.SUBCKT latchtriestado_423 In Out1 Out2 En1 En2 Write rst VSS VDD_1V8
XOut1_tri VSS En1 VDD_1V8 q Out1 BTHHDLLX1
XOut2_tri VSS En2 VDD_1V8 q Out2 BTHHDLLX1
Xq_reg q VSS rst VDD_1V8 In Write DLHRQHDLLX0
.ENDS

.SUBCKT latchtriestado_422 In Out1 Out2 En1 En2 Write rst VSS VDD_1V8
XOut1_tri VSS En1 VDD_1V8 q Out1 BTHHDLLX1
XOut2_tri VSS En2 VDD_1V8 q Out2 BTHHDLLX1
Xq_reg q VSS rst VDD_1V8 In Write DLHRQHDLLX0
.ENDS

.SUBCKT latchtriestado_421 In Out1 Out2 En1 En2 Write rst VSS VDD_1V8
XOut2_tri VSS En2 VDD_1V8 q Out2 BTHHDLLX1
XOut1_tri VSS En1 VDD_1V8 q Out1 BTHHDLLX1
Xq_reg q VSS rst VDD_1V8 In Write DLHRQHDLLX0
.ENDS

.SUBCKT latchtriestado_420 In Out1 Out2 En1 En2 Write rst VSS VDD_1V8
XOut2_tri VSS En2 VDD_1V8 q Out2 BTHHDLLX1
XOut1_tri VSS En1 VDD_1V8 q Out1 BTHHDLLX1
Xq_reg q VSS rst VDD_1V8 In Write DLHRQHDLLX0
.ENDS

.SUBCKT latchtriestado_419 In Out1 Out2 En1 En2 Write rst VSS VDD_1V8
XOut2_tri VSS En2 VDD_1V8 q Out2 BTHHDLLX1
XOut1_tri VSS En1 VDD_1V8 q Out1 BTHHDLLX1
Xq_reg q VSS rst VDD_1V8 In Write DLHRQHDLLX0
.ENDS

.SUBCKT latchtriestado_418 In Out1 Out2 En1 En2 Write rst VSS VDD_1V8
XOut2_tri VSS En2 VDD_1V8 q Out2 BTHHDLLX1
XOut1_tri VSS En1 VDD_1V8 q Out1 BTHHDLLX1
Xq_reg q VSS rst VDD_1V8 In Write DLHRQHDLLX0
.ENDS

.SUBCKT latchtriestado_417 In Out1 Out2 En1 En2 Write rst VSS VDD_1V8
XOut1_tri VSS En1 VDD_1V8 q Out1 BTHHDLLX1
XOut2_tri VSS En2 VDD_1V8 q Out2 BTHHDLLX1
Xq_reg q VSS rst VDD_1V8 In Write DLHRQHDLLX0
.ENDS

.SUBCKT latchtriestado_416 In Out1 Out2 En1 En2 Write rst VSS VDD_1V8
XOut1_tri VSS En1 VDD_1V8 q Out1 BTHHDLLX1
XOut2_tri VSS En2 VDD_1V8 q Out2 BTHHDLLX1
Xq_reg q VSS rst VDD_1V8 In Write DLHRQHDLLX0
.ENDS

.SUBCKT latchtriestado_415 In Out1 Out2 En1 En2 Write rst VSS VDD_1V8
XOut1_tri VSS En1 VDD_1V8 q Out1 BTHHDLLX1
XOut2_tri VSS En2 VDD_1V8 q Out2 BTHHDLLX1
Xq_reg q VSS rst VDD_1V8 In Write DLHRQHDLLX0
.ENDS

.SUBCKT latchtriestado_414 In Out1 Out2 En1 En2 Write rst VSS VDD_1V8
XOut1_tri VSS En1 VDD_1V8 q Out1 BTHHDLLX1
XOut2_tri VSS En2 VDD_1V8 q Out2 BTHHDLLX1
Xq_reg q VSS rst VDD_1V8 In Write DLHRQHDLLX0
.ENDS

.SUBCKT latchtriestado_413 In Out1 Out2 En1 En2 Write rst VSS VDD_1V8
XOut1_tri VSS En1 VDD_1V8 q Out1 BTHHDLLX1
XOut2_tri VSS En2 VDD_1V8 q Out2 BTHHDLLX1
Xq_reg q VSS rst VDD_1V8 In Write DLHRQHDLLX0
.ENDS

.SUBCKT latchtriestado_412 In Out1 Out2 En1 En2 Write rst VSS VDD_1V8
XOut1_tri VSS En1 VDD_1V8 q Out1 BTHHDLLX1
XOut2_tri VSS En2 VDD_1V8 q Out2 BTHHDLLX1
Xq_reg q VSS rst VDD_1V8 In Write DLHRQHDLLX0
.ENDS

.SUBCKT latchtriestado_411 In Out1 Out2 En1 En2 Write rst VSS VDD_1V8
XOut1_tri VSS En1 VDD_1V8 q Out1 BTHHDLLX1
XOut2_tri VSS En2 VDD_1V8 q Out2 BTHHDLLX1
Xq_reg q VSS rst VDD_1V8 In Write DLHRQHDLLX0
.ENDS

.SUBCKT latchtriestado_410 In Out1 Out2 En1 En2 Write rst VSS VDD_1V8
XOut1_tri VSS En1 VDD_1V8 q Out1 BTHHDLLX1
XOut2_tri VSS En2 VDD_1V8 q Out2 BTHHDLLX1
Xq_reg q VSS rst VDD_1V8 In Write DLHRQHDLLX0
.ENDS

.SUBCKT latchtriestado_409 In Out1 Out2 En1 En2 Write rst VSS VDD_1V8
XOut1_tri VSS En1 VDD_1V8 q Out1 BTHHDLLX1
XOut2_tri VSS En2 VDD_1V8 q Out2 BTHHDLLX1
Xq_reg q VSS rst VDD_1V8 In Write DLHRQHDLLX0
.ENDS

.SUBCKT latchtriestado_408 In Out1 Out2 En1 En2 Write rst VSS VDD_1V8
XOut1_tri VSS En1 VDD_1V8 q Out1 BTHHDLLX1
XOut2_tri VSS En2 VDD_1V8 q Out2 BTHHDLLX1
Xq_reg q VSS rst VDD_1V8 In Write DLHRQHDLLX0
.ENDS

.SUBCKT latchtriestado_407 In Out1 Out2 En1 En2 Write rst VSS VDD_1V8
XOut1_tri VSS En1 VDD_1V8 q Out1 BTHHDLLX1
XOut2_tri VSS En2 VDD_1V8 q Out2 BTHHDLLX1
Xq_reg q VSS rst VDD_1V8 In Write DLHRQHDLLX0
.ENDS

.SUBCKT latchtriestado_406 In Out1 Out2 En1 En2 Write rst VSS VDD_1V8
XOut2_tri VSS En2 VDD_1V8 q Out2 BTHHDLLX1
XOut1_tri VSS En1 VDD_1V8 q Out1 BTHHDLLX1
Xq_reg q VSS rst VDD_1V8 In Write DLHRQHDLLX0
.ENDS

.SUBCKT latchtriestado_405 In Out1 Out2 En1 En2 Write rst VSS VDD_1V8
XOut1_tri VSS En1 VDD_1V8 q Out1 BTHHDLLX1
XOut2_tri VSS En2 VDD_1V8 q Out2 BTHHDLLX1
Xq_reg q VSS rst VDD_1V8 In Write DLHRQHDLLX0
.ENDS

.SUBCKT latchtriestado_404 In Out1 Out2 En1 En2 Write rst VSS VDD_1V8
XOut1_tri VSS En1 VDD_1V8 q Out1 BTHHDLLX1
XOut2_tri VSS En2 VDD_1V8 q Out2 BTHHDLLX1
Xq_reg q VSS rst VDD_1V8 In Write DLHRQHDLLX0
.ENDS

.SUBCKT latchtriestado_403 In Out1 Out2 En1 En2 Write rst VSS VDD_1V8
XOut2_tri VSS En2 VDD_1V8 q Out2 BTHHDLLX1
XOut1_tri VSS En1 VDD_1V8 q Out1 BTHHDLLX1
Xq_reg q VSS rst VDD_1V8 In Write DLHRQHDLLX0
.ENDS

.SUBCKT latchtriestado_402 In Out1 Out2 En1 En2 Write rst VSS VDD_1V8
XOut2_tri VSS En2 VDD_1V8 q Out2 BTHHDLLX1
XOut1_tri VSS En1 VDD_1V8 q Out1 BTHHDLLX1
Xq_reg q VSS rst VDD_1V8 In Write DLHRQHDLLX0
.ENDS

.SUBCKT latchtriestado_401 In Out1 Out2 En1 En2 Write rst VSS VDD_1V8
XOut2_tri VSS En2 VDD_1V8 q Out2 BTHHDLLX1
XOut1_tri VSS En1 VDD_1V8 q Out1 BTHHDLLX1
Xq_reg q VSS rst VDD_1V8 In Write DLHRQHDLLX0
.ENDS

.SUBCKT latchtriestado_400 In Out1 Out2 En1 En2 Write rst VSS VDD_1V8
XOut1_tri VSS En1 VDD_1V8 q Out1 BTHHDLLX1
XOut2_tri VSS En2 VDD_1V8 q Out2 BTHHDLLX1
Xq_reg q VSS rst VDD_1V8 In Write DLHRQHDLLX0
.ENDS

.SUBCKT latchtriestado_399 In Out1 Out2 En1 En2 Write rst VSS VDD_1V8
XOut2_tri VSS En2 VDD_1V8 q Out2 BTHHDLLX1
XOut1_tri VSS En1 VDD_1V8 q Out1 BTHHDLLX1
Xq_reg q VSS rst VDD_1V8 In Write DLHRQHDLLX0
.ENDS

.SUBCKT latchtriestado_398 In Out1 Out2 En1 En2 Write rst VSS VDD_1V8
Xq_reg q VSS rst VDD_1V8 In Write DLHRQHDLLX0
XOut2_tri VSS En2 VDD_1V8 q Out2 BTHHDLLX1
XOut1_tri VSS En1 VDD_1V8 q Out1 BTHHDLLX1
.ENDS

.SUBCKT latchtriestado_397 In Out1 Out2 En1 En2 Write rst VSS VDD_1V8
Xq_reg q VSS rst VDD_1V8 In Write DLHRQHDLLX0
XOut1_tri VSS En1 VDD_1V8 q Out1 BTHHDLLX1
XOut2_tri VSS En2 VDD_1V8 q Out2 BTHHDLLX1
.ENDS

.SUBCKT latchtriestado_396 In Out1 Out2 En1 En2 Write rst VSS VDD_1V8
Xq_reg q VSS rst VDD_1V8 In Write DLHRQHDLLX0
XOut2_tri VSS En2 VDD_1V8 q Out2 BTHHDLLX1
XOut1_tri VSS En1 VDD_1V8 q Out1 BTHHDLLX1
.ENDS

.SUBCKT latchtriestado_395 In Out1 Out2 En1 En2 Write rst VSS VDD_1V8
Xq_reg q VSS rst VDD_1V8 In Write DLHRQHDLLX0
XOut2_tri VSS En2 VDD_1V8 q Out2 BTHHDLLX1
XOut1_tri VSS En1 VDD_1V8 q Out1 BTHHDLLX1
.ENDS

.SUBCKT latchtriestado_394 In Out1 Out2 En1 En2 Write rst VSS VDD_1V8
Xq_reg q VSS rst VDD_1V8 In Write DLHRQHDLLX0
XOut1_tri VSS En1 VDD_1V8 q Out1 BTHHDLLX1
XOut2_tri VSS En2 VDD_1V8 q Out2 BTHHDLLX1
.ENDS

.SUBCKT latchtriestado_393 In Out1 Out2 En1 En2 Write rst VSS VDD_1V8
XOut1_tri VSS En1 VDD_1V8 q Out1 BTHHDLLX1
XOut2_tri VSS En2 VDD_1V8 q Out2 BTHHDLLX1
Xq_reg q VSS rst VDD_1V8 In Write DLHRQHDLLX0
.ENDS

.SUBCKT latchtriestado_392 In Out1 Out2 En1 En2 Write rst VSS VDD_1V8
XOut2_tri VSS En2 VDD_1V8 q Out2 BTHHDLLX1
XOut1_tri VSS En1 VDD_1V8 q Out1 BTHHDLLX1
Xq_reg q VSS rst VDD_1V8 In Write DLHRQHDLLX0
.ENDS

.SUBCKT latchtriestado_391 In Out1 Out2 En1 En2 Write rst VSS VDD_1V8
XOut2_tri VSS En2 VDD_1V8 q Out2 BTHHDLLX1
XOut1_tri VSS En1 VDD_1V8 q Out1 BTHHDLLX1
Xq_reg q VSS rst VDD_1V8 In Write DLHRQHDLLX0
.ENDS

.SUBCKT latchtriestado_390 In Out1 Out2 En1 En2 Write rst VSS VDD_1V8
XOut1_tri VSS En1 VDD_1V8 q Out1 BTHHDLLX1
XOut2_tri VSS En2 VDD_1V8 q Out2 BTHHDLLX1
Xq_reg q VSS rst VDD_1V8 In Write DLHRQHDLLX0
.ENDS

.SUBCKT latchtriestado_389 In Out1 Out2 En1 En2 Write rst VSS VDD_1V8
XOut2_tri VSS En2 VDD_1V8 q Out2 BTHHDLLX1
XOut1_tri VSS En1 VDD_1V8 q Out1 BTHHDLLX1
Xq_reg q VSS rst VDD_1V8 In Write DLHRQHDLLX0
.ENDS

.SUBCKT latchtriestado_388 In Out1 Out2 En1 En2 Write rst VSS VDD_1V8
XOut2_tri VSS En2 VDD_1V8 q Out2 BTHHDLLX1
XOut1_tri VSS En1 VDD_1V8 q Out1 BTHHDLLX1
Xq_reg q VSS rst VDD_1V8 In Write DLHRQHDLLX0
.ENDS

.SUBCKT latchtriestado_387 In Out1 Out2 En1 En2 Write rst VSS VDD_1V8
XOut2_tri VSS En2 VDD_1V8 q Out2 BTHHDLLX1
XOut1_tri VSS En1 VDD_1V8 q Out1 BTHHDLLX1
Xq_reg q VSS rst VDD_1V8 In Write DLHRQHDLLX0
.ENDS

.SUBCKT latchtriestado_386 In Out1 Out2 En1 En2 Write rst VSS VDD_1V8
XOut2_tri VSS En2 VDD_1V8 q Out2 BTHHDLLX1
XOut1_tri VSS En1 VDD_1V8 q Out1 BTHHDLLX1
Xq_reg q VSS rst VDD_1V8 In Write DLHRQHDLLX0
.ENDS

.SUBCKT latchtriestado_385 In Out1 Out2 En1 En2 Write rst VSS VDD_1V8
XOut2_tri VSS En2 VDD_1V8 q Out2 BTHHDLLX1
XOut1_tri VSS En1 VDD_1V8 q Out1 BTHHDLLX1
Xq_reg q VSS rst VDD_1V8 In Write DLHRQHDLLX0
.ENDS

.SUBCKT latchtriestado_384 In Out1 Out2 En1 En2 Write rst VSS VDD_1V8
XOut2_tri VSS En2 VDD_1V8 q Out2 BTHHDLLX1
XOut1_tri VSS En1 VDD_1V8 q Out1 BTHHDLLX1
Xq_reg q VSS rst VDD_1V8 In Write DLHRQHDLLX0
.ENDS

.SUBCKT latchtriestado_383 In Out1 Out2 En1 En2 Write rst VSS VDD_1V8
XOut1_tri VSS En1 VDD_1V8 q Out1 BTHHDLLX1
XOut2_tri VSS En2 VDD_1V8 q Out2 BTHHDLLX1
Xq_reg q VSS rst VDD_1V8 In Write DLHRQHDLLX0
.ENDS

.SUBCKT latchtriestado_382 In Out1 Out2 En1 En2 Write rst VSS VDD_1V8
XOut1_tri VSS En1 VDD_1V8 q Out1 BTHHDLLX1
XOut2_tri VSS En2 VDD_1V8 q Out2 BTHHDLLX1
Xq_reg q VSS rst VDD_1V8 In Write DLHRQHDLLX0
.ENDS

.SUBCKT latchtriestado_381 In Out1 Out2 En1 En2 Write rst VSS VDD_1V8
XOut1_tri VSS En1 VDD_1V8 q Out1 BTHHDLLX1
XOut2_tri VSS En2 VDD_1V8 q Out2 BTHHDLLX1
Xq_reg q VSS rst VDD_1V8 In Write DLHRQHDLLX0
.ENDS

.SUBCKT latchtriestado_380 In Out1 Out2 En1 En2 Write rst VSS VDD_1V8
XOut1_tri VSS En1 VDD_1V8 q Out1 BTHHDLLX1
XOut2_tri VSS En2 VDD_1V8 q Out2 BTHHDLLX1
Xq_reg q VSS rst VDD_1V8 In Write DLHRQHDLLX0
.ENDS

.SUBCKT latchtriestado_379 In Out1 Out2 En1 En2 Write rst VSS VDD_1V8
XOut1_tri VSS En1 VDD_1V8 q Out1 BTHHDLLX1
XOut2_tri VSS En2 VDD_1V8 q Out2 BTHHDLLX1
Xq_reg q VSS rst VDD_1V8 In Write DLHRQHDLLX0
.ENDS

.SUBCKT latchtriestado_378 In Out1 Out2 En1 En2 Write rst VSS VDD_1V8
XOut1_tri VSS En1 VDD_1V8 q Out1 BTHHDLLX1
XOut2_tri VSS En2 VDD_1V8 q Out2 BTHHDLLX1
Xq_reg q VSS rst VDD_1V8 In Write DLHRQHDLLX0
.ENDS

.SUBCKT latchtriestado_377 In Out1 Out2 En1 En2 Write rst VSS VDD_1V8
XOut1_tri VSS En1 VDD_1V8 q Out1 BTHHDLLX1
XOut2_tri VSS En2 VDD_1V8 q Out2 BTHHDLLX1
Xq_reg q VSS rst VDD_1V8 In Write DLHRQHDLLX0
.ENDS

.SUBCKT latchtriestado_376 In Out1 Out2 En1 En2 Write rst VSS VDD_1V8
XOut1_tri VSS En1 VDD_1V8 q Out1 BTHHDLLX1
XOut2_tri VSS En2 VDD_1V8 q Out2 BTHHDLLX1
Xq_reg q VSS rst VDD_1V8 In Write DLHRQHDLLX0
.ENDS

.SUBCKT latchtriestado_375 In Out1 Out2 En1 En2 Write rst VSS VDD_1V8
XOut1_tri VSS En1 VDD_1V8 q Out1 BTHHDLLX1
XOut2_tri VSS En2 VDD_1V8 q Out2 BTHHDLLX1
Xq_reg q VSS rst VDD_1V8 In Write DLHRQHDLLX0
.ENDS

.SUBCKT latchtriestado_374 In Out1 Out2 En1 En2 Write rst VSS VDD_1V8
XOut2_tri VSS En2 VDD_1V8 q Out2 BTHHDLLX1
XOut1_tri VSS En1 VDD_1V8 q Out1 BTHHDLLX1
Xq_reg q VSS rst VDD_1V8 In Write DLHRQHDLLX0
.ENDS

.SUBCKT latchtriestado_373 In Out1 Out2 En1 En2 Write rst VSS VDD_1V8
XOut2_tri VSS En2 VDD_1V8 q Out2 BTHHDLLX1
XOut1_tri VSS En1 VDD_1V8 q Out1 BTHHDLLX1
Xq_reg q VSS rst VDD_1V8 In Write DLHRQHDLLX0
.ENDS

.SUBCKT latchtriestado_372 In Out1 Out2 En1 En2 Write rst VSS VDD_1V8
XOut1_tri VSS En1 VDD_1V8 q Out1 BTHHDLLX1
XOut2_tri VSS En2 VDD_1V8 q Out2 BTHHDLLX1
Xq_reg q VSS rst VDD_1V8 In Write DLHRQHDLLX0
.ENDS

.SUBCKT latchtriestado_371 In Out1 Out2 En1 En2 Write rst VSS VDD_1V8
XOut1_tri VSS En1 VDD_1V8 q Out1 BTHHDLLX1
XOut2_tri VSS En2 VDD_1V8 q Out2 BTHHDLLX1
Xq_reg q VSS rst VDD_1V8 In Write DLHRQHDLLX0
.ENDS

.SUBCKT latchtriestado_370 In Out1 Out2 En1 En2 Write rst VSS VDD_1V8
XOut2_tri VSS En2 VDD_1V8 q Out2 BTHHDLLX1
XOut1_tri VSS En1 VDD_1V8 q Out1 BTHHDLLX1
Xq_reg q VSS rst VDD_1V8 In Write DLHRQHDLLX0
.ENDS

.SUBCKT latchtriestado_369 In Out1 Out2 En1 En2 Write rst VSS VDD_1V8
XOut1_tri VSS En1 VDD_1V8 q Out1 BTHHDLLX1
XOut2_tri VSS En2 VDD_1V8 q Out2 BTHHDLLX1
Xq_reg q VSS rst VDD_1V8 In Write DLHRQHDLLX0
.ENDS

.SUBCKT latchtriestado_368 In Out1 Out2 En1 En2 Write rst VSS VDD_1V8
XOut2_tri VSS En2 VDD_1V8 q Out2 BTHHDLLX1
XOut1_tri VSS En1 VDD_1V8 q Out1 BTHHDLLX1
Xq_reg q VSS rst VDD_1V8 In Write DLHRQHDLLX0
.ENDS

.SUBCKT latchtriestado_367 In Out1 Out2 En1 En2 Write rst VSS VDD_1V8
XOut2_tri VSS En2 VDD_1V8 q Out2 BTHHDLLX1
XOut1_tri VSS En1 VDD_1V8 q Out1 BTHHDLLX1
Xq_reg q VSS rst VDD_1V8 In Write DLHRQHDLLX0
.ENDS

.SUBCKT latchtriestado_366 In Out1 Out2 En1 En2 Write rst VSS VDD_1V8
Xq_reg q VSS rst VDD_1V8 In Write DLHRQHDLLX0
XOut2_tri VSS En2 VDD_1V8 q Out2 BTHHDLLX1
XOut1_tri VSS En1 VDD_1V8 q Out1 BTHHDLLX1
.ENDS

.SUBCKT latchtriestado_365 In Out1 Out2 En1 En2 Write rst VSS VDD_1V8
Xq_reg q VSS rst VDD_1V8 In Write DLHRQHDLLX0
XOut2_tri VSS En2 VDD_1V8 q Out2 BTHHDLLX1
XOut1_tri VSS En1 VDD_1V8 q Out1 BTHHDLLX1
.ENDS

.SUBCKT latchtriestado_364 In Out1 Out2 En1 En2 Write rst VSS VDD_1V8
Xq_reg q VSS rst VDD_1V8 In Write DLHRQHDLLX0
XOut2_tri VSS En2 VDD_1V8 q Out2 BTHHDLLX1
XOut1_tri VSS En1 VDD_1V8 q Out1 BTHHDLLX1
.ENDS

.SUBCKT latchtriestado_363 In Out1 Out2 En1 En2 Write rst VSS VDD_1V8
Xq_reg q VSS rst VDD_1V8 In Write DLHRQHDLLX0
XOut1_tri VSS En1 VDD_1V8 q Out1 BTHHDLLX1
XOut2_tri VSS En2 VDD_1V8 q Out2 BTHHDLLX1
.ENDS

.SUBCKT latchtriestado_362 In Out1 Out2 En1 En2 Write rst VSS VDD_1V8
Xq_reg q VSS rst VDD_1V8 In Write DLHRQHDLLX0
XOut1_tri VSS En1 VDD_1V8 q Out1 BTHHDLLX1
XOut2_tri VSS En2 VDD_1V8 q Out2 BTHHDLLX1
.ENDS

.SUBCKT latchtriestado_361 In Out1 Out2 En1 En2 Write rst VSS VDD_1V8
XOut2_tri VSS En2 VDD_1V8 q Out2 BTHHDLLX1
XOut1_tri VSS En1 VDD_1V8 q Out1 BTHHDLLX1
Xq_reg q VSS rst VDD_1V8 In Write DLHRQHDLLX0
.ENDS

.SUBCKT latchtriestado_360 In Out1 Out2 En1 En2 Write rst VSS VDD_1V8
XOut2_tri VSS En2 VDD_1V8 q Out2 BTHHDLLX1
XOut1_tri VSS En1 VDD_1V8 q Out1 BTHHDLLX1
Xq_reg q VSS rst VDD_1V8 In Write DLHRQHDLLX0
.ENDS

.SUBCKT latchtriestado_359 In Out1 Out2 En1 En2 Write rst VSS VDD_1V8
XOut2_tri VSS En2 VDD_1V8 q Out2 BTHHDLLX1
XOut1_tri VSS En1 VDD_1V8 q Out1 BTHHDLLX1
Xq_reg q VSS rst VDD_1V8 In Write DLHRQHDLLX0
.ENDS

.SUBCKT latchtriestado_358 In Out1 Out2 En1 En2 Write rst VSS VDD_1V8
XOut2_tri VSS En2 VDD_1V8 q Out2 BTHHDLLX1
XOut1_tri VSS En1 VDD_1V8 q Out1 BTHHDLLX1
Xq_reg q VSS rst VDD_1V8 In Write DLHRQHDLLX0
.ENDS

.SUBCKT latchtriestado_357 In Out1 Out2 En1 En2 Write rst VSS VDD_1V8
XOut1_tri VSS En1 VDD_1V8 q Out1 BTHHDLLX1
XOut2_tri VSS En2 VDD_1V8 q Out2 BTHHDLLX1
Xq_reg q VSS rst VDD_1V8 In Write DLHRQHDLLX0
.ENDS

.SUBCKT latchtriestado_356 In Out1 Out2 En1 En2 Write rst VSS VDD_1V8
XOut1_tri VSS En1 VDD_1V8 q Out1 BTHHDLLX1
XOut2_tri VSS En2 VDD_1V8 q Out2 BTHHDLLX1
Xq_reg q VSS rst VDD_1V8 In Write DLHRQHDLLX0
.ENDS

.SUBCKT latchtriestado_355 In Out1 Out2 En1 En2 Write rst VSS VDD_1V8
XOut1_tri VSS En1 VDD_1V8 q Out1 BTHHDLLX1
XOut2_tri VSS En2 VDD_1V8 q Out2 BTHHDLLX1
Xq_reg q VSS rst VDD_1V8 In Write DLHRQHDLLX0
.ENDS

.SUBCKT latchtriestado_354 In Out1 Out2 En1 En2 Write rst VSS VDD_1V8
XOut1_tri VSS En1 VDD_1V8 q Out1 BTHHDLLX1
XOut2_tri VSS En2 VDD_1V8 q Out2 BTHHDLLX1
Xq_reg q VSS rst VDD_1V8 In Write DLHRQHDLLX0
.ENDS

.SUBCKT latchtriestado_353 In Out1 Out2 En1 En2 Write rst VSS VDD_1V8
XOut2_tri VSS En2 VDD_1V8 q Out2 BTHHDLLX1
XOut1_tri VSS En1 VDD_1V8 q Out1 BTHHDLLX1
Xq_reg q VSS rst VDD_1V8 In Write DLHRQHDLLX0
.ENDS

.SUBCKT latchtriestado_352 In Out1 Out2 En1 En2 Write rst VSS VDD_1V8
XOut1_tri VSS En1 VDD_1V8 q Out1 BTHHDLLX1
XOut2_tri VSS En2 VDD_1V8 q Out2 BTHHDLLX1
Xq_reg q VSS rst VDD_1V8 In Write DLHRQHDLLX0
.ENDS

.SUBCKT latchtriestado_351 In Out1 Out2 En1 En2 Write rst VSS VDD_1V8
XOut1_tri VSS En1 VDD_1V8 q Out1 BTHHDLLX1
XOut2_tri VSS En2 VDD_1V8 q Out2 BTHHDLLX1
Xq_reg q VSS rst VDD_1V8 In Write DLHRQHDLLX0
.ENDS

.SUBCKT latchtriestado_350 In Out1 Out2 En1 En2 Write rst VSS VDD_1V8
XOut1_tri VSS En1 VDD_1V8 q Out1 BTHHDLLX1
XOut2_tri VSS En2 VDD_1V8 q Out2 BTHHDLLX1
Xq_reg q VSS rst VDD_1V8 In Write DLHRQHDLLX0
.ENDS

.SUBCKT latchtriestado_349 In Out1 Out2 En1 En2 Write rst VSS VDD_1V8
XOut1_tri VSS En1 VDD_1V8 q Out1 BTHHDLLX1
XOut2_tri VSS En2 VDD_1V8 q Out2 BTHHDLLX1
Xq_reg q VSS rst VDD_1V8 In Write DLHRQHDLLX0
.ENDS

.SUBCKT latchtriestado_348 In Out1 Out2 En1 En2 Write rst VSS VDD_1V8
XOut1_tri VSS En1 VDD_1V8 q Out1 BTHHDLLX1
XOut2_tri VSS En2 VDD_1V8 q Out2 BTHHDLLX1
Xq_reg q VSS rst VDD_1V8 In Write DLHRQHDLLX0
.ENDS

.SUBCKT latchtriestado_347 In Out1 Out2 En1 En2 Write rst VSS VDD_1V8
XOut1_tri VSS En1 VDD_1V8 q Out1 BTHHDLLX1
XOut2_tri VSS En2 VDD_1V8 q Out2 BTHHDLLX1
Xq_reg q VSS rst VDD_1V8 In Write DLHRQHDLLX0
.ENDS

.SUBCKT latchtriestado_346 In Out1 Out2 En1 En2 Write rst VSS VDD_1V8
XOut1_tri VSS En1 VDD_1V8 q Out1 BTHHDLLX1
XOut2_tri VSS En2 VDD_1V8 q Out2 BTHHDLLX1
Xq_reg q VSS rst VDD_1V8 In Write DLHRQHDLLX0
.ENDS

.SUBCKT latchtriestado_345 In Out1 Out2 En1 En2 Write rst VSS VDD_1V8
XOut1_tri VSS En1 VDD_1V8 q Out1 BTHHDLLX1
XOut2_tri VSS En2 VDD_1V8 q Out2 BTHHDLLX1
Xq_reg q VSS rst VDD_1V8 In Write DLHRQHDLLX0
.ENDS

.SUBCKT latchtriestado_344 In Out1 Out2 En1 En2 Write rst VSS VDD_1V8
XOut1_tri VSS En1 VDD_1V8 q Out1 BTHHDLLX1
XOut2_tri VSS En2 VDD_1V8 q Out2 BTHHDLLX1
Xq_reg q VSS rst VDD_1V8 In Write DLHRQHDLLX0
.ENDS

.SUBCKT latchtriestado_343 In Out1 Out2 En1 En2 Write rst VSS VDD_1V8
XOut1_tri VSS En1 VDD_1V8 q Out1 BTHHDLLX1
XOut2_tri VSS En2 VDD_1V8 q Out2 BTHHDLLX1
Xq_reg q VSS rst VDD_1V8 In Write DLHRQHDLLX0
.ENDS

.SUBCKT latchtriestado_342 In Out1 Out2 En1 En2 Write rst VSS VDD_1V8
XOut1_tri VSS En1 VDD_1V8 q Out1 BTHHDLLX1
XOut2_tri VSS En2 VDD_1V8 q Out2 BTHHDLLX1
Xq_reg q VSS rst VDD_1V8 In Write DLHRQHDLLX0
.ENDS

.SUBCKT latchtriestado_341 In Out1 Out2 En1 En2 Write rst VSS VDD_1V8
XOut2_tri VSS En2 VDD_1V8 q Out2 BTHHDLLX1
XOut1_tri VSS En1 VDD_1V8 q Out1 BTHHDLLX1
Xq_reg q VSS rst VDD_1V8 In Write DLHRQHDLLX0
.ENDS

.SUBCKT latchtriestado_340 In Out1 Out2 En1 En2 Write rst VSS VDD_1V8
XOut2_tri VSS En2 VDD_1V8 q Out2 BTHHDLLX1
XOut1_tri VSS En1 VDD_1V8 q Out1 BTHHDLLX1
Xq_reg q VSS rst VDD_1V8 In Write DLHRQHDLLX0
.ENDS

.SUBCKT latchtriestado_339 In Out1 Out2 En1 En2 Write rst VSS VDD_1V8
XOut1_tri VSS En1 VDD_1V8 q Out1 BTHHDLLX1
XOut2_tri VSS En2 VDD_1V8 q Out2 BTHHDLLX1
Xq_reg q VSS rst VDD_1V8 In Write DLHRQHDLLX0
.ENDS

.SUBCKT latchtriestado_338 In Out1 Out2 En1 En2 Write rst VSS VDD_1V8
XOut1_tri VSS En1 VDD_1V8 q Out1 BTHHDLLX1
XOut2_tri VSS En2 VDD_1V8 q Out2 BTHHDLLX1
Xq_reg q VSS rst VDD_1V8 In Write DLHRQHDLLX0
.ENDS

.SUBCKT latchtriestado_337 In Out1 Out2 En1 En2 Write rst VSS VDD_1V8
XOut1_tri VSS En1 VDD_1V8 q Out1 BTHHDLLX1
XOut2_tri VSS En2 VDD_1V8 q Out2 BTHHDLLX1
Xq_reg q VSS rst VDD_1V8 In Write DLHRQHDLLX0
.ENDS

.SUBCKT latchtriestado_336 In Out1 Out2 En1 En2 Write rst VSS VDD_1V8
XOut1_tri VSS En1 VDD_1V8 q Out1 BTHHDLLX1
XOut2_tri VSS En2 VDD_1V8 q Out2 BTHHDLLX1
Xq_reg q VSS rst VDD_1V8 In Write DLHRQHDLLX0
.ENDS

.SUBCKT latchtriestado_335 In Out1 Out2 En1 En2 Write rst VSS VDD_1V8
XOut2_tri VSS En2 VDD_1V8 q Out2 BTHHDLLX1
XOut1_tri VSS En1 VDD_1V8 q Out1 BTHHDLLX1
Xq_reg q VSS rst VDD_1V8 In Write DLHRQHDLLX0
.ENDS

.SUBCKT latchtriestado_334 In Out1 Out2 En1 En2 Write rst VSS VDD_1V8
Xq_reg q VSS rst VDD_1V8 In Write DLHRQHDLLX0
XOut1_tri VSS En1 VDD_1V8 q Out1 BTHHDLLX1
XOut2_tri VSS En2 VDD_1V8 q Out2 BTHHDLLX1
.ENDS

.SUBCKT latchtriestado_333 In Out1 Out2 En1 En2 Write rst VSS VDD_1V8
Xq_reg q VSS rst VDD_1V8 In Write DLHRQHDLLX0
XOut1_tri VSS En1 VDD_1V8 q Out1 BTHHDLLX1
XOut2_tri VSS En2 VDD_1V8 q Out2 BTHHDLLX1
.ENDS

.SUBCKT latchtriestado_332 In Out1 Out2 En1 En2 Write rst VSS VDD_1V8
Xq_reg q VSS rst VDD_1V8 In Write DLHRQHDLLX0
XOut1_tri VSS En1 VDD_1V8 q Out1 BTHHDLLX1
XOut2_tri VSS En2 VDD_1V8 q Out2 BTHHDLLX1
.ENDS

.SUBCKT latchtriestado_331 In Out1 Out2 En1 En2 Write rst VSS VDD_1V8
Xq_reg q VSS rst VDD_1V8 In Write DLHRQHDLLX0
XOut1_tri VSS En1 VDD_1V8 q Out1 BTHHDLLX1
XOut2_tri VSS En2 VDD_1V8 q Out2 BTHHDLLX1
.ENDS

.SUBCKT latchtriestado_330 In Out1 Out2 En1 En2 Write rst VSS VDD_1V8
Xq_reg q VSS rst VDD_1V8 In Write DLHRQHDLLX0
XOut1_tri VSS En1 VDD_1V8 q Out1 BTHHDLLX1
XOut2_tri VSS En2 VDD_1V8 q Out2 BTHHDLLX1
.ENDS

.SUBCKT latchtriestado_329 In Out1 Out2 En1 En2 Write rst VSS VDD_1V8
XOut2_tri VSS En2 VDD_1V8 q Out2 BTHHDLLX1
XOut1_tri VSS En1 VDD_1V8 q Out1 BTHHDLLX1
Xq_reg q VSS rst VDD_1V8 In Write DLHRQHDLLX0
.ENDS

.SUBCKT latchtriestado_328 In Out1 Out2 En1 En2 Write rst VSS VDD_1V8
XOut1_tri VSS En1 VDD_1V8 q Out1 BTHHDLLX1
XOut2_tri VSS En2 VDD_1V8 q Out2 BTHHDLLX1
Xq_reg q VSS rst VDD_1V8 In Write DLHRQHDLLX0
.ENDS

.SUBCKT latchtriestado_327 In Out1 Out2 En1 En2 Write rst VSS VDD_1V8
XOut1_tri VSS En1 VDD_1V8 q Out1 BTHHDLLX1
XOut2_tri VSS En2 VDD_1V8 q Out2 BTHHDLLX1
Xq_reg q VSS rst VDD_1V8 In Write DLHRQHDLLX0
.ENDS

.SUBCKT latchtriestado_326 In Out1 Out2 En1 En2 Write rst VSS VDD_1V8
XOut2_tri VSS En2 VDD_1V8 q Out2 BTHHDLLX1
XOut1_tri VSS En1 VDD_1V8 q Out1 BTHHDLLX1
Xq_reg q VSS rst VDD_1V8 In Write DLHRQHDLLX0
.ENDS

.SUBCKT latchtriestado_325 In Out1 Out2 En1 En2 Write rst VSS VDD_1V8
XOut1_tri VSS En1 VDD_1V8 q Out1 BTHHDLLX1
XOut2_tri VSS En2 VDD_1V8 q Out2 BTHHDLLX1
Xq_reg q VSS rst VDD_1V8 In Write DLHRQHDLLX0
.ENDS

.SUBCKT latchtriestado_324 In Out1 Out2 En1 En2 Write rst VSS VDD_1V8
XOut2_tri VSS En2 VDD_1V8 q Out2 BTHHDLLX1
XOut1_tri VSS En1 VDD_1V8 q Out1 BTHHDLLX1
Xq_reg q VSS rst VDD_1V8 In Write DLHRQHDLLX0
.ENDS

.SUBCKT latchtriestado_323 In Out1 Out2 En1 En2 Write rst VSS VDD_1V8
XOut1_tri VSS En1 VDD_1V8 q Out1 BTHHDLLX1
XOut2_tri VSS En2 VDD_1V8 q Out2 BTHHDLLX1
Xq_reg q VSS rst VDD_1V8 In Write DLHRQHDLLX0
.ENDS

.SUBCKT latchtriestado_322 In Out1 Out2 En1 En2 Write rst VSS VDD_1V8
XOut1_tri VSS En1 VDD_1V8 q Out1 BTHHDLLX1
XOut2_tri VSS En2 VDD_1V8 q Out2 BTHHDLLX1
Xq_reg q VSS rst VDD_1V8 In Write DLHRQHDLLX0
.ENDS

.SUBCKT latchtriestado_321 In Out1 Out2 En1 En2 Write rst VSS VDD_1V8
XOut2_tri VSS En2 VDD_1V8 q Out2 BTHHDLLX1
XOut1_tri VSS En1 VDD_1V8 q Out1 BTHHDLLX1
Xq_reg q VSS rst VDD_1V8 In Write DLHRQHDLLX0
.ENDS

.SUBCKT latchtriestado_320 In Out1 Out2 En1 En2 Write rst VSS VDD_1V8
XOut2_tri VSS En2 VDD_1V8 q Out2 BTHHDLLX1
XOut1_tri VSS En1 VDD_1V8 q Out1 BTHHDLLX1
Xq_reg q VSS rst VDD_1V8 In Write DLHRQHDLLX0
.ENDS

.SUBCKT latchtriestado_319 In Out1 Out2 En1 En2 Write rst VSS VDD_1V8
XOut1_tri VSS En1 VDD_1V8 q Out1 BTHHDLLX1
XOut2_tri VSS En2 VDD_1V8 q Out2 BTHHDLLX1
Xq_reg q VSS rst VDD_1V8 In Write DLHRQHDLLX0
.ENDS

.SUBCKT latchtriestado_318 In Out1 Out2 En1 En2 Write rst VSS VDD_1V8
XOut1_tri VSS En1 VDD_1V8 q Out1 BTHHDLLX1
XOut2_tri VSS En2 VDD_1V8 q Out2 BTHHDLLX1
Xq_reg q VSS rst VDD_1V8 In Write DLHRQHDLLX0
.ENDS

.SUBCKT latchtriestado_317 In Out1 Out2 En1 En2 Write rst VSS VDD_1V8
XOut1_tri VSS En1 VDD_1V8 q Out1 BTHHDLLX1
XOut2_tri VSS En2 VDD_1V8 q Out2 BTHHDLLX1
Xq_reg q VSS rst VDD_1V8 In Write DLHRQHDLLX0
.ENDS

.SUBCKT latchtriestado_316 In Out1 Out2 En1 En2 Write rst VSS VDD_1V8
XOut1_tri VSS En1 VDD_1V8 q Out1 BTHHDLLX1
XOut2_tri VSS En2 VDD_1V8 q Out2 BTHHDLLX1
Xq_reg q VSS rst VDD_1V8 In Write DLHRQHDLLX0
.ENDS

.SUBCKT latchtriestado_315 In Out1 Out2 En1 En2 Write rst VSS VDD_1V8
XOut1_tri VSS En1 VDD_1V8 q Out1 BTHHDLLX1
XOut2_tri VSS En2 VDD_1V8 q Out2 BTHHDLLX1
Xq_reg q VSS rst VDD_1V8 In Write DLHRQHDLLX0
.ENDS

.SUBCKT latchtriestado_314 In Out1 Out2 En1 En2 Write rst VSS VDD_1V8
XOut1_tri VSS En1 VDD_1V8 q Out1 BTHHDLLX1
XOut2_tri VSS En2 VDD_1V8 q Out2 BTHHDLLX1
Xq_reg q VSS rst VDD_1V8 In Write DLHRQHDLLX0
.ENDS

.SUBCKT latchtriestado_313 In Out1 Out2 En1 En2 Write rst VSS VDD_1V8
XOut1_tri VSS En1 VDD_1V8 q Out1 BTHHDLLX1
XOut2_tri VSS En2 VDD_1V8 q Out2 BTHHDLLX1
Xq_reg q VSS rst VDD_1V8 In Write DLHRQHDLLX0
.ENDS

.SUBCKT latchtriestado_312 In Out1 Out2 En1 En2 Write rst VSS VDD_1V8
XOut1_tri VSS En1 VDD_1V8 q Out1 BTHHDLLX1
XOut2_tri VSS En2 VDD_1V8 q Out2 BTHHDLLX1
Xq_reg q VSS rst VDD_1V8 In Write DLHRQHDLLX0
.ENDS

.SUBCKT latchtriestado_311 In Out1 Out2 En1 En2 Write rst VSS VDD_1V8
XOut1_tri VSS En1 VDD_1V8 q Out1 BTHHDLLX1
XOut2_tri VSS En2 VDD_1V8 q Out2 BTHHDLLX1
Xq_reg q VSS rst VDD_1V8 In Write DLHRQHDLLX0
.ENDS

.SUBCKT latchtriestado_310 In Out1 Out2 En1 En2 Write rst VSS VDD_1V8
XOut2_tri VSS En2 VDD_1V8 q Out2 BTHHDLLX1
XOut1_tri VSS En1 VDD_1V8 q Out1 BTHHDLLX1
Xq_reg q VSS rst VDD_1V8 In Write DLHRQHDLLX0
.ENDS

.SUBCKT latchtriestado_309 In Out1 Out2 En1 En2 Write rst VSS VDD_1V8
XOut1_tri VSS En1 VDD_1V8 q Out1 BTHHDLLX1
XOut2_tri VSS En2 VDD_1V8 q Out2 BTHHDLLX1
Xq_reg q VSS rst VDD_1V8 In Write DLHRQHDLLX0
.ENDS

.SUBCKT latchtriestado_308 In Out1 Out2 En1 En2 Write rst VSS VDD_1V8
XOut1_tri VSS En1 VDD_1V8 q Out1 BTHHDLLX1
XOut2_tri VSS En2 VDD_1V8 q Out2 BTHHDLLX1
Xq_reg q VSS rst VDD_1V8 In Write DLHRQHDLLX0
.ENDS

.SUBCKT latchtriestado_307 In Out1 Out2 En1 En2 Write rst VSS VDD_1V8
XOut2_tri VSS En2 VDD_1V8 q Out2 BTHHDLLX1
XOut1_tri VSS En1 VDD_1V8 q Out1 BTHHDLLX1
Xq_reg q VSS rst VDD_1V8 In Write DLHRQHDLLX0
.ENDS

.SUBCKT latchtriestado_306 In Out1 Out2 En1 En2 Write rst VSS VDD_1V8
XOut2_tri VSS En2 VDD_1V8 q Out2 BTHHDLLX1
XOut1_tri VSS En1 VDD_1V8 q Out1 BTHHDLLX1
Xq_reg q VSS rst VDD_1V8 In Write DLHRQHDLLX0
.ENDS

.SUBCKT latchtriestado_305 In Out1 Out2 En1 En2 Write rst VSS VDD_1V8
XOut2_tri VSS En2 VDD_1V8 q Out2 BTHHDLLX1
XOut1_tri VSS En1 VDD_1V8 q Out1 BTHHDLLX1
Xq_reg q VSS rst VDD_1V8 In Write DLHRQHDLLX0
.ENDS

.SUBCKT latchtriestado_304 In Out1 Out2 En1 En2 Write rst VSS VDD_1V8
XOut2_tri VSS En2 VDD_1V8 q Out2 BTHHDLLX1
XOut1_tri VSS En1 VDD_1V8 q Out1 BTHHDLLX1
Xq_reg q VSS rst VDD_1V8 In Write DLHRQHDLLX0
.ENDS

.SUBCKT latchtriestado_303 In Out1 Out2 En1 En2 Write rst VSS VDD_1V8
XOut1_tri VSS En1 VDD_1V8 q Out1 BTHHDLLX1
XOut2_tri VSS En2 VDD_1V8 q Out2 BTHHDLLX1
Xq_reg q VSS rst VDD_1V8 In Write DLHRQHDLLX0
.ENDS

.SUBCKT latchtriestado_302 In Out1 Out2 En1 En2 Write rst VSS VDD_1V8
Xq_reg q VSS rst VDD_1V8 In Write DLHRQHDLLX0
XOut1_tri VSS En1 VDD_1V8 q Out1 BTHHDLLX1
XOut2_tri VSS En2 VDD_1V8 q Out2 BTHHDLLX1
.ENDS

.SUBCKT latchtriestado_301 In Out1 Out2 En1 En2 Write rst VSS VDD_1V8
Xq_reg q VSS rst VDD_1V8 In Write DLHRQHDLLX0
XOut1_tri VSS En1 VDD_1V8 q Out1 BTHHDLLX1
XOut2_tri VSS En2 VDD_1V8 q Out2 BTHHDLLX1
.ENDS

.SUBCKT latchtriestado_300 In Out1 Out2 En1 En2 Write rst VSS VDD_1V8
Xq_reg q VSS rst VDD_1V8 In Write DLHRQHDLLX0
XOut1_tri VSS En1 VDD_1V8 q Out1 BTHHDLLX1
XOut2_tri VSS En2 VDD_1V8 q Out2 BTHHDLLX1
.ENDS

.SUBCKT latchtriestado_299 In Out1 Out2 En1 En2 Write rst VSS VDD_1V8
Xq_reg q VSS rst VDD_1V8 In Write DLHRQHDLLX0
XOut1_tri VSS En1 VDD_1V8 q Out1 BTHHDLLX1
XOut2_tri VSS En2 VDD_1V8 q Out2 BTHHDLLX1
.ENDS

.SUBCKT latchtriestado_298 In Out1 Out2 En1 En2 Write rst VSS VDD_1V8
Xq_reg q VSS rst VDD_1V8 In Write DLHRQHDLLX0
XOut1_tri VSS En1 VDD_1V8 q Out1 BTHHDLLX1
XOut2_tri VSS En2 VDD_1V8 q Out2 BTHHDLLX1
.ENDS

.SUBCKT latchtriestado_297 In Out1 Out2 En1 En2 Write rst VSS VDD_1V8
XOut1_tri VSS En1 VDD_1V8 q Out1 BTHHDLLX1
XOut2_tri VSS En2 VDD_1V8 q Out2 BTHHDLLX1
Xq_reg q VSS rst VDD_1V8 In Write DLHRQHDLLX0
.ENDS

.SUBCKT latchtriestado_296 In Out1 Out2 En1 En2 Write rst VSS VDD_1V8
XOut1_tri VSS En1 VDD_1V8 q Out1 BTHHDLLX1
XOut2_tri VSS En2 VDD_1V8 q Out2 BTHHDLLX1
Xq_reg q VSS rst VDD_1V8 In Write DLHRQHDLLX0
.ENDS

.SUBCKT latchtriestado_295 In Out1 Out2 En1 En2 Write rst VSS VDD_1V8
XOut2_tri VSS En2 VDD_1V8 q Out2 BTHHDLLX1
XOut1_tri VSS En1 VDD_1V8 q Out1 BTHHDLLX1
Xq_reg q VSS rst VDD_1V8 In Write DLHRQHDLLX0
.ENDS

.SUBCKT latchtriestado_294 In Out1 Out2 En1 En2 Write rst VSS VDD_1V8
XOut1_tri VSS En1 VDD_1V8 q Out1 BTHHDLLX1
XOut2_tri VSS En2 VDD_1V8 q Out2 BTHHDLLX1
Xq_reg q VSS rst VDD_1V8 In Write DLHRQHDLLX0
.ENDS

.SUBCKT latchtriestado_293 In Out1 Out2 En1 En2 Write rst VSS VDD_1V8
XOut2_tri VSS En2 VDD_1V8 q Out2 BTHHDLLX1
XOut1_tri VSS En1 VDD_1V8 q Out1 BTHHDLLX1
Xq_reg q VSS rst VDD_1V8 In Write DLHRQHDLLX0
.ENDS

.SUBCKT latchtriestado_292 In Out1 Out2 En1 En2 Write rst VSS VDD_1V8
XOut2_tri VSS En2 VDD_1V8 q Out2 BTHHDLLX1
XOut1_tri VSS En1 VDD_1V8 q Out1 BTHHDLLX1
Xq_reg q VSS rst VDD_1V8 In Write DLHRQHDLLX0
.ENDS

.SUBCKT latchtriestado_291 In Out1 Out2 En1 En2 Write rst VSS VDD_1V8
XOut2_tri VSS En2 VDD_1V8 q Out2 BTHHDLLX1
XOut1_tri VSS En1 VDD_1V8 q Out1 BTHHDLLX1
Xq_reg q VSS rst VDD_1V8 In Write DLHRQHDLLX0
.ENDS

.SUBCKT latchtriestado_290 In Out1 Out2 En1 En2 Write rst VSS VDD_1V8
XOut2_tri VSS En2 VDD_1V8 q Out2 BTHHDLLX1
XOut1_tri VSS En1 VDD_1V8 q Out1 BTHHDLLX1
Xq_reg q VSS rst VDD_1V8 In Write DLHRQHDLLX0
.ENDS

.SUBCKT latchtriestado_289 In Out1 Out2 En1 En2 Write rst VSS VDD_1V8
XOut1_tri VSS En1 VDD_1V8 q Out1 BTHHDLLX1
XOut2_tri VSS En2 VDD_1V8 q Out2 BTHHDLLX1
Xq_reg q VSS rst VDD_1V8 In Write DLHRQHDLLX0
.ENDS

.SUBCKT latchtriestado_288 In Out1 Out2 En1 En2 Write rst VSS VDD_1V8
XOut2_tri VSS En2 VDD_1V8 q Out2 BTHHDLLX1
XOut1_tri VSS En1 VDD_1V8 q Out1 BTHHDLLX1
Xq_reg q VSS rst VDD_1V8 In Write DLHRQHDLLX0
.ENDS

.SUBCKT latchtriestado_287 In Out1 Out2 En1 En2 Write rst VSS VDD_1V8
XOut1_tri VSS En1 VDD_1V8 q Out1 BTHHDLLX1
XOut2_tri VSS En2 VDD_1V8 q Out2 BTHHDLLX1
Xq_reg q VSS rst VDD_1V8 In Write DLHRQHDLLX0
.ENDS

.SUBCKT latchtriestado_286 In Out1 Out2 En1 En2 Write rst VSS VDD_1V8
XOut1_tri VSS En1 VDD_1V8 q Out1 BTHHDLLX1
XOut2_tri VSS En2 VDD_1V8 q Out2 BTHHDLLX1
Xq_reg q VSS rst VDD_1V8 In Write DLHRQHDLLX0
.ENDS

.SUBCKT latchtriestado_285 In Out1 Out2 En1 En2 Write rst VSS VDD_1V8
XOut1_tri VSS En1 VDD_1V8 q Out1 BTHHDLLX1
XOut2_tri VSS En2 VDD_1V8 q Out2 BTHHDLLX1
Xq_reg q VSS rst VDD_1V8 In Write DLHRQHDLLX0
.ENDS

.SUBCKT latchtriestado_284 In Out1 Out2 En1 En2 Write rst VSS VDD_1V8
XOut1_tri VSS En1 VDD_1V8 q Out1 BTHHDLLX1
XOut2_tri VSS En2 VDD_1V8 q Out2 BTHHDLLX1
Xq_reg q VSS rst VDD_1V8 In Write DLHRQHDLLX0
.ENDS

.SUBCKT latchtriestado_283 In Out1 Out2 En1 En2 Write rst VSS VDD_1V8
XOut1_tri VSS En1 VDD_1V8 q Out1 BTHHDLLX1
XOut2_tri VSS En2 VDD_1V8 q Out2 BTHHDLLX1
Xq_reg q VSS rst VDD_1V8 In Write DLHRQHDLLX0
.ENDS

.SUBCKT latchtriestado_282 In Out1 Out2 En1 En2 Write rst VSS VDD_1V8
XOut1_tri VSS En1 VDD_1V8 q Out1 BTHHDLLX1
XOut2_tri VSS En2 VDD_1V8 q Out2 BTHHDLLX1
Xq_reg q VSS rst VDD_1V8 In Write DLHRQHDLLX0
.ENDS

.SUBCKT latchtriestado_281 In Out1 Out2 En1 En2 Write rst VSS VDD_1V8
XOut1_tri VSS En1 VDD_1V8 q Out1 BTHHDLLX1
XOut2_tri VSS En2 VDD_1V8 q Out2 BTHHDLLX1
Xq_reg q VSS rst VDD_1V8 In Write DLHRQHDLLX0
.ENDS

.SUBCKT latchtriestado_280 In Out1 Out2 En1 En2 Write rst VSS VDD_1V8
XOut1_tri VSS En1 VDD_1V8 q Out1 BTHHDLLX1
XOut2_tri VSS En2 VDD_1V8 q Out2 BTHHDLLX1
Xq_reg q VSS rst VDD_1V8 In Write DLHRQHDLLX0
.ENDS

.SUBCKT latchtriestado_279 In Out1 Out2 En1 En2 Write rst VSS VDD_1V8
XOut1_tri VSS En1 VDD_1V8 q Out1 BTHHDLLX1
XOut2_tri VSS En2 VDD_1V8 q Out2 BTHHDLLX1
Xq_reg q VSS rst VDD_1V8 In Write DLHRQHDLLX0
.ENDS

.SUBCKT latchtriestado_278 In Out1 Out2 En1 En2 Write rst VSS VDD_1V8
XOut2_tri VSS En2 VDD_1V8 q Out2 BTHHDLLX1
XOut1_tri VSS En1 VDD_1V8 q Out1 BTHHDLLX1
Xq_reg q VSS rst VDD_1V8 In Write DLHRQHDLLX0
.ENDS

.SUBCKT latchtriestado_277 In Out1 Out2 En1 En2 Write rst VSS VDD_1V8
XOut1_tri VSS En1 VDD_1V8 q Out1 BTHHDLLX1
XOut2_tri VSS En2 VDD_1V8 q Out2 BTHHDLLX1
Xq_reg q VSS rst VDD_1V8 In Write DLHRQHDLLX0
.ENDS

.SUBCKT latchtriestado_276 In Out1 Out2 En1 En2 Write rst VSS VDD_1V8
XOut1_tri VSS En1 VDD_1V8 q Out1 BTHHDLLX1
XOut2_tri VSS En2 VDD_1V8 q Out2 BTHHDLLX1
Xq_reg q VSS rst VDD_1V8 In Write DLHRQHDLLX0
.ENDS

.SUBCKT latchtriestado_275 In Out1 Out2 En1 En2 Write rst VSS VDD_1V8
XOut2_tri VSS En2 VDD_1V8 q Out2 BTHHDLLX1
XOut1_tri VSS En1 VDD_1V8 q Out1 BTHHDLLX1
Xq_reg q VSS rst VDD_1V8 In Write DLHRQHDLLX0
.ENDS

.SUBCKT latchtriestado_274 In Out1 Out2 En1 En2 Write rst VSS VDD_1V8
XOut2_tri VSS En2 VDD_1V8 q Out2 BTHHDLLX1
XOut1_tri VSS En1 VDD_1V8 q Out1 BTHHDLLX1
Xq_reg q VSS rst VDD_1V8 In Write DLHRQHDLLX0
.ENDS

.SUBCKT latchtriestado_273 In Out1 Out2 En1 En2 Write rst VSS VDD_1V8
XOut2_tri VSS En2 VDD_1V8 q Out2 BTHHDLLX1
XOut1_tri VSS En1 VDD_1V8 q Out1 BTHHDLLX1
Xq_reg q VSS rst VDD_1V8 In Write DLHRQHDLLX0
.ENDS

.SUBCKT latchtriestado_272 In Out1 Out2 En1 En2 Write rst VSS VDD_1V8
XOut2_tri VSS En2 VDD_1V8 q Out2 BTHHDLLX1
XOut1_tri VSS En1 VDD_1V8 q Out1 BTHHDLLX1
Xq_reg q VSS rst VDD_1V8 In Write DLHRQHDLLX0
.ENDS

.SUBCKT latchtriestado_271 In Out1 Out2 En1 En2 Write rst VSS VDD_1V8
XOut1_tri VSS En1 VDD_1V8 q Out1 BTHHDLLX1
XOut2_tri VSS En2 VDD_1V8 q Out2 BTHHDLLX1
Xq_reg q VSS rst VDD_1V8 In Write DLHRQHDLLX0
.ENDS

.SUBCKT latchtriestado_270 In Out1 Out2 En1 En2 Write rst VSS VDD_1V8
Xq_reg q VSS rst VDD_1V8 In Write DLHRQHDLLX0
XOut1_tri VSS En1 VDD_1V8 q Out1 BTHHDLLX1
XOut2_tri VSS En2 VDD_1V8 q Out2 BTHHDLLX1
.ENDS

.SUBCKT latchtriestado_269 In Out1 Out2 En1 En2 Write rst VSS VDD_1V8
Xq_reg q VSS rst VDD_1V8 In Write DLHRQHDLLX0
XOut1_tri VSS En1 VDD_1V8 q Out1 BTHHDLLX1
XOut2_tri VSS En2 VDD_1V8 q Out2 BTHHDLLX1
.ENDS

.SUBCKT latchtriestado_268 In Out1 Out2 En1 En2 Write rst VSS VDD_1V8
Xq_reg q VSS rst VDD_1V8 In Write DLHRQHDLLX0
XOut1_tri VSS En1 VDD_1V8 q Out1 BTHHDLLX1
XOut2_tri VSS En2 VDD_1V8 q Out2 BTHHDLLX1
.ENDS

.SUBCKT latchtriestado_267 In Out1 Out2 En1 En2 Write rst VSS VDD_1V8
Xq_reg q VSS rst VDD_1V8 In Write DLHRQHDLLX0
XOut1_tri VSS En1 VDD_1V8 q Out1 BTHHDLLX1
XOut2_tri VSS En2 VDD_1V8 q Out2 BTHHDLLX1
.ENDS

.SUBCKT latchtriestado_266 In Out1 Out2 En1 En2 Write rst VSS VDD_1V8
Xq_reg q VSS rst VDD_1V8 In Write DLHRQHDLLX0
XOut1_tri VSS En1 VDD_1V8 q Out1 BTHHDLLX1
XOut2_tri VSS En2 VDD_1V8 q Out2 BTHHDLLX1
.ENDS

.SUBCKT latchtriestado_265 In Out1 Out2 En1 En2 Write rst VSS VDD_1V8
XOut2_tri VSS En2 VDD_1V8 q Out2 BTHHDLLX1
XOut1_tri VSS En1 VDD_1V8 q Out1 BTHHDLLX1
Xq_reg q VSS rst VDD_1V8 In Write DLHRQHDLLX0
.ENDS

.SUBCKT latchtriestado_264 In Out1 Out2 En1 En2 Write rst VSS VDD_1V8
XOut1_tri VSS En1 VDD_1V8 q Out1 BTHHDLLX1
XOut2_tri VSS En2 VDD_1V8 q Out2 BTHHDLLX1
Xq_reg q VSS rst VDD_1V8 In Write DLHRQHDLLX0
.ENDS

.SUBCKT latchtriestado_263 In Out1 Out2 En1 En2 Write rst VSS VDD_1V8
XOut2_tri VSS En2 VDD_1V8 q Out2 BTHHDLLX1
XOut1_tri VSS En1 VDD_1V8 q Out1 BTHHDLLX1
Xq_reg q VSS rst VDD_1V8 In Write DLHRQHDLLX0
.ENDS

.SUBCKT latchtriestado_262 In Out1 Out2 En1 En2 Write rst VSS VDD_1V8
XOut2_tri VSS En2 VDD_1V8 q Out2 BTHHDLLX1
XOut1_tri VSS En1 VDD_1V8 q Out1 BTHHDLLX1
Xq_reg q VSS rst VDD_1V8 In Write DLHRQHDLLX0
.ENDS

.SUBCKT latchtriestado_261 In Out1 Out2 En1 En2 Write rst VSS VDD_1V8
XOut2_tri VSS En2 VDD_1V8 q Out2 BTHHDLLX1
XOut1_tri VSS En1 VDD_1V8 q Out1 BTHHDLLX1
Xq_reg q VSS rst VDD_1V8 In Write DLHRQHDLLX0
.ENDS

.SUBCKT latchtriestado_260 In Out1 Out2 En1 En2 Write rst VSS VDD_1V8
XOut2_tri VSS En2 VDD_1V8 q Out2 BTHHDLLX1
XOut1_tri VSS En1 VDD_1V8 q Out1 BTHHDLLX1
Xq_reg q VSS rst VDD_1V8 In Write DLHRQHDLLX0
.ENDS

.SUBCKT latchtriestado_259 In Out1 Out2 En1 En2 Write rst VSS VDD_1V8
XOut2_tri VSS En2 VDD_1V8 q Out2 BTHHDLLX1
XOut1_tri VSS En1 VDD_1V8 q Out1 BTHHDLLX1
Xq_reg q VSS rst VDD_1V8 In Write DLHRQHDLLX0
.ENDS

.SUBCKT latchtriestado_258 In Out1 Out2 En1 En2 Write rst VSS VDD_1V8
XOut2_tri VSS En2 VDD_1V8 q Out2 BTHHDLLX1
XOut1_tri VSS En1 VDD_1V8 q Out1 BTHHDLLX1
Xq_reg q VSS rst VDD_1V8 In Write DLHRQHDLLX0
.ENDS

.SUBCKT latchtriestado_257 In Out1 Out2 En1 En2 Write rst VSS VDD_1V8
XOut1_tri VSS En1 VDD_1V8 q Out1 BTHHDLLX1
XOut2_tri VSS En2 VDD_1V8 q Out2 BTHHDLLX1
Xq_reg q VSS rst VDD_1V8 In Write DLHRQHDLLX0
.ENDS

.SUBCKT latchtriestado_256 In Out1 Out2 En1 En2 Write rst VSS VDD_1V8
XOut2_tri VSS En2 VDD_1V8 q Out2 BTHHDLLX1
XOut1_tri VSS En1 VDD_1V8 q Out1 BTHHDLLX1
Xq_reg q VSS rst VDD_1V8 In Write DLHRQHDLLX0
.ENDS

.SUBCKT latchtriestado_255 In Out1 Out2 En1 En2 Write rst VSS VDD_1V8
XOut1_tri VSS En1 VDD_1V8 q Out1 BTHHDLLX1
XOut2_tri VSS En2 VDD_1V8 q Out2 BTHHDLLX1
Xq_reg q VSS rst VDD_1V8 In Write DLHRQHDLLX0
.ENDS

.SUBCKT latchtriestado_254 In Out1 Out2 En1 En2 Write rst VSS VDD_1V8
XOut1_tri VSS En1 VDD_1V8 q Out1 BTHHDLLX1
XOut2_tri VSS En2 VDD_1V8 q Out2 BTHHDLLX1
Xq_reg q VSS rst VDD_1V8 In Write DLHRQHDLLX0
.ENDS

.SUBCKT latchtriestado_253 In Out1 Out2 En1 En2 Write rst VSS VDD_1V8
XOut1_tri VSS En1 VDD_1V8 q Out1 BTHHDLLX1
XOut2_tri VSS En2 VDD_1V8 q Out2 BTHHDLLX1
Xq_reg q VSS rst VDD_1V8 In Write DLHRQHDLLX0
.ENDS

.SUBCKT latchtriestado_252 In Out1 Out2 En1 En2 Write rst VSS VDD_1V8
XOut1_tri VSS En1 VDD_1V8 q Out1 BTHHDLLX1
XOut2_tri VSS En2 VDD_1V8 q Out2 BTHHDLLX1
Xq_reg q VSS rst VDD_1V8 In Write DLHRQHDLLX0
.ENDS

.SUBCKT latchtriestado_251 In Out1 Out2 En1 En2 Write rst VSS VDD_1V8
XOut1_tri VSS En1 VDD_1V8 q Out1 BTHHDLLX1
XOut2_tri VSS En2 VDD_1V8 q Out2 BTHHDLLX1
Xq_reg q VSS rst VDD_1V8 In Write DLHRQHDLLX0
.ENDS

.SUBCKT latchtriestado_250 In Out1 Out2 En1 En2 Write rst VSS VDD_1V8
XOut1_tri VSS En1 VDD_1V8 q Out1 BTHHDLLX1
XOut2_tri VSS En2 VDD_1V8 q Out2 BTHHDLLX1
Xq_reg q VSS rst VDD_1V8 In Write DLHRQHDLLX0
.ENDS

.SUBCKT latchtriestado_249 In Out1 Out2 En1 En2 Write rst VSS VDD_1V8
XOut1_tri VSS En1 VDD_1V8 q Out1 BTHHDLLX1
XOut2_tri VSS En2 VDD_1V8 q Out2 BTHHDLLX1
Xq_reg q VSS rst VDD_1V8 In Write DLHRQHDLLX0
.ENDS

.SUBCKT latchtriestado_248 In Out1 Out2 En1 En2 Write rst VSS VDD_1V8
XOut1_tri VSS En1 VDD_1V8 q Out1 BTHHDLLX1
XOut2_tri VSS En2 VDD_1V8 q Out2 BTHHDLLX1
Xq_reg q VSS rst VDD_1V8 In Write DLHRQHDLLX0
.ENDS

.SUBCKT latchtriestado_247 In Out1 Out2 En1 En2 Write rst VSS VDD_1V8
XOut1_tri VSS En1 VDD_1V8 q Out1 BTHHDLLX1
XOut2_tri VSS En2 VDD_1V8 q Out2 BTHHDLLX1
Xq_reg q VSS rst VDD_1V8 In Write DLHRQHDLLX0
.ENDS

.SUBCKT latchtriestado_246 In Out1 Out2 En1 En2 Write rst VSS VDD_1V8
XOut1_tri VSS En1 VDD_1V8 q Out1 BTHHDLLX1
XOut2_tri VSS En2 VDD_1V8 q Out2 BTHHDLLX1
Xq_reg q VSS rst VDD_1V8 In Write DLHRQHDLLX0
.ENDS

.SUBCKT latchtriestado_245 In Out1 Out2 En1 En2 Write rst VSS VDD_1V8
XOut2_tri VSS En2 VDD_1V8 q Out2 BTHHDLLX1
XOut1_tri VSS En1 VDD_1V8 q Out1 BTHHDLLX1
Xq_reg q VSS rst VDD_1V8 In Write DLHRQHDLLX0
.ENDS

.SUBCKT latchtriestado_244 In Out1 Out2 En1 En2 Write rst VSS VDD_1V8
XOut1_tri VSS En1 VDD_1V8 q Out1 BTHHDLLX1
XOut2_tri VSS En2 VDD_1V8 q Out2 BTHHDLLX1
Xq_reg q VSS rst VDD_1V8 In Write DLHRQHDLLX0
.ENDS

.SUBCKT latchtriestado_243 In Out1 Out2 En1 En2 Write rst VSS VDD_1V8
XOut1_tri VSS En1 VDD_1V8 q Out1 BTHHDLLX1
XOut2_tri VSS En2 VDD_1V8 q Out2 BTHHDLLX1
Xq_reg q VSS rst VDD_1V8 In Write DLHRQHDLLX0
.ENDS

.SUBCKT latchtriestado_242 In Out1 Out2 En1 En2 Write rst VSS VDD_1V8
XOut1_tri VSS En1 VDD_1V8 q Out1 BTHHDLLX1
XOut2_tri VSS En2 VDD_1V8 q Out2 BTHHDLLX1
Xq_reg q VSS rst VDD_1V8 In Write DLHRQHDLLX0
.ENDS

.SUBCKT latchtriestado_241 In Out1 Out2 En1 En2 Write rst VSS VDD_1V8
XOut1_tri VSS En1 VDD_1V8 q Out1 BTHHDLLX1
XOut2_tri VSS En2 VDD_1V8 q Out2 BTHHDLLX1
Xq_reg q VSS rst VDD_1V8 In Write DLHRQHDLLX0
.ENDS

.SUBCKT latchtriestado_240 In Out1 Out2 En1 En2 Write rst VSS VDD_1V8
XOut1_tri VSS En1 VDD_1V8 q Out1 BTHHDLLX1
XOut2_tri VSS En2 VDD_1V8 q Out2 BTHHDLLX1
Xq_reg q VSS rst VDD_1V8 In Write DLHRQHDLLX0
.ENDS

.SUBCKT latchtriestado_239 In Out1 Out2 En1 En2 Write rst VSS VDD_1V8
XOut2_tri VSS En2 VDD_1V8 q Out2 BTHHDLLX1
XOut1_tri VSS En1 VDD_1V8 q Out1 BTHHDLLX1
Xq_reg q VSS rst VDD_1V8 In Write DLHRQHDLLX0
.ENDS

.SUBCKT latchtriestado_238 In Out1 Out2 En1 En2 Write rst VSS VDD_1V8
Xq_reg q VSS rst VDD_1V8 In Write DLHRQHDLLX0
XOut1_tri VSS En1 VDD_1V8 q Out1 BTHHDLLX1
XOut2_tri VSS En2 VDD_1V8 q Out2 BTHHDLLX1
.ENDS

.SUBCKT latchtriestado_237 In Out1 Out2 En1 En2 Write rst VSS VDD_1V8
Xq_reg q VSS rst VDD_1V8 In Write DLHRQHDLLX0
XOut2_tri VSS En2 VDD_1V8 q Out2 BTHHDLLX1
XOut1_tri VSS En1 VDD_1V8 q Out1 BTHHDLLX1
.ENDS

.SUBCKT latchtriestado_236 In Out1 Out2 En1 En2 Write rst VSS VDD_1V8
Xq_reg q VSS rst VDD_1V8 In Write DLHRQHDLLX0
XOut1_tri VSS En1 VDD_1V8 q Out1 BTHHDLLX1
XOut2_tri VSS En2 VDD_1V8 q Out2 BTHHDLLX1
.ENDS

.SUBCKT latchtriestado_235 In Out1 Out2 En1 En2 Write rst VSS VDD_1V8
Xq_reg q VSS rst VDD_1V8 In Write DLHRQHDLLX0
XOut1_tri VSS En1 VDD_1V8 q Out1 BTHHDLLX1
XOut2_tri VSS En2 VDD_1V8 q Out2 BTHHDLLX1
.ENDS

.SUBCKT latchtriestado_234 In Out1 Out2 En1 En2 Write rst VSS VDD_1V8
Xq_reg q VSS rst VDD_1V8 In Write DLHRQHDLLX0
XOut1_tri VSS En1 VDD_1V8 q Out1 BTHHDLLX1
XOut2_tri VSS En2 VDD_1V8 q Out2 BTHHDLLX1
.ENDS

.SUBCKT latchtriestado_233 In Out1 Out2 En1 En2 Write rst VSS VDD_1V8
XOut1_tri VSS En1 VDD_1V8 q Out1 BTHHDLLX1
XOut2_tri VSS En2 VDD_1V8 q Out2 BTHHDLLX1
Xq_reg q VSS rst VDD_1V8 In Write DLHRQHDLLX0
.ENDS

.SUBCKT latchtriestado_232 In Out1 Out2 En1 En2 Write rst VSS VDD_1V8
XOut1_tri VSS En1 VDD_1V8 q Out1 BTHHDLLX1
XOut2_tri VSS En2 VDD_1V8 q Out2 BTHHDLLX1
Xq_reg q VSS rst VDD_1V8 In Write DLHRQHDLLX0
.ENDS

.SUBCKT latchtriestado_231 In Out1 Out2 En1 En2 Write rst VSS VDD_1V8
XOut1_tri VSS En1 VDD_1V8 q Out1 BTHHDLLX1
XOut2_tri VSS En2 VDD_1V8 q Out2 BTHHDLLX1
Xq_reg q VSS rst VDD_1V8 In Write DLHRQHDLLX0
.ENDS

.SUBCKT latchtriestado_230 In Out1 Out2 En1 En2 Write rst VSS VDD_1V8
XOut1_tri VSS En1 VDD_1V8 q Out1 BTHHDLLX1
XOut2_tri VSS En2 VDD_1V8 q Out2 BTHHDLLX1
Xq_reg q VSS rst VDD_1V8 In Write DLHRQHDLLX0
.ENDS

.SUBCKT latchtriestado_229 In Out1 Out2 En1 En2 Write rst VSS VDD_1V8
XOut1_tri VSS En1 VDD_1V8 q Out1 BTHHDLLX1
XOut2_tri VSS En2 VDD_1V8 q Out2 BTHHDLLX1
Xq_reg q VSS rst VDD_1V8 In Write DLHRQHDLLX0
.ENDS

.SUBCKT latchtriestado_228 In Out1 Out2 En1 En2 Write rst VSS VDD_1V8
XOut1_tri VSS En1 VDD_1V8 q Out1 BTHHDLLX1
XOut2_tri VSS En2 VDD_1V8 q Out2 BTHHDLLX1
Xq_reg q VSS rst VDD_1V8 In Write DLHRQHDLLX0
.ENDS

.SUBCKT latchtriestado_227 In Out1 Out2 En1 En2 Write rst VSS VDD_1V8
XOut1_tri VSS En1 VDD_1V8 q Out1 BTHHDLLX1
XOut2_tri VSS En2 VDD_1V8 q Out2 BTHHDLLX1
Xq_reg q VSS rst VDD_1V8 In Write DLHRQHDLLX0
.ENDS

.SUBCKT latchtriestado_226 In Out1 Out2 En1 En2 Write rst VSS VDD_1V8
XOut1_tri VSS En1 VDD_1V8 q Out1 BTHHDLLX1
XOut2_tri VSS En2 VDD_1V8 q Out2 BTHHDLLX1
Xq_reg q VSS rst VDD_1V8 In Write DLHRQHDLLX0
.ENDS

.SUBCKT latchtriestado_225 In Out1 Out2 En1 En2 Write rst VSS VDD_1V8
XOut1_tri VSS En1 VDD_1V8 q Out1 BTHHDLLX1
XOut2_tri VSS En2 VDD_1V8 q Out2 BTHHDLLX1
Xq_reg q VSS rst VDD_1V8 In Write DLHRQHDLLX0
.ENDS

.SUBCKT latchtriestado_224 In Out1 Out2 En1 En2 Write rst VSS VDD_1V8
XOut2_tri VSS En2 VDD_1V8 q Out2 BTHHDLLX1
XOut1_tri VSS En1 VDD_1V8 q Out1 BTHHDLLX1
Xq_reg q VSS rst VDD_1V8 In Write DLHRQHDLLX0
.ENDS

.SUBCKT latchtriestado_223 In Out1 Out2 En1 En2 Write rst VSS VDD_1V8
XOut1_tri VSS En1 VDD_1V8 q Out1 BTHHDLLX1
XOut2_tri VSS En2 VDD_1V8 q Out2 BTHHDLLX1
Xq_reg q VSS rst VDD_1V8 In Write DLHRQHDLLX0
.ENDS

.SUBCKT latchtriestado_222 In Out1 Out2 En1 En2 Write rst VSS VDD_1V8
XOut1_tri VSS En1 VDD_1V8 q Out1 BTHHDLLX1
XOut2_tri VSS En2 VDD_1V8 q Out2 BTHHDLLX1
Xq_reg q VSS rst VDD_1V8 In Write DLHRQHDLLX0
.ENDS

.SUBCKT latchtriestado_221 In Out1 Out2 En1 En2 Write rst VSS VDD_1V8
XOut1_tri VSS En1 VDD_1V8 q Out1 BTHHDLLX1
XOut2_tri VSS En2 VDD_1V8 q Out2 BTHHDLLX1
Xq_reg q VSS rst VDD_1V8 In Write DLHRQHDLLX0
.ENDS

.SUBCKT latchtriestado_220 In Out1 Out2 En1 En2 Write rst VSS VDD_1V8
XOut1_tri VSS En1 VDD_1V8 q Out1 BTHHDLLX1
XOut2_tri VSS En2 VDD_1V8 q Out2 BTHHDLLX1
Xq_reg q VSS rst VDD_1V8 In Write DLHRQHDLLX0
.ENDS

.SUBCKT latchtriestado_219 In Out1 Out2 En1 En2 Write rst VSS VDD_1V8
XOut1_tri VSS En1 VDD_1V8 q Out1 BTHHDLLX1
XOut2_tri VSS En2 VDD_1V8 q Out2 BTHHDLLX1
Xq_reg q VSS rst VDD_1V8 In Write DLHRQHDLLX0
.ENDS

.SUBCKT latchtriestado_218 In Out1 Out2 En1 En2 Write rst VSS VDD_1V8
XOut1_tri VSS En1 VDD_1V8 q Out1 BTHHDLLX1
XOut2_tri VSS En2 VDD_1V8 q Out2 BTHHDLLX1
Xq_reg q VSS rst VDD_1V8 In Write DLHRQHDLLX0
.ENDS

.SUBCKT latchtriestado_217 In Out1 Out2 En1 En2 Write rst VSS VDD_1V8
XOut1_tri VSS En1 VDD_1V8 q Out1 BTHHDLLX1
XOut2_tri VSS En2 VDD_1V8 q Out2 BTHHDLLX1
Xq_reg q VSS rst VDD_1V8 In Write DLHRQHDLLX0
.ENDS

.SUBCKT latchtriestado_216 In Out1 Out2 En1 En2 Write rst VSS VDD_1V8
XOut1_tri VSS En1 VDD_1V8 q Out1 BTHHDLLX1
XOut2_tri VSS En2 VDD_1V8 q Out2 BTHHDLLX1
Xq_reg q VSS rst VDD_1V8 In Write DLHRQHDLLX0
.ENDS

.SUBCKT latchtriestado_215 In Out1 Out2 En1 En2 Write rst VSS VDD_1V8
XOut1_tri VSS En1 VDD_1V8 q Out1 BTHHDLLX1
XOut2_tri VSS En2 VDD_1V8 q Out2 BTHHDLLX1
Xq_reg q VSS rst VDD_1V8 In Write DLHRQHDLLX0
.ENDS

.SUBCKT latchtriestado_214 In Out1 Out2 En1 En2 Write rst VSS VDD_1V8
XOut1_tri VSS En1 VDD_1V8 q Out1 BTHHDLLX1
XOut2_tri VSS En2 VDD_1V8 q Out2 BTHHDLLX1
Xq_reg q VSS rst VDD_1V8 In Write DLHRQHDLLX0
.ENDS

.SUBCKT latchtriestado_213 In Out1 Out2 En1 En2 Write rst VSS VDD_1V8
XOut2_tri VSS En2 VDD_1V8 q Out2 BTHHDLLX1
XOut1_tri VSS En1 VDD_1V8 q Out1 BTHHDLLX1
Xq_reg q VSS rst VDD_1V8 In Write DLHRQHDLLX0
.ENDS

.SUBCKT latchtriestado_212 In Out1 Out2 En1 En2 Write rst VSS VDD_1V8
XOut2_tri VSS En2 VDD_1V8 q Out2 BTHHDLLX1
XOut1_tri VSS En1 VDD_1V8 q Out1 BTHHDLLX1
Xq_reg q VSS rst VDD_1V8 In Write DLHRQHDLLX0
.ENDS

.SUBCKT latchtriestado_211 In Out1 Out2 En1 En2 Write rst VSS VDD_1V8
XOut1_tri VSS En1 VDD_1V8 q Out1 BTHHDLLX1
XOut2_tri VSS En2 VDD_1V8 q Out2 BTHHDLLX1
Xq_reg q VSS rst VDD_1V8 In Write DLHRQHDLLX0
.ENDS

.SUBCKT latchtriestado_210 In Out1 Out2 En1 En2 Write rst VSS VDD_1V8
XOut2_tri VSS En2 VDD_1V8 q Out2 BTHHDLLX1
XOut1_tri VSS En1 VDD_1V8 q Out1 BTHHDLLX1
Xq_reg q VSS rst VDD_1V8 In Write DLHRQHDLLX0
.ENDS

.SUBCKT latchtriestado_209 In Out1 Out2 En1 En2 Write rst VSS VDD_1V8
XOut2_tri VSS En2 VDD_1V8 q Out2 BTHHDLLX1
XOut1_tri VSS En1 VDD_1V8 q Out1 BTHHDLLX1
Xq_reg q VSS rst VDD_1V8 In Write DLHRQHDLLX0
.ENDS

.SUBCKT latchtriestado_208 In Out1 Out2 En1 En2 Write rst VSS VDD_1V8
XOut2_tri VSS En2 VDD_1V8 q Out2 BTHHDLLX1
XOut1_tri VSS En1 VDD_1V8 q Out1 BTHHDLLX1
Xq_reg q VSS rst VDD_1V8 In Write DLHRQHDLLX0
.ENDS

.SUBCKT latchtriestado_207 In Out1 Out2 En1 En2 Write rst VSS VDD_1V8
XOut2_tri VSS En2 VDD_1V8 q Out2 BTHHDLLX1
XOut1_tri VSS En1 VDD_1V8 q Out1 BTHHDLLX1
Xq_reg q VSS rst VDD_1V8 In Write DLHRQHDLLX0
.ENDS

.SUBCKT latchtriestado_206 In Out1 Out2 En1 En2 Write rst VSS VDD_1V8
Xq_reg q VSS rst VDD_1V8 In Write DLHRQHDLLX0
XOut1_tri VSS En1 VDD_1V8 q Out1 BTHHDLLX1
XOut2_tri VSS En2 VDD_1V8 q Out2 BTHHDLLX1
.ENDS

.SUBCKT latchtriestado_205 In Out1 Out2 En1 En2 Write rst VSS VDD_1V8
Xq_reg q VSS rst VDD_1V8 In Write DLHRQHDLLX0
XOut2_tri VSS En2 VDD_1V8 q Out2 BTHHDLLX1
XOut1_tri VSS En1 VDD_1V8 q Out1 BTHHDLLX1
.ENDS

.SUBCKT latchtriestado_204 In Out1 Out2 En1 En2 Write rst VSS VDD_1V8
Xq_reg q VSS rst VDD_1V8 In Write DLHRQHDLLX0
XOut1_tri VSS En1 VDD_1V8 q Out1 BTHHDLLX1
XOut2_tri VSS En2 VDD_1V8 q Out2 BTHHDLLX1
.ENDS

.SUBCKT latchtriestado_203 In Out1 Out2 En1 En2 Write rst VSS VDD_1V8
Xq_reg q VSS rst VDD_1V8 In Write DLHRQHDLLX0
XOut2_tri VSS En2 VDD_1V8 q Out2 BTHHDLLX1
XOut1_tri VSS En1 VDD_1V8 q Out1 BTHHDLLX1
.ENDS

.SUBCKT latchtriestado_202 In Out1 Out2 En1 En2 Write rst VSS VDD_1V8
Xq_reg q VSS rst VDD_1V8 In Write DLHRQHDLLX0
XOut2_tri VSS En2 VDD_1V8 q Out2 BTHHDLLX1
XOut1_tri VSS En1 VDD_1V8 q Out1 BTHHDLLX1
.ENDS

.SUBCKT latchtriestado_201 In Out1 Out2 En1 En2 Write rst VSS VDD_1V8
XOut1_tri VSS En1 VDD_1V8 q Out1 BTHHDLLX1
XOut2_tri VSS En2 VDD_1V8 q Out2 BTHHDLLX1
Xq_reg q VSS rst VDD_1V8 In Write DLHRQHDLLX0
.ENDS

.SUBCKT latchtriestado_200 In Out1 Out2 En1 En2 Write rst VSS VDD_1V8
XOut2_tri VSS En2 VDD_1V8 q Out2 BTHHDLLX1
XOut1_tri VSS En1 VDD_1V8 q Out1 BTHHDLLX1
Xq_reg q VSS rst VDD_1V8 In Write DLHRQHDLLX0
.ENDS

.SUBCKT latchtriestado_199 In Out1 Out2 En1 En2 Write rst VSS VDD_1V8
XOut1_tri VSS En1 VDD_1V8 q Out1 BTHHDLLX1
XOut2_tri VSS En2 VDD_1V8 q Out2 BTHHDLLX1
Xq_reg q VSS rst VDD_1V8 In Write DLHRQHDLLX0
.ENDS

.SUBCKT latchtriestado_198 In Out1 Out2 En1 En2 Write rst VSS VDD_1V8
XOut1_tri VSS En1 VDD_1V8 q Out1 BTHHDLLX1
XOut2_tri VSS En2 VDD_1V8 q Out2 BTHHDLLX1
Xq_reg q VSS rst VDD_1V8 In Write DLHRQHDLLX0
.ENDS

.SUBCKT latchtriestado_197 In Out1 Out2 En1 En2 Write rst VSS VDD_1V8
XOut1_tri VSS En1 VDD_1V8 q Out1 BTHHDLLX1
XOut2_tri VSS En2 VDD_1V8 q Out2 BTHHDLLX1
Xq_reg q VSS rst VDD_1V8 In Write DLHRQHDLLX0
.ENDS

.SUBCKT latchtriestado_196 In Out1 Out2 En1 En2 Write rst VSS VDD_1V8
XOut1_tri VSS En1 VDD_1V8 q Out1 BTHHDLLX1
XOut2_tri VSS En2 VDD_1V8 q Out2 BTHHDLLX1
Xq_reg q VSS rst VDD_1V8 In Write DLHRQHDLLX0
.ENDS

.SUBCKT latchtriestado_195 In Out1 Out2 En1 En2 Write rst VSS VDD_1V8
XOut1_tri VSS En1 VDD_1V8 q Out1 BTHHDLLX1
XOut2_tri VSS En2 VDD_1V8 q Out2 BTHHDLLX1
Xq_reg q VSS rst VDD_1V8 In Write DLHRQHDLLX0
.ENDS

.SUBCKT latchtriestado_194 In Out1 Out2 En1 En2 Write rst VSS VDD_1V8
XOut1_tri VSS En1 VDD_1V8 q Out1 BTHHDLLX1
XOut2_tri VSS En2 VDD_1V8 q Out2 BTHHDLLX1
Xq_reg q VSS rst VDD_1V8 In Write DLHRQHDLLX0
.ENDS

.SUBCKT latchtriestado_193 In Out1 Out2 En1 En2 Write rst VSS VDD_1V8
XOut1_tri VSS En1 VDD_1V8 q Out1 BTHHDLLX1
XOut2_tri VSS En2 VDD_1V8 q Out2 BTHHDLLX1
Xq_reg q VSS rst VDD_1V8 In Write DLHRQHDLLX0
.ENDS

.SUBCKT latchtriestado_192 In Out1 Out2 En1 En2 Write rst VSS VDD_1V8
XOut2_tri VSS En2 VDD_1V8 q Out2 BTHHDLLX1
XOut1_tri VSS En1 VDD_1V8 q Out1 BTHHDLLX1
Xq_reg q VSS rst VDD_1V8 In Write DLHRQHDLLX0
.ENDS

.SUBCKT latchtriestado_191 In Out1 Out2 En1 En2 Write rst VSS VDD_1V8
XOut1_tri VSS En1 VDD_1V8 q Out1 BTHHDLLX1
XOut2_tri VSS En2 VDD_1V8 q Out2 BTHHDLLX1
Xq_reg q VSS rst VDD_1V8 In Write DLHRQHDLLX0
.ENDS

.SUBCKT latchtriestado_190 In Out1 Out2 En1 En2 Write rst VSS VDD_1V8
XOut1_tri VSS En1 VDD_1V8 q Out1 BTHHDLLX1
XOut2_tri VSS En2 VDD_1V8 q Out2 BTHHDLLX1
Xq_reg q VSS rst VDD_1V8 In Write DLHRQHDLLX0
.ENDS

.SUBCKT latchtriestado_189 In Out1 Out2 En1 En2 Write rst VSS VDD_1V8
XOut1_tri VSS En1 VDD_1V8 q Out1 BTHHDLLX1
XOut2_tri VSS En2 VDD_1V8 q Out2 BTHHDLLX1
Xq_reg q VSS rst VDD_1V8 In Write DLHRQHDLLX0
.ENDS

.SUBCKT latchtriestado_188 In Out1 Out2 En1 En2 Write rst VSS VDD_1V8
XOut1_tri VSS En1 VDD_1V8 q Out1 BTHHDLLX1
XOut2_tri VSS En2 VDD_1V8 q Out2 BTHHDLLX1
Xq_reg q VSS rst VDD_1V8 In Write DLHRQHDLLX0
.ENDS

.SUBCKT latchtriestado_187 In Out1 Out2 En1 En2 Write rst VSS VDD_1V8
XOut1_tri VSS En1 VDD_1V8 q Out1 BTHHDLLX1
XOut2_tri VSS En2 VDD_1V8 q Out2 BTHHDLLX1
Xq_reg q VSS rst VDD_1V8 In Write DLHRQHDLLX0
.ENDS

.SUBCKT latchtriestado_186 In Out1 Out2 En1 En2 Write rst VSS VDD_1V8
XOut1_tri VSS En1 VDD_1V8 q Out1 BTHHDLLX1
XOut2_tri VSS En2 VDD_1V8 q Out2 BTHHDLLX1
Xq_reg q VSS rst VDD_1V8 In Write DLHRQHDLLX0
.ENDS

.SUBCKT latchtriestado_185 In Out1 Out2 En1 En2 Write rst VSS VDD_1V8
XOut1_tri VSS En1 VDD_1V8 q Out1 BTHHDLLX1
XOut2_tri VSS En2 VDD_1V8 q Out2 BTHHDLLX1
Xq_reg q VSS rst VDD_1V8 In Write DLHRQHDLLX0
.ENDS

.SUBCKT latchtriestado_184 In Out1 Out2 En1 En2 Write rst VSS VDD_1V8
XOut1_tri VSS En1 VDD_1V8 q Out1 BTHHDLLX1
XOut2_tri VSS En2 VDD_1V8 q Out2 BTHHDLLX1
Xq_reg q VSS rst VDD_1V8 In Write DLHRQHDLLX0
.ENDS

.SUBCKT latchtriestado_183 In Out1 Out2 En1 En2 Write rst VSS VDD_1V8
XOut1_tri VSS En1 VDD_1V8 q Out1 BTHHDLLX1
XOut2_tri VSS En2 VDD_1V8 q Out2 BTHHDLLX1
Xq_reg q VSS rst VDD_1V8 In Write DLHRQHDLLX0
.ENDS

.SUBCKT latchtriestado_182 In Out1 Out2 En1 En2 Write rst VSS VDD_1V8
XOut1_tri VSS En1 VDD_1V8 q Out1 BTHHDLLX1
XOut2_tri VSS En2 VDD_1V8 q Out2 BTHHDLLX1
Xq_reg q VSS rst VDD_1V8 In Write DLHRQHDLLX0
.ENDS

.SUBCKT latchtriestado_181 In Out1 Out2 En1 En2 Write rst VSS VDD_1V8
XOut2_tri VSS En2 VDD_1V8 q Out2 BTHHDLLX1
XOut1_tri VSS En1 VDD_1V8 q Out1 BTHHDLLX1
Xq_reg q VSS rst VDD_1V8 In Write DLHRQHDLLX0
.ENDS

.SUBCKT latchtriestado_180 In Out1 Out2 En1 En2 Write rst VSS VDD_1V8
XOut2_tri VSS En2 VDD_1V8 q Out2 BTHHDLLX1
XOut1_tri VSS En1 VDD_1V8 q Out1 BTHHDLLX1
Xq_reg q VSS rst VDD_1V8 In Write DLHRQHDLLX0
.ENDS

.SUBCKT latchtriestado_179 In Out1 Out2 En1 En2 Write rst VSS VDD_1V8
XOut1_tri VSS En1 VDD_1V8 q Out1 BTHHDLLX1
XOut2_tri VSS En2 VDD_1V8 q Out2 BTHHDLLX1
Xq_reg q VSS rst VDD_1V8 In Write DLHRQHDLLX0
.ENDS

.SUBCKT latchtriestado_178 In Out1 Out2 En1 En2 Write rst VSS VDD_1V8
XOut1_tri VSS En1 VDD_1V8 q Out1 BTHHDLLX1
XOut2_tri VSS En2 VDD_1V8 q Out2 BTHHDLLX1
Xq_reg q VSS rst VDD_1V8 In Write DLHRQHDLLX0
.ENDS

.SUBCKT latchtriestado_177 In Out1 Out2 En1 En2 Write rst VSS VDD_1V8
XOut1_tri VSS En1 VDD_1V8 q Out1 BTHHDLLX1
XOut2_tri VSS En2 VDD_1V8 q Out2 BTHHDLLX1
Xq_reg q VSS rst VDD_1V8 In Write DLHRQHDLLX0
.ENDS

.SUBCKT latchtriestado_176 In Out1 Out2 En1 En2 Write rst VSS VDD_1V8
XOut1_tri VSS En1 VDD_1V8 q Out1 BTHHDLLX1
XOut2_tri VSS En2 VDD_1V8 q Out2 BTHHDLLX1
Xq_reg q VSS rst VDD_1V8 In Write DLHRQHDLLX0
.ENDS

.SUBCKT latchtriestado_175 In Out1 Out2 En1 En2 Write rst VSS VDD_1V8
XOut1_tri VSS En1 VDD_1V8 q Out1 BTHHDLLX1
XOut2_tri VSS En2 VDD_1V8 q Out2 BTHHDLLX1
Xq_reg q VSS rst VDD_1V8 In Write DLHRQHDLLX0
.ENDS

.SUBCKT latchtriestado_174 In Out1 Out2 En1 En2 Write rst VSS VDD_1V8
Xq_reg q VSS rst VDD_1V8 In Write DLHRQHDLLX0
XOut1_tri VSS En1 VDD_1V8 q Out1 BTHHDLLX1
XOut2_tri VSS En2 VDD_1V8 q Out2 BTHHDLLX1
.ENDS

.SUBCKT latchtriestado_173 In Out1 Out2 En1 En2 Write rst VSS VDD_1V8
Xq_reg q VSS rst VDD_1V8 In Write DLHRQHDLLX0
XOut1_tri VSS En1 VDD_1V8 q Out1 BTHHDLLX1
XOut2_tri VSS En2 VDD_1V8 q Out2 BTHHDLLX1
.ENDS

.SUBCKT latchtriestado_172 In Out1 Out2 En1 En2 Write rst VSS VDD_1V8
Xq_reg q VSS rst VDD_1V8 In Write DLHRQHDLLX0
XOut1_tri VSS En1 VDD_1V8 q Out1 BTHHDLLX1
XOut2_tri VSS En2 VDD_1V8 q Out2 BTHHDLLX1
.ENDS

.SUBCKT latchtriestado_171 In Out1 Out2 En1 En2 Write rst VSS VDD_1V8
Xq_reg q VSS rst VDD_1V8 In Write DLHRQHDLLX0
XOut2_tri VSS En2 VDD_1V8 q Out2 BTHHDLLX1
XOut1_tri VSS En1 VDD_1V8 q Out1 BTHHDLLX1
.ENDS

.SUBCKT latchtriestado_170 In Out1 Out2 En1 En2 Write rst VSS VDD_1V8
Xq_reg q VSS rst VDD_1V8 In Write DLHRQHDLLX0
XOut2_tri VSS En2 VDD_1V8 q Out2 BTHHDLLX1
XOut1_tri VSS En1 VDD_1V8 q Out1 BTHHDLLX1
.ENDS

.SUBCKT latchtriestado_169 In Out1 Out2 En1 En2 Write rst VSS VDD_1V8
XOut2_tri VSS En2 VDD_1V8 q Out2 BTHHDLLX1
XOut1_tri VSS En1 VDD_1V8 q Out1 BTHHDLLX1
Xq_reg q VSS rst VDD_1V8 In Write DLHRQHDLLX0
.ENDS

.SUBCKT latchtriestado_168 In Out1 Out2 En1 En2 Write rst VSS VDD_1V8
XOut2_tri VSS En2 VDD_1V8 q Out2 BTHHDLLX1
XOut1_tri VSS En1 VDD_1V8 q Out1 BTHHDLLX1
Xq_reg q VSS rst VDD_1V8 In Write DLHRQHDLLX0
.ENDS

.SUBCKT latchtriestado_167 In Out1 Out2 En1 En2 Write rst VSS VDD_1V8
XOut2_tri VSS En2 VDD_1V8 q Out2 BTHHDLLX1
XOut1_tri VSS En1 VDD_1V8 q Out1 BTHHDLLX1
Xq_reg q VSS rst VDD_1V8 In Write DLHRQHDLLX0
.ENDS

.SUBCKT latchtriestado_166 In Out1 Out2 En1 En2 Write rst VSS VDD_1V8
XOut2_tri VSS En2 VDD_1V8 q Out2 BTHHDLLX1
XOut1_tri VSS En1 VDD_1V8 q Out1 BTHHDLLX1
Xq_reg q VSS rst VDD_1V8 In Write DLHRQHDLLX0
.ENDS

.SUBCKT latchtriestado_165 In Out1 Out2 En1 En2 Write rst VSS VDD_1V8
XOut1_tri VSS En1 VDD_1V8 q Out1 BTHHDLLX1
XOut2_tri VSS En2 VDD_1V8 q Out2 BTHHDLLX1
Xq_reg q VSS rst VDD_1V8 In Write DLHRQHDLLX0
.ENDS

.SUBCKT latchtriestado_164 In Out1 Out2 En1 En2 Write rst VSS VDD_1V8
XOut2_tri VSS En2 VDD_1V8 q Out2 BTHHDLLX1
XOut1_tri VSS En1 VDD_1V8 q Out1 BTHHDLLX1
Xq_reg q VSS rst VDD_1V8 In Write DLHRQHDLLX0
.ENDS

.SUBCKT latchtriestado_163 In Out1 Out2 En1 En2 Write rst VSS VDD_1V8
XOut2_tri VSS En2 VDD_1V8 q Out2 BTHHDLLX1
XOut1_tri VSS En1 VDD_1V8 q Out1 BTHHDLLX1
Xq_reg q VSS rst VDD_1V8 In Write DLHRQHDLLX0
.ENDS

.SUBCKT latchtriestado_162 In Out1 Out2 En1 En2 Write rst VSS VDD_1V8
XOut2_tri VSS En2 VDD_1V8 q Out2 BTHHDLLX1
XOut1_tri VSS En1 VDD_1V8 q Out1 BTHHDLLX1
Xq_reg q VSS rst VDD_1V8 In Write DLHRQHDLLX0
.ENDS

.SUBCKT latchtriestado_161 In Out1 Out2 En1 En2 Write rst VSS VDD_1V8
XOut1_tri VSS En1 VDD_1V8 q Out1 BTHHDLLX1
XOut2_tri VSS En2 VDD_1V8 q Out2 BTHHDLLX1
Xq_reg q VSS rst VDD_1V8 In Write DLHRQHDLLX0
.ENDS

.SUBCKT latchtriestado_160 In Out1 Out2 En1 En2 Write rst VSS VDD_1V8
XOut2_tri VSS En2 VDD_1V8 q Out2 BTHHDLLX1
XOut1_tri VSS En1 VDD_1V8 q Out1 BTHHDLLX1
Xq_reg q VSS rst VDD_1V8 In Write DLHRQHDLLX0
.ENDS

.SUBCKT latchtriestado_159 In Out1 Out2 En1 En2 Write rst VSS VDD_1V8
XOut1_tri VSS En1 VDD_1V8 q Out1 BTHHDLLX1
XOut2_tri VSS En2 VDD_1V8 q Out2 BTHHDLLX1
Xq_reg q VSS rst VDD_1V8 In Write DLHRQHDLLX0
.ENDS

.SUBCKT latchtriestado_158 In Out1 Out2 En1 En2 Write rst VSS VDD_1V8
XOut1_tri VSS En1 VDD_1V8 q Out1 BTHHDLLX1
XOut2_tri VSS En2 VDD_1V8 q Out2 BTHHDLLX1
Xq_reg q VSS rst VDD_1V8 In Write DLHRQHDLLX0
.ENDS

.SUBCKT latchtriestado_157 In Out1 Out2 En1 En2 Write rst VSS VDD_1V8
XOut1_tri VSS En1 VDD_1V8 q Out1 BTHHDLLX1
XOut2_tri VSS En2 VDD_1V8 q Out2 BTHHDLLX1
Xq_reg q VSS rst VDD_1V8 In Write DLHRQHDLLX0
.ENDS

.SUBCKT latchtriestado_156 In Out1 Out2 En1 En2 Write rst VSS VDD_1V8
XOut1_tri VSS En1 VDD_1V8 q Out1 BTHHDLLX1
XOut2_tri VSS En2 VDD_1V8 q Out2 BTHHDLLX1
Xq_reg q VSS rst VDD_1V8 In Write DLHRQHDLLX0
.ENDS

.SUBCKT latchtriestado_155 In Out1 Out2 En1 En2 Write rst VSS VDD_1V8
XOut1_tri VSS En1 VDD_1V8 q Out1 BTHHDLLX1
XOut2_tri VSS En2 VDD_1V8 q Out2 BTHHDLLX1
Xq_reg q VSS rst VDD_1V8 In Write DLHRQHDLLX0
.ENDS

.SUBCKT latchtriestado_154 In Out1 Out2 En1 En2 Write rst VSS VDD_1V8
XOut1_tri VSS En1 VDD_1V8 q Out1 BTHHDLLX1
XOut2_tri VSS En2 VDD_1V8 q Out2 BTHHDLLX1
Xq_reg q VSS rst VDD_1V8 In Write DLHRQHDLLX0
.ENDS

.SUBCKT latchtriestado_153 In Out1 Out2 En1 En2 Write rst VSS VDD_1V8
XOut1_tri VSS En1 VDD_1V8 q Out1 BTHHDLLX1
XOut2_tri VSS En2 VDD_1V8 q Out2 BTHHDLLX1
Xq_reg q VSS rst VDD_1V8 In Write DLHRQHDLLX0
.ENDS

.SUBCKT latchtriestado_152 In Out1 Out2 En1 En2 Write rst VSS VDD_1V8
XOut1_tri VSS En1 VDD_1V8 q Out1 BTHHDLLX1
XOut2_tri VSS En2 VDD_1V8 q Out2 BTHHDLLX1
Xq_reg q VSS rst VDD_1V8 In Write DLHRQHDLLX0
.ENDS

.SUBCKT latchtriestado_151 In Out1 Out2 En1 En2 Write rst VSS VDD_1V8
XOut1_tri VSS En1 VDD_1V8 q Out1 BTHHDLLX1
XOut2_tri VSS En2 VDD_1V8 q Out2 BTHHDLLX1
Xq_reg q VSS rst VDD_1V8 In Write DLHRQHDLLX0
.ENDS

.SUBCKT latchtriestado_150 In Out1 Out2 En1 En2 Write rst VSS VDD_1V8
XOut1_tri VSS En1 VDD_1V8 q Out1 BTHHDLLX1
XOut2_tri VSS En2 VDD_1V8 q Out2 BTHHDLLX1
Xq_reg q VSS rst VDD_1V8 In Write DLHRQHDLLX0
.ENDS

.SUBCKT latchtriestado_149 In Out1 Out2 En1 En2 Write rst VSS VDD_1V8
XOut2_tri VSS En2 VDD_1V8 q Out2 BTHHDLLX1
XOut1_tri VSS En1 VDD_1V8 q Out1 BTHHDLLX1
Xq_reg q VSS rst VDD_1V8 In Write DLHRQHDLLX0
.ENDS

.SUBCKT latchtriestado_148 In Out1 Out2 En1 En2 Write rst VSS VDD_1V8
XOut2_tri VSS En2 VDD_1V8 q Out2 BTHHDLLX1
XOut1_tri VSS En1 VDD_1V8 q Out1 BTHHDLLX1
Xq_reg q VSS rst VDD_1V8 In Write DLHRQHDLLX0
.ENDS

.SUBCKT latchtriestado_147 In Out1 Out2 En1 En2 Write rst VSS VDD_1V8
XOut1_tri VSS En1 VDD_1V8 q Out1 BTHHDLLX1
XOut2_tri VSS En2 VDD_1V8 q Out2 BTHHDLLX1
Xq_reg q VSS rst VDD_1V8 In Write DLHRQHDLLX0
.ENDS

.SUBCKT latchtriestado_146 In Out1 Out2 En1 En2 Write rst VSS VDD_1V8
XOut1_tri VSS En1 VDD_1V8 q Out1 BTHHDLLX1
XOut2_tri VSS En2 VDD_1V8 q Out2 BTHHDLLX1
Xq_reg q VSS rst VDD_1V8 In Write DLHRQHDLLX0
.ENDS

.SUBCKT latchtriestado_145 In Out1 Out2 En1 En2 Write rst VSS VDD_1V8
XOut1_tri VSS En1 VDD_1V8 q Out1 BTHHDLLX1
XOut2_tri VSS En2 VDD_1V8 q Out2 BTHHDLLX1
Xq_reg q VSS rst VDD_1V8 In Write DLHRQHDLLX0
.ENDS

.SUBCKT latchtriestado_144 In Out1 Out2 En1 En2 Write rst VSS VDD_1V8
XOut1_tri VSS En1 VDD_1V8 q Out1 BTHHDLLX1
XOut2_tri VSS En2 VDD_1V8 q Out2 BTHHDLLX1
Xq_reg q VSS rst VDD_1V8 In Write DLHRQHDLLX0
.ENDS

.SUBCKT latchtriestado_143 In Out1 Out2 En1 En2 Write rst VSS VDD_1V8
XOut1_tri VSS En1 VDD_1V8 q Out1 BTHHDLLX1
XOut2_tri VSS En2 VDD_1V8 q Out2 BTHHDLLX1
Xq_reg q VSS rst VDD_1V8 In Write DLHRQHDLLX0
.ENDS

.SUBCKT latchtriestado_142 In Out1 Out2 En1 En2 Write rst VSS VDD_1V8
Xq_reg q VSS rst VDD_1V8 In Write DLHRQHDLLX0
XOut1_tri VSS En1 VDD_1V8 q Out1 BTHHDLLX1
XOut2_tri VSS En2 VDD_1V8 q Out2 BTHHDLLX1
.ENDS

.SUBCKT latchtriestado_141 In Out1 Out2 En1 En2 Write rst VSS VDD_1V8
Xq_reg q VSS rst VDD_1V8 In Write DLHRQHDLLX0
XOut1_tri VSS En1 VDD_1V8 q Out1 BTHHDLLX1
XOut2_tri VSS En2 VDD_1V8 q Out2 BTHHDLLX1
.ENDS

.SUBCKT latchtriestado_140 In Out1 Out2 En1 En2 Write rst VSS VDD_1V8
Xq_reg q VSS rst VDD_1V8 In Write DLHRQHDLLX0
XOut1_tri VSS En1 VDD_1V8 q Out1 BTHHDLLX1
XOut2_tri VSS En2 VDD_1V8 q Out2 BTHHDLLX1
.ENDS

.SUBCKT latchtriestado_139 In Out1 Out2 En1 En2 Write rst VSS VDD_1V8
Xq_reg q VSS rst VDD_1V8 In Write DLHRQHDLLX0
XOut1_tri VSS En1 VDD_1V8 q Out1 BTHHDLLX1
XOut2_tri VSS En2 VDD_1V8 q Out2 BTHHDLLX1
.ENDS

.SUBCKT latchtriestado_138 In Out1 Out2 En1 En2 Write rst VSS VDD_1V8
Xq_reg q VSS rst VDD_1V8 In Write DLHRQHDLLX0
XOut2_tri VSS En2 VDD_1V8 q Out2 BTHHDLLX1
XOut1_tri VSS En1 VDD_1V8 q Out1 BTHHDLLX1
.ENDS

.SUBCKT latchtriestado_137 In Out1 Out2 En1 En2 Write rst VSS VDD_1V8
XOut1_tri VSS En1 VDD_1V8 q Out1 BTHHDLLX1
XOut2_tri VSS En2 VDD_1V8 q Out2 BTHHDLLX1
Xq_reg q VSS rst VDD_1V8 In Write DLHRQHDLLX0
.ENDS

.SUBCKT latchtriestado_136 In Out1 Out2 En1 En2 Write rst VSS VDD_1V8
XOut2_tri VSS En2 VDD_1V8 q Out2 BTHHDLLX1
XOut1_tri VSS En1 VDD_1V8 q Out1 BTHHDLLX1
Xq_reg q VSS rst VDD_1V8 In Write DLHRQHDLLX0
.ENDS

.SUBCKT latchtriestado_135 In Out1 Out2 En1 En2 Write rst VSS VDD_1V8
XOut2_tri VSS En2 VDD_1V8 q Out2 BTHHDLLX1
XOut1_tri VSS En1 VDD_1V8 q Out1 BTHHDLLX1
Xq_reg q VSS rst VDD_1V8 In Write DLHRQHDLLX0
.ENDS

.SUBCKT latchtriestado_134 In Out1 Out2 En1 En2 Write rst VSS VDD_1V8
XOut1_tri VSS En1 VDD_1V8 q Out1 BTHHDLLX1
XOut2_tri VSS En2 VDD_1V8 q Out2 BTHHDLLX1
Xq_reg q VSS rst VDD_1V8 In Write DLHRQHDLLX0
.ENDS

.SUBCKT latchtriestado_133 In Out1 Out2 En1 En2 Write rst VSS VDD_1V8
XOut1_tri VSS En1 VDD_1V8 q Out1 BTHHDLLX1
XOut2_tri VSS En2 VDD_1V8 q Out2 BTHHDLLX1
Xq_reg q VSS rst VDD_1V8 In Write DLHRQHDLLX0
.ENDS

.SUBCKT latchtriestado_132 In Out1 Out2 En1 En2 Write rst VSS VDD_1V8
XOut1_tri VSS En1 VDD_1V8 q Out1 BTHHDLLX1
XOut2_tri VSS En2 VDD_1V8 q Out2 BTHHDLLX1
Xq_reg q VSS rst VDD_1V8 In Write DLHRQHDLLX0
.ENDS

.SUBCKT latchtriestado_131 In Out1 Out2 En1 En2 Write rst VSS VDD_1V8
XOut1_tri VSS En1 VDD_1V8 q Out1 BTHHDLLX1
XOut2_tri VSS En2 VDD_1V8 q Out2 BTHHDLLX1
Xq_reg q VSS rst VDD_1V8 In Write DLHRQHDLLX0
.ENDS

.SUBCKT latchtriestado_130 In Out1 Out2 En1 En2 Write rst VSS VDD_1V8
XOut2_tri VSS En2 VDD_1V8 q Out2 BTHHDLLX1
XOut1_tri VSS En1 VDD_1V8 q Out1 BTHHDLLX1
Xq_reg q VSS rst VDD_1V8 In Write DLHRQHDLLX0
.ENDS

.SUBCKT latchtriestado_129 In Out1 Out2 En1 En2 Write rst VSS VDD_1V8
XOut1_tri VSS En1 VDD_1V8 q Out1 BTHHDLLX1
XOut2_tri VSS En2 VDD_1V8 q Out2 BTHHDLLX1
Xq_reg q VSS rst VDD_1V8 In Write DLHRQHDLLX0
.ENDS

.SUBCKT latchtriestado_128 In Out1 Out2 En1 En2 Write rst VSS VDD_1V8
XOut1_tri VSS En1 VDD_1V8 q Out1 BTHHDLLX1
XOut2_tri VSS En2 VDD_1V8 q Out2 BTHHDLLX1
Xq_reg q VSS rst VDD_1V8 In Write DLHRQHDLLX0
.ENDS

.SUBCKT latchtriestado_127 In Out1 Out2 En1 En2 Write rst VSS VDD_1V8
XOut1_tri VSS En1 VDD_1V8 q Out1 BTHHDLLX1
XOut2_tri VSS En2 VDD_1V8 q Out2 BTHHDLLX1
Xq_reg q VSS rst VDD_1V8 In Write DLHRQHDLLX0
.ENDS

.SUBCKT latchtriestado_126 In Out1 Out2 En1 En2 Write rst VSS VDD_1V8
XOut1_tri VSS En1 VDD_1V8 q Out1 BTHHDLLX1
XOut2_tri VSS En2 VDD_1V8 q Out2 BTHHDLLX1
Xq_reg q VSS rst VDD_1V8 In Write DLHRQHDLLX0
.ENDS

.SUBCKT latchtriestado_125 In Out1 Out2 En1 En2 Write rst VSS VDD_1V8
XOut1_tri VSS En1 VDD_1V8 q Out1 BTHHDLLX1
XOut2_tri VSS En2 VDD_1V8 q Out2 BTHHDLLX1
Xq_reg q VSS rst VDD_1V8 In Write DLHRQHDLLX0
.ENDS

.SUBCKT latchtriestado_124 In Out1 Out2 En1 En2 Write rst VSS VDD_1V8
XOut1_tri VSS En1 VDD_1V8 q Out1 BTHHDLLX1
XOut2_tri VSS En2 VDD_1V8 q Out2 BTHHDLLX1
Xq_reg q VSS rst VDD_1V8 In Write DLHRQHDLLX0
.ENDS

.SUBCKT latchtriestado_123 In Out1 Out2 En1 En2 Write rst VSS VDD_1V8
XOut1_tri VSS En1 VDD_1V8 q Out1 BTHHDLLX1
XOut2_tri VSS En2 VDD_1V8 q Out2 BTHHDLLX1
Xq_reg q VSS rst VDD_1V8 In Write DLHRQHDLLX0
.ENDS

.SUBCKT latchtriestado_122 In Out1 Out2 En1 En2 Write rst VSS VDD_1V8
XOut1_tri VSS En1 VDD_1V8 q Out1 BTHHDLLX1
XOut2_tri VSS En2 VDD_1V8 q Out2 BTHHDLLX1
Xq_reg q VSS rst VDD_1V8 In Write DLHRQHDLLX0
.ENDS

.SUBCKT latchtriestado_121 In Out1 Out2 En1 En2 Write rst VSS VDD_1V8
XOut1_tri VSS En1 VDD_1V8 q Out1 BTHHDLLX1
XOut2_tri VSS En2 VDD_1V8 q Out2 BTHHDLLX1
Xq_reg q VSS rst VDD_1V8 In Write DLHRQHDLLX0
.ENDS

.SUBCKT latchtriestado_120 In Out1 Out2 En1 En2 Write rst VSS VDD_1V8
XOut1_tri VSS En1 VDD_1V8 q Out1 BTHHDLLX1
XOut2_tri VSS En2 VDD_1V8 q Out2 BTHHDLLX1
Xq_reg q VSS rst VDD_1V8 In Write DLHRQHDLLX0
.ENDS

.SUBCKT latchtriestado_119 In Out1 Out2 En1 En2 Write rst VSS VDD_1V8
XOut1_tri VSS En1 VDD_1V8 q Out1 BTHHDLLX1
XOut2_tri VSS En2 VDD_1V8 q Out2 BTHHDLLX1
Xq_reg q VSS rst VDD_1V8 In Write DLHRQHDLLX0
.ENDS

.SUBCKT latchtriestado_118 In Out1 Out2 En1 En2 Write rst VSS VDD_1V8
XOut1_tri VSS En1 VDD_1V8 q Out1 BTHHDLLX1
XOut2_tri VSS En2 VDD_1V8 q Out2 BTHHDLLX1
Xq_reg q VSS rst VDD_1V8 In Write DLHRQHDLLX0
.ENDS

.SUBCKT latchtriestado_117 In Out1 Out2 En1 En2 Write rst VSS VDD_1V8
XOut1_tri VSS En1 VDD_1V8 q Out1 BTHHDLLX1
XOut2_tri VSS En2 VDD_1V8 q Out2 BTHHDLLX1
Xq_reg q VSS rst VDD_1V8 In Write DLHRQHDLLX0
.ENDS

.SUBCKT latchtriestado_116 In Out1 Out2 En1 En2 Write rst VSS VDD_1V8
XOut1_tri VSS En1 VDD_1V8 q Out1 BTHHDLLX1
XOut2_tri VSS En2 VDD_1V8 q Out2 BTHHDLLX1
Xq_reg q VSS rst VDD_1V8 In Write DLHRQHDLLX0
.ENDS

.SUBCKT latchtriestado_115 In Out1 Out2 En1 En2 Write rst VSS VDD_1V8
XOut1_tri VSS En1 VDD_1V8 q Out1 BTHHDLLX1
XOut2_tri VSS En2 VDD_1V8 q Out2 BTHHDLLX1
Xq_reg q VSS rst VDD_1V8 In Write DLHRQHDLLX0
.ENDS

.SUBCKT latchtriestado_114 In Out1 Out2 En1 En2 Write rst VSS VDD_1V8
XOut2_tri VSS En2 VDD_1V8 q Out2 BTHHDLLX1
XOut1_tri VSS En1 VDD_1V8 q Out1 BTHHDLLX1
Xq_reg q VSS rst VDD_1V8 In Write DLHRQHDLLX0
.ENDS

.SUBCKT latchtriestado_113 In Out1 Out2 En1 En2 Write rst VSS VDD_1V8
XOut1_tri VSS En1 VDD_1V8 q Out1 BTHHDLLX1
XOut2_tri VSS En2 VDD_1V8 q Out2 BTHHDLLX1
Xq_reg q VSS rst VDD_1V8 In Write DLHRQHDLLX0
.ENDS

.SUBCKT latchtriestado_112 In Out1 Out2 En1 En2 Write rst VSS VDD_1V8
XOut1_tri VSS En1 VDD_1V8 q Out1 BTHHDLLX1
XOut2_tri VSS En2 VDD_1V8 q Out2 BTHHDLLX1
Xq_reg q VSS rst VDD_1V8 In Write DLHRQHDLLX0
.ENDS

.SUBCKT latchtriestado_111 In Out1 Out2 En1 En2 Write rst VSS VDD_1V8
XOut1_tri VSS En1 VDD_1V8 q Out1 BTHHDLLX1
XOut2_tri VSS En2 VDD_1V8 q Out2 BTHHDLLX1
Xq_reg q VSS rst VDD_1V8 In Write DLHRQHDLLX0
.ENDS

.SUBCKT latchtriestado_110 In Out1 Out2 En1 En2 Write rst VSS VDD_1V8
Xq_reg q VSS rst VDD_1V8 In Write DLHRQHDLLX0
XOut1_tri VSS En1 VDD_1V8 q Out1 BTHHDLLX1
XOut2_tri VSS En2 VDD_1V8 q Out2 BTHHDLLX1
.ENDS

.SUBCKT latchtriestado_109 In Out1 Out2 En1 En2 Write rst VSS VDD_1V8
Xq_reg q VSS rst VDD_1V8 In Write DLHRQHDLLX0
XOut1_tri VSS En1 VDD_1V8 q Out1 BTHHDLLX1
XOut2_tri VSS En2 VDD_1V8 q Out2 BTHHDLLX1
.ENDS

.SUBCKT latchtriestado_108 In Out1 Out2 En1 En2 Write rst VSS VDD_1V8
Xq_reg q VSS rst VDD_1V8 In Write DLHRQHDLLX0
XOut1_tri VSS En1 VDD_1V8 q Out1 BTHHDLLX1
XOut2_tri VSS En2 VDD_1V8 q Out2 BTHHDLLX1
.ENDS

.SUBCKT latchtriestado_107 In Out1 Out2 En1 En2 Write rst VSS VDD_1V8
Xq_reg q VSS rst VDD_1V8 In Write DLHRQHDLLX0
XOut2_tri VSS En2 VDD_1V8 q Out2 BTHHDLLX1
XOut1_tri VSS En1 VDD_1V8 q Out1 BTHHDLLX1
.ENDS

.SUBCKT latchtriestado_106 In Out1 Out2 En1 En2 Write rst VSS VDD_1V8
Xq_reg q VSS rst VDD_1V8 In Write DLHRQHDLLX0
XOut2_tri VSS En2 VDD_1V8 q Out2 BTHHDLLX1
XOut1_tri VSS En1 VDD_1V8 q Out1 BTHHDLLX1
.ENDS

.SUBCKT latchtriestado_105 In Out1 Out2 En1 En2 Write rst VSS VDD_1V8
XOut1_tri VSS En1 VDD_1V8 q Out1 BTHHDLLX1
XOut2_tri VSS En2 VDD_1V8 q Out2 BTHHDLLX1
Xq_reg q VSS rst VDD_1V8 In Write DLHRQHDLLX0
.ENDS

.SUBCKT latchtriestado_104 In Out1 Out2 En1 En2 Write rst VSS VDD_1V8
XOut1_tri VSS En1 VDD_1V8 q Out1 BTHHDLLX1
XOut2_tri VSS En2 VDD_1V8 q Out2 BTHHDLLX1
Xq_reg q VSS rst VDD_1V8 In Write DLHRQHDLLX0
.ENDS

.SUBCKT latchtriestado_103 In Out1 Out2 En1 En2 Write rst VSS VDD_1V8
XOut1_tri VSS En1 VDD_1V8 q Out1 BTHHDLLX1
XOut2_tri VSS En2 VDD_1V8 q Out2 BTHHDLLX1
Xq_reg q VSS rst VDD_1V8 In Write DLHRQHDLLX0
.ENDS

.SUBCKT latchtriestado_102 In Out1 Out2 En1 En2 Write rst VSS VDD_1V8
XOut1_tri VSS En1 VDD_1V8 q Out1 BTHHDLLX1
XOut2_tri VSS En2 VDD_1V8 q Out2 BTHHDLLX1
Xq_reg q VSS rst VDD_1V8 In Write DLHRQHDLLX0
.ENDS

.SUBCKT latchtriestado_101 In Out1 Out2 En1 En2 Write rst VSS VDD_1V8
XOut2_tri VSS En2 VDD_1V8 q Out2 BTHHDLLX1
XOut1_tri VSS En1 VDD_1V8 q Out1 BTHHDLLX1
Xq_reg q VSS rst VDD_1V8 In Write DLHRQHDLLX0
.ENDS

.SUBCKT latchtriestado_100 In Out1 Out2 En1 En2 Write rst VSS VDD_1V8
XOut2_tri VSS En2 VDD_1V8 q Out2 BTHHDLLX1
XOut1_tri VSS En1 VDD_1V8 q Out1 BTHHDLLX1
Xq_reg q VSS rst VDD_1V8 In Write DLHRQHDLLX0
.ENDS

.SUBCKT latchtriestado_99 In Out1 Out2 En1 En2 Write rst VSS VDD_1V8
XOut2_tri VSS En2 VDD_1V8 q Out2 BTHHDLLX1
XOut1_tri VSS En1 VDD_1V8 q Out1 BTHHDLLX1
Xq_reg q VSS rst VDD_1V8 In Write DLHRQHDLLX0
.ENDS

.SUBCKT latchtriestado_98 In Out1 Out2 En1 En2 Write rst VSS VDD_1V8
XOut2_tri VSS En2 VDD_1V8 q Out2 BTHHDLLX1
XOut1_tri VSS En1 VDD_1V8 q Out1 BTHHDLLX1
Xq_reg q VSS rst VDD_1V8 In Write DLHRQHDLLX0
.ENDS

.SUBCKT latchtriestado_97 In Out1 Out2 En1 En2 Write rst VSS VDD_1V8
XOut2_tri VSS En2 VDD_1V8 q Out2 BTHHDLLX1
XOut1_tri VSS En1 VDD_1V8 q Out1 BTHHDLLX1
Xq_reg q VSS rst VDD_1V8 In Write DLHRQHDLLX0
.ENDS

.SUBCKT latchtriestado_96 In Out1 Out2 En1 En2 Write rst VSS VDD_1V8
XOut1_tri VSS En1 VDD_1V8 q Out1 BTHHDLLX1
XOut2_tri VSS En2 VDD_1V8 q Out2 BTHHDLLX1
Xq_reg q VSS rst VDD_1V8 In Write DLHRQHDLLX0
.ENDS

.SUBCKT latchtriestado_95 In Out1 Out2 En1 En2 Write rst VSS VDD_1V8
XOut1_tri VSS En1 VDD_1V8 q Out1 BTHHDLLX1
XOut2_tri VSS En2 VDD_1V8 q Out2 BTHHDLLX1
Xq_reg q VSS rst VDD_1V8 In Write DLHRQHDLLX0
.ENDS

.SUBCKT latchtriestado_94 In Out1 Out2 En1 En2 Write rst VSS VDD_1V8
XOut1_tri VSS En1 VDD_1V8 q Out1 BTHHDLLX1
XOut2_tri VSS En2 VDD_1V8 q Out2 BTHHDLLX1
Xq_reg q VSS rst VDD_1V8 In Write DLHRQHDLLX0
.ENDS

.SUBCKT latchtriestado_93 In Out1 Out2 En1 En2 Write rst VSS VDD_1V8
XOut1_tri VSS En1 VDD_1V8 q Out1 BTHHDLLX1
XOut2_tri VSS En2 VDD_1V8 q Out2 BTHHDLLX1
Xq_reg q VSS rst VDD_1V8 In Write DLHRQHDLLX0
.ENDS

.SUBCKT latchtriestado_92 In Out1 Out2 En1 En2 Write rst VSS VDD_1V8
XOut1_tri VSS En1 VDD_1V8 q Out1 BTHHDLLX1
XOut2_tri VSS En2 VDD_1V8 q Out2 BTHHDLLX1
Xq_reg q VSS rst VDD_1V8 In Write DLHRQHDLLX0
.ENDS

.SUBCKT latchtriestado_91 In Out1 Out2 En1 En2 Write rst VSS VDD_1V8
XOut1_tri VSS En1 VDD_1V8 q Out1 BTHHDLLX1
XOut2_tri VSS En2 VDD_1V8 q Out2 BTHHDLLX1
Xq_reg q VSS rst VDD_1V8 In Write DLHRQHDLLX0
.ENDS

.SUBCKT latchtriestado_90 In Out1 Out2 En1 En2 Write rst VSS VDD_1V8
XOut1_tri VSS En1 VDD_1V8 q Out1 BTHHDLLX1
XOut2_tri VSS En2 VDD_1V8 q Out2 BTHHDLLX1
Xq_reg q VSS rst VDD_1V8 In Write DLHRQHDLLX0
.ENDS

.SUBCKT latchtriestado_89 In Out1 Out2 En1 En2 Write rst VSS VDD_1V8
XOut1_tri VSS En1 VDD_1V8 q Out1 BTHHDLLX1
XOut2_tri VSS En2 VDD_1V8 q Out2 BTHHDLLX1
Xq_reg q VSS rst VDD_1V8 In Write DLHRQHDLLX0
.ENDS

.SUBCKT latchtriestado_88 In Out1 Out2 En1 En2 Write rst VSS VDD_1V8
XOut1_tri VSS En1 VDD_1V8 q Out1 BTHHDLLX1
XOut2_tri VSS En2 VDD_1V8 q Out2 BTHHDLLX1
Xq_reg q VSS rst VDD_1V8 In Write DLHRQHDLLX0
.ENDS

.SUBCKT latchtriestado_87 In Out1 Out2 En1 En2 Write rst VSS VDD_1V8
XOut1_tri VSS En1 VDD_1V8 q Out1 BTHHDLLX1
XOut2_tri VSS En2 VDD_1V8 q Out2 BTHHDLLX1
Xq_reg q VSS rst VDD_1V8 In Write DLHRQHDLLX0
.ENDS

.SUBCKT latchtriestado_86 In Out1 Out2 En1 En2 Write rst VSS VDD_1V8
XOut1_tri VSS En1 VDD_1V8 q Out1 BTHHDLLX1
XOut2_tri VSS En2 VDD_1V8 q Out2 BTHHDLLX1
Xq_reg q VSS rst VDD_1V8 In Write DLHRQHDLLX0
.ENDS

.SUBCKT latchtriestado_85 In Out1 Out2 En1 En2 Write rst VSS VDD_1V8
XOut1_tri VSS En1 VDD_1V8 q Out1 BTHHDLLX1
XOut2_tri VSS En2 VDD_1V8 q Out2 BTHHDLLX1
Xq_reg q VSS rst VDD_1V8 In Write DLHRQHDLLX0
.ENDS

.SUBCKT latchtriestado_84 In Out1 Out2 En1 En2 Write rst VSS VDD_1V8
XOut1_tri VSS En1 VDD_1V8 q Out1 BTHHDLLX1
XOut2_tri VSS En2 VDD_1V8 q Out2 BTHHDLLX1
Xq_reg q VSS rst VDD_1V8 In Write DLHRQHDLLX0
.ENDS

.SUBCKT latchtriestado_83 In Out1 Out2 En1 En2 Write rst VSS VDD_1V8
XOut1_tri VSS En1 VDD_1V8 q Out1 BTHHDLLX1
XOut2_tri VSS En2 VDD_1V8 q Out2 BTHHDLLX1
Xq_reg q VSS rst VDD_1V8 In Write DLHRQHDLLX0
.ENDS

.SUBCKT latchtriestado_82 In Out1 Out2 En1 En2 Write rst VSS VDD_1V8
XOut1_tri VSS En1 VDD_1V8 q Out1 BTHHDLLX1
XOut2_tri VSS En2 VDD_1V8 q Out2 BTHHDLLX1
Xq_reg q VSS rst VDD_1V8 In Write DLHRQHDLLX0
.ENDS

.SUBCKT latchtriestado_81 In Out1 Out2 En1 En2 Write rst VSS VDD_1V8
XOut1_tri VSS En1 VDD_1V8 q Out1 BTHHDLLX1
XOut2_tri VSS En2 VDD_1V8 q Out2 BTHHDLLX1
Xq_reg q VSS rst VDD_1V8 In Write DLHRQHDLLX0
.ENDS

.SUBCKT latchtriestado_80 In Out1 Out2 En1 En2 Write rst VSS VDD_1V8
XOut1_tri VSS En1 VDD_1V8 q Out1 BTHHDLLX1
XOut2_tri VSS En2 VDD_1V8 q Out2 BTHHDLLX1
Xq_reg q VSS rst VDD_1V8 In Write DLHRQHDLLX0
.ENDS

.SUBCKT latchtriestado_79 In Out1 Out2 En1 En2 Write rst VSS VDD_1V8
XOut1_tri VSS En1 VDD_1V8 q Out1 BTHHDLLX1
XOut2_tri VSS En2 VDD_1V8 q Out2 BTHHDLLX1
Xq_reg q VSS rst VDD_1V8 In Write DLHRQHDLLX0
.ENDS

.SUBCKT latchtriestado_78 In Out1 Out2 En1 En2 Write rst VSS VDD_1V8
Xq_reg q VSS rst VDD_1V8 In Write DLHRQHDLLX0
XOut1_tri VSS En1 VDD_1V8 q Out1 BTHHDLLX1
XOut2_tri VSS En2 VDD_1V8 q Out2 BTHHDLLX1
.ENDS

.SUBCKT latchtriestado_77 In Out1 Out2 En1 En2 Write rst VSS VDD_1V8
Xq_reg q VSS rst VDD_1V8 In Write DLHRQHDLLX0
XOut1_tri VSS En1 VDD_1V8 q Out1 BTHHDLLX1
XOut2_tri VSS En2 VDD_1V8 q Out2 BTHHDLLX1
.ENDS

.SUBCKT latchtriestado_76 In Out1 Out2 En1 En2 Write rst VSS VDD_1V8
Xq_reg q VSS rst VDD_1V8 In Write DLHRQHDLLX0
XOut1_tri VSS En1 VDD_1V8 q Out1 BTHHDLLX1
XOut2_tri VSS En2 VDD_1V8 q Out2 BTHHDLLX1
.ENDS

.SUBCKT latchtriestado_75 In Out1 Out2 En1 En2 Write rst VSS VDD_1V8
Xq_reg q VSS rst VDD_1V8 In Write DLHRQHDLLX0
XOut1_tri VSS En1 VDD_1V8 q Out1 BTHHDLLX1
XOut2_tri VSS En2 VDD_1V8 q Out2 BTHHDLLX1
.ENDS

.SUBCKT latchtriestado_74 In Out1 Out2 En1 En2 Write rst VSS VDD_1V8
Xq_reg q VSS rst VDD_1V8 In Write DLHRQHDLLX0
XOut1_tri VSS En1 VDD_1V8 q Out1 BTHHDLLX1
XOut2_tri VSS En2 VDD_1V8 q Out2 BTHHDLLX1
.ENDS

.SUBCKT latchtriestado_73 In Out1 Out2 En1 En2 Write rst VSS VDD_1V8
XOut2_tri VSS En2 VDD_1V8 q Out2 BTHHDLLX1
XOut1_tri VSS En1 VDD_1V8 q Out1 BTHHDLLX1
Xq_reg q VSS rst VDD_1V8 In Write DLHRQHDLLX0
.ENDS

.SUBCKT latchtriestado_72 In Out1 Out2 En1 En2 Write rst VSS VDD_1V8
XOut1_tri VSS En1 VDD_1V8 q Out1 BTHHDLLX1
XOut2_tri VSS En2 VDD_1V8 q Out2 BTHHDLLX1
Xq_reg q VSS rst VDD_1V8 In Write DLHRQHDLLX0
.ENDS

.SUBCKT latchtriestado_71 In Out1 Out2 En1 En2 Write rst VSS VDD_1V8
XOut2_tri VSS En2 VDD_1V8 q Out2 BTHHDLLX1
XOut1_tri VSS En1 VDD_1V8 q Out1 BTHHDLLX1
Xq_reg q VSS rst VDD_1V8 In Write DLHRQHDLLX0
.ENDS

.SUBCKT latchtriestado_70 In Out1 Out2 En1 En2 Write rst VSS VDD_1V8
XOut2_tri VSS En2 VDD_1V8 q Out2 BTHHDLLX1
XOut1_tri VSS En1 VDD_1V8 q Out1 BTHHDLLX1
Xq_reg q VSS rst VDD_1V8 In Write DLHRQHDLLX0
.ENDS

.SUBCKT latchtriestado_69 In Out1 Out2 En1 En2 Write rst VSS VDD_1V8
XOut1_tri VSS En1 VDD_1V8 q Out1 BTHHDLLX1
XOut2_tri VSS En2 VDD_1V8 q Out2 BTHHDLLX1
Xq_reg q VSS rst VDD_1V8 In Write DLHRQHDLLX0
.ENDS

.SUBCKT latchtriestado_68 In Out1 Out2 En1 En2 Write rst VSS VDD_1V8
XOut1_tri VSS En1 VDD_1V8 q Out1 BTHHDLLX1
XOut2_tri VSS En2 VDD_1V8 q Out2 BTHHDLLX1
Xq_reg q VSS rst VDD_1V8 In Write DLHRQHDLLX0
.ENDS

.SUBCKT latchtriestado_67 In Out1 Out2 En1 En2 Write rst VSS VDD_1V8
XOut1_tri VSS En1 VDD_1V8 q Out1 BTHHDLLX1
XOut2_tri VSS En2 VDD_1V8 q Out2 BTHHDLLX1
Xq_reg q VSS rst VDD_1V8 In Write DLHRQHDLLX0
.ENDS

.SUBCKT latchtriestado_66 In Out1 Out2 En1 En2 Write rst VSS VDD_1V8
XOut1_tri VSS En1 VDD_1V8 q Out1 BTHHDLLX1
XOut2_tri VSS En2 VDD_1V8 q Out2 BTHHDLLX1
Xq_reg q VSS rst VDD_1V8 In Write DLHRQHDLLX0
.ENDS

.SUBCKT latchtriestado_65 In Out1 Out2 En1 En2 Write rst VSS VDD_1V8
XOut1_tri VSS En1 VDD_1V8 q Out1 BTHHDLLX1
XOut2_tri VSS En2 VDD_1V8 q Out2 BTHHDLLX1
Xq_reg q VSS rst VDD_1V8 In Write DLHRQHDLLX0
.ENDS

.SUBCKT latchtriestado_64 In Out1 Out2 En1 En2 Write rst VSS VDD_1V8
XOut1_tri VSS En1 VDD_1V8 q Out1 BTHHDLLX1
XOut2_tri VSS En2 VDD_1V8 q Out2 BTHHDLLX1
Xq_reg q VSS rst VDD_1V8 In Write DLHRQHDLLX0
.ENDS

.SUBCKT latchtriestado_63 In Out1 Out2 En1 En2 Write rst VSS VDD_1V8
XOut1_tri VSS En1 VDD_1V8 q Out1 BTHHDLLX1
XOut2_tri VSS En2 VDD_1V8 q Out2 BTHHDLLX1
Xq_reg q VSS rst VDD_1V8 In Write DLHRQHDLLX0
.ENDS

.SUBCKT latchtriestado_62 In Out1 Out2 En1 En2 Write rst VSS VDD_1V8
XOut1_tri VSS En1 VDD_1V8 q Out1 BTHHDLLX1
XOut2_tri VSS En2 VDD_1V8 q Out2 BTHHDLLX1
Xq_reg q VSS rst VDD_1V8 In Write DLHRQHDLLX0
.ENDS

.SUBCKT latchtriestado_61 In Out1 Out2 En1 En2 Write rst VSS VDD_1V8
XOut1_tri VSS En1 VDD_1V8 q Out1 BTHHDLLX1
XOut2_tri VSS En2 VDD_1V8 q Out2 BTHHDLLX1
Xq_reg q VSS rst VDD_1V8 In Write DLHRQHDLLX0
.ENDS

.SUBCKT latchtriestado_60 In Out1 Out2 En1 En2 Write rst VSS VDD_1V8
XOut1_tri VSS En1 VDD_1V8 q Out1 BTHHDLLX1
XOut2_tri VSS En2 VDD_1V8 q Out2 BTHHDLLX1
Xq_reg q VSS rst VDD_1V8 In Write DLHRQHDLLX0
.ENDS

.SUBCKT latchtriestado_59 In Out1 Out2 En1 En2 Write rst VSS VDD_1V8
XOut1_tri VSS En1 VDD_1V8 q Out1 BTHHDLLX1
XOut2_tri VSS En2 VDD_1V8 q Out2 BTHHDLLX1
Xq_reg q VSS rst VDD_1V8 In Write DLHRQHDLLX0
.ENDS

.SUBCKT latchtriestado_58 In Out1 Out2 En1 En2 Write rst VSS VDD_1V8
XOut1_tri VSS En1 VDD_1V8 q Out1 BTHHDLLX1
XOut2_tri VSS En2 VDD_1V8 q Out2 BTHHDLLX1
Xq_reg q VSS rst VDD_1V8 In Write DLHRQHDLLX0
.ENDS

.SUBCKT latchtriestado_57 In Out1 Out2 En1 En2 Write rst VSS VDD_1V8
XOut1_tri VSS En1 VDD_1V8 q Out1 BTHHDLLX1
XOut2_tri VSS En2 VDD_1V8 q Out2 BTHHDLLX1
Xq_reg q VSS rst VDD_1V8 In Write DLHRQHDLLX0
.ENDS

.SUBCKT latchtriestado_56 In Out1 Out2 En1 En2 Write rst VSS VDD_1V8
XOut1_tri VSS En1 VDD_1V8 q Out1 BTHHDLLX1
XOut2_tri VSS En2 VDD_1V8 q Out2 BTHHDLLX1
Xq_reg q VSS rst VDD_1V8 In Write DLHRQHDLLX0
.ENDS

.SUBCKT latchtriestado_55 In Out1 Out2 En1 En2 Write rst VSS VDD_1V8
XOut1_tri VSS En1 VDD_1V8 q Out1 BTHHDLLX1
XOut2_tri VSS En2 VDD_1V8 q Out2 BTHHDLLX1
Xq_reg q VSS rst VDD_1V8 In Write DLHRQHDLLX0
.ENDS

.SUBCKT latchtriestado_54 In Out1 Out2 En1 En2 Write rst VSS VDD_1V8
XOut1_tri VSS En1 VDD_1V8 q Out1 BTHHDLLX1
XOut2_tri VSS En2 VDD_1V8 q Out2 BTHHDLLX1
Xq_reg q VSS rst VDD_1V8 In Write DLHRQHDLLX0
.ENDS

.SUBCKT latchtriestado_53 In Out1 Out2 En1 En2 Write rst VSS VDD_1V8
XOut1_tri VSS En1 VDD_1V8 q Out1 BTHHDLLX1
XOut2_tri VSS En2 VDD_1V8 q Out2 BTHHDLLX1
Xq_reg q VSS rst VDD_1V8 In Write DLHRQHDLLX0
.ENDS

.SUBCKT latchtriestado_52 In Out1 Out2 En1 En2 Write rst VSS VDD_1V8
XOut1_tri VSS En1 VDD_1V8 q Out1 BTHHDLLX1
XOut2_tri VSS En2 VDD_1V8 q Out2 BTHHDLLX1
Xq_reg q VSS rst VDD_1V8 In Write DLHRQHDLLX0
.ENDS

.SUBCKT latchtriestado_51 In Out1 Out2 En1 En2 Write rst VSS VDD_1V8
XOut1_tri VSS En1 VDD_1V8 q Out1 BTHHDLLX1
XOut2_tri VSS En2 VDD_1V8 q Out2 BTHHDLLX1
Xq_reg q VSS rst VDD_1V8 In Write DLHRQHDLLX0
.ENDS

.SUBCKT latchtriestado_50 In Out1 Out2 En1 En2 Write rst VSS VDD_1V8
XOut1_tri VSS En1 VDD_1V8 q Out1 BTHHDLLX1
XOut2_tri VSS En2 VDD_1V8 q Out2 BTHHDLLX1
Xq_reg q VSS rst VDD_1V8 In Write DLHRQHDLLX0
.ENDS

.SUBCKT latchtriestado_49 In Out1 Out2 En1 En2 Write rst VSS VDD_1V8
XOut1_tri VSS En1 VDD_1V8 q Out1 BTHHDLLX1
XOut2_tri VSS En2 VDD_1V8 q Out2 BTHHDLLX1
Xq_reg q VSS rst VDD_1V8 In Write DLHRQHDLLX0
.ENDS

.SUBCKT latchtriestado_48 In Out1 Out2 En1 En2 Write rst VSS VDD_1V8
XOut1_tri VSS En1 VDD_1V8 q Out1 BTHHDLLX1
XOut2_tri VSS En2 VDD_1V8 q Out2 BTHHDLLX1
Xq_reg q VSS rst VDD_1V8 In Write DLHRQHDLLX0
.ENDS

.SUBCKT latchtriestado_47 In Out1 Out2 En1 En2 Write rst VSS VDD_1V8
XOut1_tri VSS En1 VDD_1V8 q Out1 BTHHDLLX1
XOut2_tri VSS En2 VDD_1V8 q Out2 BTHHDLLX1
Xq_reg q VSS rst VDD_1V8 In Write DLHRQHDLLX0
.ENDS

.SUBCKT latchtriestado_46 In Out1 Out2 En1 En2 Write rst VSS VDD_1V8
Xq_reg q VSS rst VDD_1V8 In Write DLHRQHDLLX0
XOut1_tri VSS En1 VDD_1V8 q Out1 BTHHDLLX1
XOut2_tri VSS En2 VDD_1V8 q Out2 BTHHDLLX1
.ENDS

.SUBCKT latchtriestado_45 In Out1 Out2 En1 En2 Write rst VSS VDD_1V8
Xq_reg q VSS rst VDD_1V8 In Write DLHRQHDLLX0
XOut1_tri VSS En1 VDD_1V8 q Out1 BTHHDLLX1
XOut2_tri VSS En2 VDD_1V8 q Out2 BTHHDLLX1
.ENDS

.SUBCKT latchtriestado_44 In Out1 Out2 En1 En2 Write rst VSS VDD_1V8
Xq_reg q VSS rst VDD_1V8 In Write DLHRQHDLLX0
XOut1_tri VSS En1 VDD_1V8 q Out1 BTHHDLLX1
XOut2_tri VSS En2 VDD_1V8 q Out2 BTHHDLLX1
.ENDS

.SUBCKT latchtriestado_43 In Out1 Out2 En1 En2 Write rst VSS VDD_1V8
Xq_reg q VSS rst VDD_1V8 In Write DLHRQHDLLX0
XOut1_tri VSS En1 VDD_1V8 q Out1 BTHHDLLX1
XOut2_tri VSS En2 VDD_1V8 q Out2 BTHHDLLX1
.ENDS

.SUBCKT latchtriestado_42 In Out1 Out2 En1 En2 Write rst VSS VDD_1V8
Xq_reg q VSS rst VDD_1V8 In Write DLHRQHDLLX0
XOut1_tri VSS En1 VDD_1V8 q Out1 BTHHDLLX1
XOut2_tri VSS En2 VDD_1V8 q Out2 BTHHDLLX1
.ENDS

.SUBCKT latchtriestado_41 In Out1 Out2 En1 En2 Write rst VSS VDD_1V8
XOut2_tri VSS En2 VDD_1V8 q Out2 BTHHDLLX1
XOut1_tri VSS En1 VDD_1V8 q Out1 BTHHDLLX1
Xq_reg q VSS rst VDD_1V8 In Write DLHRQHDLLX0
.ENDS

.SUBCKT latchtriestado_40 In Out1 Out2 En1 En2 Write rst VSS VDD_1V8
XOut1_tri VSS En1 VDD_1V8 q Out1 BTHHDLLX1
XOut2_tri VSS En2 VDD_1V8 q Out2 BTHHDLLX1
Xq_reg q VSS rst VDD_1V8 In Write DLHRQHDLLX0
.ENDS

.SUBCKT latchtriestado_39 In Out1 Out2 En1 En2 Write rst VSS VDD_1V8
XOut1_tri VSS En1 VDD_1V8 q Out1 BTHHDLLX1
XOut2_tri VSS En2 VDD_1V8 q Out2 BTHHDLLX1
Xq_reg q VSS rst VDD_1V8 In Write DLHRQHDLLX0
.ENDS

.SUBCKT latchtriestado_38 In Out1 Out2 En1 En2 Write rst VSS VDD_1V8
XOut2_tri VSS En2 VDD_1V8 q Out2 BTHHDLLX1
XOut1_tri VSS En1 VDD_1V8 q Out1 BTHHDLLX1
Xq_reg q VSS rst VDD_1V8 In Write DLHRQHDLLX0
.ENDS

.SUBCKT latchtriestado_37 In Out1 Out2 En1 En2 Write rst VSS VDD_1V8
XOut1_tri VSS En1 VDD_1V8 q Out1 BTHHDLLX1
XOut2_tri VSS En2 VDD_1V8 q Out2 BTHHDLLX1
Xq_reg q VSS rst VDD_1V8 In Write DLHRQHDLLX0
.ENDS

.SUBCKT latchtriestado_36 In Out1 Out2 En1 En2 Write rst VSS VDD_1V8
XOut1_tri VSS En1 VDD_1V8 q Out1 BTHHDLLX1
XOut2_tri VSS En2 VDD_1V8 q Out2 BTHHDLLX1
Xq_reg q VSS rst VDD_1V8 In Write DLHRQHDLLX0
.ENDS

.SUBCKT latchtriestado_35 In Out1 Out2 En1 En2 Write rst VSS VDD_1V8
XOut1_tri VSS En1 VDD_1V8 q Out1 BTHHDLLX1
XOut2_tri VSS En2 VDD_1V8 q Out2 BTHHDLLX1
Xq_reg q VSS rst VDD_1V8 In Write DLHRQHDLLX0
.ENDS

.SUBCKT latchtriestado_34 In Out1 Out2 En1 En2 Write rst VSS VDD_1V8
XOut1_tri VSS En1 VDD_1V8 q Out1 BTHHDLLX1
XOut2_tri VSS En2 VDD_1V8 q Out2 BTHHDLLX1
Xq_reg q VSS rst VDD_1V8 In Write DLHRQHDLLX0
.ENDS

.SUBCKT latchtriestado_33 In Out1 Out2 En1 En2 Write rst VSS VDD_1V8
XOut1_tri VSS En1 VDD_1V8 q Out1 BTHHDLLX1
XOut2_tri VSS En2 VDD_1V8 q Out2 BTHHDLLX1
Xq_reg q VSS rst VDD_1V8 In Write DLHRQHDLLX0
.ENDS

.SUBCKT latchtriestado_32 In Out1 Out2 En1 En2 Write rst VSS VDD_1V8
XOut1_tri VSS En1 VDD_1V8 q Out1 BTHHDLLX1
XOut2_tri VSS En2 VDD_1V8 q Out2 BTHHDLLX1
Xq_reg q VSS rst VDD_1V8 In Write DLHRQHDLLX0
.ENDS

.SUBCKT latchtriestado_31 In Out1 Out2 En1 En2 Write rst VSS VDD_1V8
XOut1_tri VSS En1 VDD_1V8 q Out1 BTHHDLLX1
XOut2_tri VSS En2 VDD_1V8 q Out2 BTHHDLLX1
Xq_reg q VSS rst VDD_1V8 In Write DLHRQHDLLX0
.ENDS

.SUBCKT latchtriestado_30 In Out1 Out2 En1 En2 Write rst VSS VDD_1V8
XOut1_tri VSS En1 VDD_1V8 q Out1 BTHHDLLX1
XOut2_tri VSS En2 VDD_1V8 q Out2 BTHHDLLX1
Xq_reg q VSS rst VDD_1V8 In Write DLHRQHDLLX0
.ENDS

.SUBCKT latchtriestado_29 In Out1 Out2 En1 En2 Write rst VSS VDD_1V8
XOut1_tri VSS En1 VDD_1V8 q Out1 BTHHDLLX1
XOut2_tri VSS En2 VDD_1V8 q Out2 BTHHDLLX1
Xq_reg q VSS rst VDD_1V8 In Write DLHRQHDLLX0
.ENDS

.SUBCKT latchtriestado_28 In Out1 Out2 En1 En2 Write rst VSS VDD_1V8
XOut1_tri VSS En1 VDD_1V8 q Out1 BTHHDLLX1
XOut2_tri VSS En2 VDD_1V8 q Out2 BTHHDLLX1
Xq_reg q VSS rst VDD_1V8 In Write DLHRQHDLLX0
.ENDS

.SUBCKT latchtriestado_27 In Out1 Out2 En1 En2 Write rst VSS VDD_1V8
XOut1_tri VSS En1 VDD_1V8 q Out1 BTHHDLLX1
XOut2_tri VSS En2 VDD_1V8 q Out2 BTHHDLLX1
Xq_reg q VSS rst VDD_1V8 In Write DLHRQHDLLX0
.ENDS

.SUBCKT latchtriestado_26 In Out1 Out2 En1 En2 Write rst VSS VDD_1V8
XOut1_tri VSS En1 VDD_1V8 q Out1 BTHHDLLX1
XOut2_tri VSS En2 VDD_1V8 q Out2 BTHHDLLX1
Xq_reg q VSS rst VDD_1V8 In Write DLHRQHDLLX0
.ENDS

.SUBCKT latchtriestado_25 In Out1 Out2 En1 En2 Write rst VSS VDD_1V8
XOut1_tri VSS En1 VDD_1V8 q Out1 BTHHDLLX1
XOut2_tri VSS En2 VDD_1V8 q Out2 BTHHDLLX1
Xq_reg q VSS rst VDD_1V8 In Write DLHRQHDLLX0
.ENDS

.SUBCKT latchtriestado_24 In Out1 Out2 En1 En2 Write rst VSS VDD_1V8
XOut1_tri VSS En1 VDD_1V8 q Out1 BTHHDLLX1
XOut2_tri VSS En2 VDD_1V8 q Out2 BTHHDLLX1
Xq_reg q VSS rst VDD_1V8 In Write DLHRQHDLLX0
.ENDS

.SUBCKT latchtriestado_23 In Out1 Out2 En1 En2 Write rst VSS VDD_1V8
XOut1_tri VSS En1 VDD_1V8 q Out1 BTHHDLLX1
XOut2_tri VSS En2 VDD_1V8 q Out2 BTHHDLLX1
Xq_reg q VSS rst VDD_1V8 In Write DLHRQHDLLX0
.ENDS

.SUBCKT latchtriestado_22 In Out1 Out2 En1 En2 Write rst VSS VDD_1V8
XOut1_tri VSS En1 VDD_1V8 q Out1 BTHHDLLX1
XOut2_tri VSS En2 VDD_1V8 q Out2 BTHHDLLX1
Xq_reg q VSS rst VDD_1V8 In Write DLHRQHDLLX0
.ENDS

.SUBCKT latchtriestado_21 In Out1 Out2 En1 En2 Write rst VSS VDD_1V8
XOut2_tri VSS En2 VDD_1V8 q Out2 BTHHDLLX1
XOut1_tri VSS En1 VDD_1V8 q Out1 BTHHDLLX1
Xq_reg q VSS rst VDD_1V8 In Write DLHRQHDLLX0
.ENDS

.SUBCKT latchtriestado_20 In Out1 Out2 En1 En2 Write rst VSS VDD_1V8
XOut1_tri VSS En1 VDD_1V8 q Out1 BTHHDLLX1
XOut2_tri VSS En2 VDD_1V8 q Out2 BTHHDLLX1
Xq_reg q VSS rst VDD_1V8 In Write DLHRQHDLLX0
.ENDS

.SUBCKT latchtriestado_19 In Out1 Out2 En1 En2 Write rst VSS VDD_1V8
XOut2_tri VSS En2 VDD_1V8 q Out2 BTHHDLLX1
XOut1_tri VSS En1 VDD_1V8 q Out1 BTHHDLLX1
Xq_reg q VSS rst VDD_1V8 In Write DLHRQHDLLX0
.ENDS

.SUBCKT latchtriestado_18 In Out1 Out2 En1 En2 Write rst VSS VDD_1V8
XOut2_tri VSS En2 VDD_1V8 q Out2 BTHHDLLX1
XOut1_tri VSS En1 VDD_1V8 q Out1 BTHHDLLX1
Xq_reg q VSS rst VDD_1V8 In Write DLHRQHDLLX0
.ENDS

.SUBCKT latchtriestado_17 In Out1 Out2 En1 En2 Write rst VSS VDD_1V8
XOut2_tri VSS En2 VDD_1V8 q Out2 BTHHDLLX1
XOut1_tri VSS En1 VDD_1V8 q Out1 BTHHDLLX1
Xq_reg q VSS rst VDD_1V8 In Write DLHRQHDLLX0
.ENDS

.SUBCKT latchtriestado_16 In Out1 Out2 En1 En2 Write rst VSS VDD_1V8
XOut2_tri VSS En2 VDD_1V8 q Out2 BTHHDLLX1
XOut1_tri VSS En1 VDD_1V8 q Out1 BTHHDLLX1
Xq_reg q VSS rst VDD_1V8 In Write DLHRQHDLLX0
.ENDS

.SUBCKT latchtriestado_15 In Out1 Out2 En1 En2 Write rst VSS VDD_1V8
XOut1_tri VSS En1 VDD_1V8 q Out1 BTHHDLLX1
XOut2_tri VSS En2 VDD_1V8 q Out2 BTHHDLLX1
Xq_reg q VSS rst VDD_1V8 In Write DLHRQHDLLX0
.ENDS

.SUBCKT latchtriestado_14 In Out1 Out2 En1 En2 Write rst VSS VDD_1V8
Xq_reg q VSS rst VDD_1V8 In Write DLHRQHDLLX0
XOut1_tri VSS En1 VDD_1V8 q Out1 BTHHDLLX1
XOut2_tri VSS En2 VDD_1V8 q Out2 BTHHDLLX1
.ENDS

.SUBCKT latchtriestado_13 In Out1 Out2 En1 En2 Write rst VSS VDD_1V8
Xq_reg q VSS rst VDD_1V8 In Write DLHRQHDLLX0
XOut1_tri VSS En1 VDD_1V8 q Out1 BTHHDLLX1
XOut2_tri VSS En2 VDD_1V8 q Out2 BTHHDLLX1
.ENDS

.SUBCKT latchtriestado_12 In Out1 Out2 En1 En2 Write rst VSS VDD_1V8
Xq_reg q VSS rst VDD_1V8 In Write DLHRQHDLLX0
XOut1_tri VSS En1 VDD_1V8 q Out1 BTHHDLLX1
XOut2_tri VSS En2 VDD_1V8 q Out2 BTHHDLLX1
.ENDS

.SUBCKT latchtriestado_11 In Out1 Out2 En1 En2 Write rst VSS VDD_1V8
Xq_reg q VSS rst VDD_1V8 In Write DLHRQHDLLX0
XOut2_tri VSS En2 VDD_1V8 q Out2 BTHHDLLX1
XOut1_tri VSS En1 VDD_1V8 q Out1 BTHHDLLX1
.ENDS

.SUBCKT latchtriestado_10 In Out1 Out2 En1 En2 Write rst VSS VDD_1V8
Xq_reg q VSS rst VDD_1V8 In Write DLHRQHDLLX0
XOut2_tri VSS En2 VDD_1V8 q Out2 BTHHDLLX1
XOut1_tri VSS En1 VDD_1V8 q Out1 BTHHDLLX1
.ENDS

.SUBCKT latchtriestado_9 In Out1 Out2 En1 En2 Write rst VSS VDD_1V8
XOut2_tri VSS En2 VDD_1V8 q Out2 BTHHDLLX1
XOut1_tri VSS En1 VDD_1V8 q Out1 BTHHDLLX1
Xq_reg q VSS rst VDD_1V8 In Write DLHRQHDLLX0
.ENDS

.SUBCKT latchtriestado_8 In Out1 Out2 En1 En2 Write rst VSS VDD_1V8
XOut2_tri VSS En2 VDD_1V8 q Out2 BTHHDLLX1
XOut1_tri VSS En1 VDD_1V8 q Out1 BTHHDLLX1
Xq_reg q VSS rst VDD_1V8 In Write DLHRQHDLLX0
.ENDS

.SUBCKT latchtriestado_7 In Out1 Out2 En1 En2 Write rst VSS VDD_1V8
XOut2_tri VSS En2 VDD_1V8 q Out2 BTHHDLLX1
XOut1_tri VSS En1 VDD_1V8 q Out1 BTHHDLLX1
Xq_reg q VSS rst VDD_1V8 In Write DLHRQHDLLX0
.ENDS

.SUBCKT latchtriestado_6 In Out1 Out2 En1 En2 Write rst VSS VDD_1V8
XOut1_tri VSS En1 VDD_1V8 q Out1 BTHHDLLX1
XOut2_tri VSS En2 VDD_1V8 q Out2 BTHHDLLX1
Xq_reg q VSS rst VDD_1V8 In Write DLHRQHDLLX0
.ENDS

.SUBCKT latchtriestado_5 In Out1 Out2 En1 En2 Write rst VSS VDD_1V8
XOut2_tri VSS En2 VDD_1V8 q Out2 BTHHDLLX1
XOut1_tri VSS En1 VDD_1V8 q Out1 BTHHDLLX1
Xq_reg q VSS rst VDD_1V8 In Write DLHRQHDLLX0
.ENDS

.SUBCKT latchtriestado_4 In Out1 Out2 En1 En2 Write rst VSS VDD_1V8
XOut2_tri VSS En2 VDD_1V8 q Out2 BTHHDLLX1
XOut1_tri VSS En1 VDD_1V8 q Out1 BTHHDLLX1
Xq_reg q VSS rst VDD_1V8 In Write DLHRQHDLLX0
.ENDS

.SUBCKT latchtriestado_3 In Out1 Out2 En1 En2 Write rst VSS VDD_1V8
XOut2_tri VSS En2 VDD_1V8 q Out2 BTHHDLLX1
XOut1_tri VSS En1 VDD_1V8 q Out1 BTHHDLLX1
Xq_reg q VSS rst VDD_1V8 In Write DLHRQHDLLX0
.ENDS

.SUBCKT latchtriestado_2 In Out1 Out2 En1 En2 Write rst VSS VDD_1V8
XOut2_tri VSS En2 VDD_1V8 q Out2 BTHHDLLX1
XOut1_tri VSS En1 VDD_1V8 q Out1 BTHHDLLX1
Xq_reg q VSS rst VDD_1V8 In Write DLHRQHDLLX0
.ENDS

.SUBCKT latchtriestado_1 In Out1 Out2 En1 En2 Write rst VSS VDD_1V8
XOut2_tri VSS En2 VDD_1V8 q Out2 BTHHDLLX1
XOut1_tri VSS En1 VDD_1V8 q Out1 BTHHDLLX1
Xq_reg q VSS rst VDD_1V8 In Write DLHRQHDLLX0
.ENDS

.SUBCKT latchtriestado_0 In Out1 Out2 En1 En2 Write rst VSS VDD_1V8
XOut1_tri VSS En1 VDD_1V8 q Out1 BTHHDLLX1
XOut2_tri VSS En2 VDD_1V8 q Out2 BTHHDLLX1
Xq_reg q VSS rst VDD_1V8 In Write DLHRQHDLLX0
.ENDS

.SUBCKT tristategate_447 input_x enable output_x VSS VDD_1V8
XU1 n3 VSS VDD_1V8 LOGIC0HDLL
Xoutput_x_tri VSS enable VDD_1V8 n3 output_x BTHHDLLX1
.ENDS

.SUBCKT tristategate_446 input_x enable output_x VSS VDD_1V8
XU1 n6 VSS VDD_1V8 LOGIC0HDLL
Xoutput_x_tri VSS enable VDD_1V8 n6 output_x BTHHDLLX1
.ENDS

.SUBCKT tristategate_445 input_x enable output_x VSS VDD_1V8
XU1 n6 VSS VDD_1V8 LOGIC0HDLL
Xoutput_x_tri VSS enable VDD_1V8 n6 output_x BTHHDLLX1
.ENDS

.SUBCKT tristategate_444 input_x enable output_x VSS VDD_1V8
XU1 n6 VSS VDD_1V8 LOGIC0HDLL
Xoutput_x_tri VSS enable VDD_1V8 n6 output_x BTHHDLLX1
.ENDS

.SUBCKT tristategate_443 input_x enable output_x VSS VDD_1V8
XU1 n6 VSS VDD_1V8 LOGIC0HDLL
Xoutput_x_tri VSS enable VDD_1V8 n6 output_x BTHHDLLX1
.ENDS

.SUBCKT tristategate_442 input_x enable output_x VSS VDD_1V8
XU1 n6 VSS VDD_1V8 LOGIC0HDLL
Xoutput_x_tri VSS enable VDD_1V8 n6 output_x BTHHDLLX1
.ENDS

.SUBCKT tristategate_441 input_x enable output_x VSS VDD_1V8
XU1 n6 VSS VDD_1V8 LOGIC0HDLL
Xoutput_x_tri VSS enable VDD_1V8 n6 output_x BTHHDLLX1
.ENDS

.SUBCKT tristategate_440 input_x enable output_x VSS VDD_1V8
XU1 n6 VSS VDD_1V8 LOGIC0HDLL
Xoutput_x_tri VSS enable VDD_1V8 n6 output_x BTHHDLLX1
.ENDS

.SUBCKT tristategate_439 input_x enable output_x VSS VDD_1V8
XU1 n6 VSS VDD_1V8 LOGIC0HDLL
Xoutput_x_tri VSS enable VDD_1V8 n6 output_x BTHHDLLX1
.ENDS

.SUBCKT tristategate_438 input_x enable output_x VSS VDD_1V8
XU1 n6 VSS VDD_1V8 LOGIC0HDLL
Xoutput_x_tri VSS enable VDD_1V8 n6 output_x BTHHDLLX1
.ENDS

.SUBCKT tristategate_437 input_x enable output_x VSS VDD_1V8
XU1 n6 VSS VDD_1V8 LOGIC0HDLL
Xoutput_x_tri VSS enable VDD_1V8 n6 output_x BTHHDLLX1
.ENDS

.SUBCKT tristategate_436 input_x enable output_x VSS VDD_1V8
XU1 n6 VSS VDD_1V8 LOGIC0HDLL
Xoutput_x_tri VSS enable VDD_1V8 n6 output_x BTHHDLLX1
.ENDS

.SUBCKT tristategate_435 input_x enable output_x VSS VDD_1V8
XU1 n6 VSS VDD_1V8 LOGIC0HDLL
Xoutput_x_tri VSS enable VDD_1V8 n6 output_x BTHHDLLX1
.ENDS

.SUBCKT tristategate_434 input_x enable output_x VSS VDD_1V8
XU1 n6 VSS VDD_1V8 LOGIC0HDLL
Xoutput_x_tri VSS enable VDD_1V8 n6 output_x BTHHDLLX1
.ENDS

.SUBCKT tristategate_433 input_x enable output_x VSS VDD_1V8
XU1 n6 VSS VDD_1V8 LOGIC0HDLL
Xoutput_x_tri VSS enable VDD_1V8 n6 output_x BTHHDLLX1
.ENDS

.SUBCKT tristategate_432 input_x enable output_x VSS VDD_1V8
XU1 n6 VSS VDD_1V8 LOGIC0HDLL
Xoutput_x_tri VSS enable VDD_1V8 n6 output_x BTHHDLLX1
.ENDS

.SUBCKT tristategate_431 input_x enable output_x VSS VDD_1V8
XU1 n6 VSS VDD_1V8 LOGIC0HDLL
Xoutput_x_tri VSS enable VDD_1V8 n6 output_x BTHHDLLX1
.ENDS

.SUBCKT tristategate_430 input_x enable output_x VSS VDD_1V8
XU1 n6 VSS VDD_1V8 LOGIC0HDLL
Xoutput_x_tri VSS enable VDD_1V8 n6 output_x BTHHDLLX1
.ENDS

.SUBCKT tristategate_429 input_x enable output_x VSS VDD_1V8
XU1 n6 VSS VDD_1V8 LOGIC0HDLL
Xoutput_x_tri VSS enable VDD_1V8 n6 output_x BTHHDLLX1
.ENDS

.SUBCKT tristategate_428 input_x enable output_x VSS VDD_1V8
XU1 n6 VSS VDD_1V8 LOGIC0HDLL
Xoutput_x_tri VSS enable VDD_1V8 n6 output_x BTHHDLLX1
.ENDS

.SUBCKT tristategate_427 input_x enable output_x VSS VDD_1V8
XU1 n6 VSS VDD_1V8 LOGIC0HDLL
Xoutput_x_tri VSS enable VDD_1V8 n6 output_x BTHHDLLX1
.ENDS

.SUBCKT tristategate_426 input_x enable output_x VSS VDD_1V8
XU1 n6 VSS VDD_1V8 LOGIC0HDLL
Xoutput_x_tri VSS enable VDD_1V8 n6 output_x BTHHDLLX1
.ENDS

.SUBCKT tristategate_425 input_x enable output_x VSS VDD_1V8
XU1 n6 VSS VDD_1V8 LOGIC0HDLL
Xoutput_x_tri VSS enable VDD_1V8 n6 output_x BTHHDLLX1
.ENDS

.SUBCKT tristategate_424 input_x enable output_x VSS VDD_1V8
XU1 n6 VSS VDD_1V8 LOGIC0HDLL
Xoutput_x_tri VSS enable VDD_1V8 n6 output_x BTHHDLLX1
.ENDS

.SUBCKT tristategate_423 input_x enable output_x VSS VDD_1V8
XU1 n6 VSS VDD_1V8 LOGIC0HDLL
Xoutput_x_tri VSS enable VDD_1V8 n6 output_x BTHHDLLX1
.ENDS

.SUBCKT tristategate_422 input_x enable output_x VSS VDD_1V8
XU1 n6 VSS VDD_1V8 LOGIC0HDLL
Xoutput_x_tri VSS enable VDD_1V8 n6 output_x BTHHDLLX1
.ENDS

.SUBCKT tristategate_421 input_x enable output_x VSS VDD_1V8
XU1 n6 VSS VDD_1V8 LOGIC0HDLL
Xoutput_x_tri VSS enable VDD_1V8 n6 output_x BTHHDLLX1
.ENDS

.SUBCKT tristategate_420 input_x enable output_x VSS VDD_1V8
XU1 n6 VSS VDD_1V8 LOGIC0HDLL
Xoutput_x_tri VSS enable VDD_1V8 n6 output_x BTHHDLLX1
.ENDS

.SUBCKT tristategate_419 input_x enable output_x VSS VDD_1V8
XU1 n6 VSS VDD_1V8 LOGIC0HDLL
Xoutput_x_tri VSS enable VDD_1V8 n6 output_x BTHHDLLX1
.ENDS

.SUBCKT tristategate_418 input_x enable output_x VSS VDD_1V8
XU1 n6 VSS VDD_1V8 LOGIC0HDLL
Xoutput_x_tri VSS enable VDD_1V8 n6 output_x BTHHDLLX1
.ENDS

.SUBCKT tristategate_417 input_x enable output_x VSS VDD_1V8
XU1 n6 VSS VDD_1V8 LOGIC0HDLL
Xoutput_x_tri VSS enable VDD_1V8 n6 output_x BTHHDLLX1
.ENDS

.SUBCKT tristategate_416 input_x enable output_x VSS VDD_1V8
XU1 n6 VSS VDD_1V8 LOGIC0HDLL
Xoutput_x_tri VSS enable VDD_1V8 n6 output_x BTHHDLLX1
.ENDS

.SUBCKT tristategate_415 input_x enable output_x VSS VDD_1V8
XU1 n6 VSS VDD_1V8 LOGIC0HDLL
Xoutput_x_tri VSS enable VDD_1V8 n6 output_x BTHHDLLX1
.ENDS

.SUBCKT tristategate_414 input_x enable output_x VSS VDD_1V8
XU1 n6 VSS VDD_1V8 LOGIC0HDLL
Xoutput_x_tri VSS enable VDD_1V8 n6 output_x BTHHDLLX1
.ENDS

.SUBCKT tristategate_413 input_x enable output_x VSS VDD_1V8
XU1 n6 VSS VDD_1V8 LOGIC0HDLL
Xoutput_x_tri VSS enable VDD_1V8 n6 output_x BTHHDLLX1
.ENDS

.SUBCKT tristategate_412 input_x enable output_x VSS VDD_1V8
XU1 n6 VSS VDD_1V8 LOGIC0HDLL
Xoutput_x_tri VSS enable VDD_1V8 n6 output_x BTHHDLLX1
.ENDS

.SUBCKT tristategate_411 input_x enable output_x VSS VDD_1V8
XU1 n6 VSS VDD_1V8 LOGIC0HDLL
Xoutput_x_tri VSS enable VDD_1V8 n6 output_x BTHHDLLX1
.ENDS

.SUBCKT tristategate_410 input_x enable output_x VSS VDD_1V8
XU1 n6 VSS VDD_1V8 LOGIC0HDLL
Xoutput_x_tri VSS enable VDD_1V8 n6 output_x BTHHDLLX1
.ENDS

.SUBCKT tristategate_409 input_x enable output_x VSS VDD_1V8
XU1 n6 VSS VDD_1V8 LOGIC0HDLL
Xoutput_x_tri VSS enable VDD_1V8 n6 output_x BTHHDLLX1
.ENDS

.SUBCKT tristategate_408 input_x enable output_x VSS VDD_1V8
XU1 n6 VSS VDD_1V8 LOGIC0HDLL
Xoutput_x_tri VSS enable VDD_1V8 n6 output_x BTHHDLLX1
.ENDS

.SUBCKT tristategate_407 input_x enable output_x VSS VDD_1V8
XU1 n6 VSS VDD_1V8 LOGIC0HDLL
Xoutput_x_tri VSS enable VDD_1V8 n6 output_x BTHHDLLX1
.ENDS

.SUBCKT tristategate_406 input_x enable output_x VSS VDD_1V8
XU1 n6 VSS VDD_1V8 LOGIC0HDLL
Xoutput_x_tri VSS enable VDD_1V8 n6 output_x BTHHDLLX1
.ENDS

.SUBCKT tristategate_405 input_x enable output_x VSS VDD_1V8
XU1 n6 VSS VDD_1V8 LOGIC0HDLL
Xoutput_x_tri VSS enable VDD_1V8 n6 output_x BTHHDLLX1
.ENDS

.SUBCKT tristategate_404 input_x enable output_x VSS VDD_1V8
XU1 n6 VSS VDD_1V8 LOGIC0HDLL
Xoutput_x_tri VSS enable VDD_1V8 n6 output_x BTHHDLLX1
.ENDS

.SUBCKT tristategate_403 input_x enable output_x VSS VDD_1V8
XU1 n6 VSS VDD_1V8 LOGIC0HDLL
Xoutput_x_tri VSS enable VDD_1V8 n6 output_x BTHHDLLX1
.ENDS

.SUBCKT tristategate_402 input_x enable output_x VSS VDD_1V8
XU1 n6 VSS VDD_1V8 LOGIC0HDLL
Xoutput_x_tri VSS enable VDD_1V8 n6 output_x BTHHDLLX1
.ENDS

.SUBCKT tristategate_401 input_x enable output_x VSS VDD_1V8
XU1 n6 VSS VDD_1V8 LOGIC0HDLL
Xoutput_x_tri VSS enable VDD_1V8 n6 output_x BTHHDLLX1
.ENDS

.SUBCKT tristategate_400 input_x enable output_x VSS VDD_1V8
XU1 n6 VSS VDD_1V8 LOGIC0HDLL
Xoutput_x_tri VSS enable VDD_1V8 n6 output_x BTHHDLLX1
.ENDS

.SUBCKT tristategate_399 input_x enable output_x VSS VDD_1V8
XU1 n6 VSS VDD_1V8 LOGIC0HDLL
Xoutput_x_tri VSS enable VDD_1V8 n6 output_x BTHHDLLX1
.ENDS

.SUBCKT tristategate_398 input_x enable output_x VSS VDD_1V8
XU1 n6 VSS VDD_1V8 LOGIC0HDLL
Xoutput_x_tri VSS enable VDD_1V8 n6 output_x BTHHDLLX1
.ENDS

.SUBCKT tristategate_397 input_x enable output_x VSS VDD_1V8
XU1 n6 VSS VDD_1V8 LOGIC0HDLL
Xoutput_x_tri VSS enable VDD_1V8 n6 output_x BTHHDLLX1
.ENDS

.SUBCKT tristategate_396 input_x enable output_x VSS VDD_1V8
XU1 n6 VSS VDD_1V8 LOGIC0HDLL
Xoutput_x_tri VSS enable VDD_1V8 n6 output_x BTHHDLLX1
.ENDS

.SUBCKT tristategate_395 input_x enable output_x VSS VDD_1V8
XU1 n6 VSS VDD_1V8 LOGIC0HDLL
Xoutput_x_tri VSS enable VDD_1V8 n6 output_x BTHHDLLX1
.ENDS

.SUBCKT tristategate_394 input_x enable output_x VSS VDD_1V8
XU1 n6 VSS VDD_1V8 LOGIC0HDLL
Xoutput_x_tri VSS enable VDD_1V8 n6 output_x BTHHDLLX1
.ENDS

.SUBCKT tristategate_393 input_x enable output_x VSS VDD_1V8
XU1 n6 VSS VDD_1V8 LOGIC0HDLL
Xoutput_x_tri VSS enable VDD_1V8 n6 output_x BTHHDLLX1
.ENDS

.SUBCKT tristategate_392 input_x enable output_x VSS VDD_1V8
XU1 n6 VSS VDD_1V8 LOGIC0HDLL
Xoutput_x_tri VSS enable VDD_1V8 n6 output_x BTHHDLLX1
.ENDS

.SUBCKT tristategate_391 input_x enable output_x VSS VDD_1V8
XU1 n6 VSS VDD_1V8 LOGIC0HDLL
Xoutput_x_tri VSS enable VDD_1V8 n6 output_x BTHHDLLX1
.ENDS

.SUBCKT tristategate_390 input_x enable output_x VSS VDD_1V8
XU1 n6 VSS VDD_1V8 LOGIC0HDLL
Xoutput_x_tri VSS enable VDD_1V8 n6 output_x BTHHDLLX1
.ENDS

.SUBCKT tristategate_389 input_x enable output_x VSS VDD_1V8
XU1 n6 VSS VDD_1V8 LOGIC0HDLL
Xoutput_x_tri VSS enable VDD_1V8 n6 output_x BTHHDLLX1
.ENDS

.SUBCKT tristategate_388 input_x enable output_x VSS VDD_1V8
XU1 n6 VSS VDD_1V8 LOGIC0HDLL
Xoutput_x_tri VSS enable VDD_1V8 n6 output_x BTHHDLLX1
.ENDS

.SUBCKT tristategate_387 input_x enable output_x VSS VDD_1V8
XU1 n6 VSS VDD_1V8 LOGIC0HDLL
Xoutput_x_tri VSS enable VDD_1V8 n6 output_x BTHHDLLX1
.ENDS

.SUBCKT tristategate_386 input_x enable output_x VSS VDD_1V8
XU1 n6 VSS VDD_1V8 LOGIC0HDLL
Xoutput_x_tri VSS enable VDD_1V8 n6 output_x BTHHDLLX1
.ENDS

.SUBCKT tristategate_385 input_x enable output_x VSS VDD_1V8
XU1 n6 VSS VDD_1V8 LOGIC0HDLL
Xoutput_x_tri VSS enable VDD_1V8 n6 output_x BTHHDLLX1
.ENDS

.SUBCKT tristategate_384 input_x enable output_x VSS VDD_1V8
XU1 n6 VSS VDD_1V8 LOGIC0HDLL
Xoutput_x_tri VSS enable VDD_1V8 n6 output_x BTHHDLLX1
.ENDS

.SUBCKT Decodificador_width12 addres_in[3] addres_in[2] addres_in[1] addres_in[0]
+ out[11] out[10] out[9] out[8] out[7] out[6] out[5] out[4] out[3] out[2] out[1]
+ out[0] VSS VDD_1V8
XU24 n11 out[2] VSS VDD_1V8 n9 addres_in[0] NO3HDLLX2
XU21 n13 out[8] VSS VDD_1V8 addres_in[1] addres_in[0] NO3HDLLX2
XU19 n5 out[4] VSS VDD_1V8 addres_in[1] addres_in[0] NO3HDLLX2
XU17 n9 out[10] VSS VDD_1V8 n13 addres_in[0] NO3HDLLX2
XU14 n8 out[3] VSS VDD_1V8 addres_in[3] addres_in[2] NO3HDLLX2
XU12 n11 out[0] VSS VDD_1V8 addres_in[1] addres_in[0] NO3HDLLX2
XU7 n5 out[6] VSS VDD_1V8 n9 addres_in[0] NO3HDLLX2
XU23 VSS out[11] n13 n8 VDD_1V8 NO2HDLLX1
XU5 VSS out[7] n8 n5 VDD_1V8 NO2HDLLX2
XU27 VSS out[9] n13 n12 VDD_1V8 NO2HDLLX1
XU26 VSS out[1] n12 n11 VDD_1V8 NO2HDLLX2
XU10 VSS out[5] n12 n5 VDD_1V8 NO2HDLLX1
XU16 n13 VSS addres_in[2] VDD_1V8 addres_in[3] NA2I1HDLLX0
XU11 VSS VDD_1V8 n11 addres_in[2] addres_in[3] OR2HDLLX0
XU9 VSS addres_in[0] n9 VDD_1V8 n12 NA2HDLLX0
XU6 n9 VSS VDD_1V8 addres_in[1] INHDLLX0
XU4 n5 VSS addres_in[3] VDD_1V8 addres_in[2] NA2I1HDLLX0
XU3 VSS addres_in[0] addres_in[1] VDD_1V8 n8 NA2HDLLX0
.ENDS

.SUBCKT tristategate_250 input_x enable output_x VSS VDD_1V8
Xoutput_x_tri VSS enable VDD_1V8 input_x output_x BTHHDLLX1
.ENDS

.SUBCKT latch_250 clk d q rst VSS VDD_1V8
Xq_reg q VSS rst VDD_1V8 d clk DLHRQHDLLX0
.ENDS

.SUBCKT tristategate_249 input_x enable output_x VSS VDD_1V8
Xoutput_x_tri VSS enable VDD_1V8 input_x output_x BTHHDLLX1
.ENDS

.SUBCKT latch_249 clk d q rst VSS VDD_1V8
Xq_reg q VSS rst VDD_1V8 d clk DLHRQHDLLX0
.ENDS

.SUBCKT tristategate_383 input_x enable output_x VSS VDD_1V8
Xoutput_x_tri VSS enable VDD_1V8 input_x output_x BTHHDLLX1
.ENDS

.SUBCKT tristategate_382 input_x enable output_x VSS VDD_1V8
Xoutput_x_tri VSS enable VDD_1V8 input_x output_x BTHHDLLX1
.ENDS

.SUBCKT tristategate_248 input_x enable output_x VSS VDD_1V8
Xoutput_x_tri VSS enable VDD_1V8 input_x output_x BTHHDLLX1
.ENDS

.SUBCKT latch_248 clk d q rst VSS VDD_1V8
Xq_reg q VSS rst VDD_1V8 d clk DLHRQHDLLX0
.ENDS

.SUBCKT tristategate_381 input_x enable output_x VSS VDD_1V8
Xoutput_x_tri VSS enable VDD_1V8 input_x output_x BTHHDLLX1
.ENDS

.SUBCKT tristategate_380 input_x enable output_x VSS VDD_1V8
XU1 n2 VSS VDD_1V8 LOGIC0HDLL
Xoutput_x_tri VSS enable VDD_1V8 n2 output_x BTHHDLLX1
.ENDS

.SUBCKT tristategate_379 input_x enable output_x VSS VDD_1V8
XU1 n2 VSS VDD_1V8 LOGIC0HDLL
Xoutput_x_tri VSS enable VDD_1V8 n2 output_x BTHHDLLX1
.ENDS

.SUBCKT tristategate_247 input_x enable output_x VSS VDD_1V8
Xoutput_x_tri VSS enable VDD_1V8 input_x output_x BTHHDLLX1
.ENDS

.SUBCKT latch_247 clk d q rst VSS VDD_1V8
Xq_reg q VSS rst VDD_1V8 d clk DLHRQHDLLX0
.ENDS

.SUBCKT tristategate_246 input_x enable output_x VSS VDD_1V8
Xoutput_x_tri VSS enable VDD_1V8 input_x output_x BTHHDLLX1
.ENDS

.SUBCKT latch_246 clk d q rst VSS VDD_1V8
Xq_reg q VSS rst VDD_1V8 d clk DLHRQHDLLX0
.ENDS

.SUBCKT tristategate_245 input_x enable output_x VSS VDD_1V8
Xoutput_x_tri VSS enable VDD_1V8 input_x output_x BTHHDLLX1
.ENDS

.SUBCKT latch_245 clk d q rst VSS VDD_1V8
Xq_reg q VSS rst VDD_1V8 d clk DLHRQHDLLX0
.ENDS

.SUBCKT tristategate_244 input_x enable output_x VSS VDD_1V8
Xoutput_x_tri VSS enable VDD_1V8 input_x output_x BTHHDLLX1
.ENDS

.SUBCKT latch_244 clk d q rst VSS VDD_1V8
Xq_reg q VSS rst VDD_1V8 d clk DLHRQHDLLX0
.ENDS

.SUBCKT tristategate_243 input_x enable output_x VSS VDD_1V8
Xoutput_x_tri VSS enable VDD_1V8 input_x output_x BTHHDLLX1
.ENDS

.SUBCKT latch_243 clk d q rst VSS VDD_1V8
Xq_reg q VSS rst VDD_1V8 d clk DLHRQHDLLX0
.ENDS

.SUBCKT tristategate_242 input_x enable output_x VSS VDD_1V8
Xoutput_x_tri VSS enable VDD_1V8 input_x output_x BTHHDLLX1
.ENDS

.SUBCKT latch_242 clk d q rst VSS VDD_1V8
Xq_reg q VSS rst VDD_1V8 d clk DLHRQHDLLX0
.ENDS

.SUBCKT tristategate_241 input_x enable output_x VSS VDD_1V8
Xoutput_x_tri VSS enable VDD_1V8 input_x output_x BTHHDLLX1
.ENDS

.SUBCKT latch_241 clk d q rst VSS VDD_1V8
Xq_reg q VSS rst VDD_1V8 d clk DLHRQHDLLX0
.ENDS

.SUBCKT tristategate_240 input_x enable output_x VSS VDD_1V8
Xoutput_x_tri VSS enable VDD_1V8 input_x output_x BTHHDLLX1
.ENDS

.SUBCKT latch_240 clk d q rst VSS VDD_1V8
Xq_reg q VSS rst VDD_1V8 d clk DLHRQHDLLX0
.ENDS

.SUBCKT tristategate_378 input_x enable output_x VSS VDD_1V8
XU1 n2 VSS VDD_1V8 LOGIC0HDLL
Xoutput_x_tri VSS enable VDD_1V8 n2 output_x BTHHDLLX2
.ENDS

.SUBCKT tristategate_377 input_x enable output_x VSS VDD_1V8
XU1 n2 VSS VDD_1V8 LOGIC0HDLL
Xoutput_x_tri VSS enable VDD_1V8 n2 output_x BTHHDLLX2
.ENDS

.SUBCKT tristategate_376 input_x enable output_x VSS VDD_1V8
XU1 n2 VSS VDD_1V8 LOGIC0HDLL
Xoutput_x_tri VSS enable VDD_1V8 n2 output_x BTHHDLLX2
.ENDS

.SUBCKT tristategate_375 input_x enable output_x VSS VDD_1V8
XU1 n2 VSS VDD_1V8 LOGIC0HDLL
Xoutput_x_tri VSS enable VDD_1V8 n2 output_x BTHHDLLX2
.ENDS

.SUBCKT tristategate_374 input_x enable output_x VSS VDD_1V8
XU1 n2 VSS VDD_1V8 LOGIC0HDLL
Xoutput_x_tri VSS enable VDD_1V8 n2 output_x BTHHDLLX2
.ENDS

.SUBCKT tristategate_373 input_x enable output_x VSS VDD_1V8
XU1 n2 VSS VDD_1V8 LOGIC0HDLL
Xoutput_x_tri VSS enable VDD_1V8 n2 output_x BTHHDLLX2
.ENDS

.SUBCKT tristategate_372 input_x enable output_x VSS VDD_1V8
XU1 n2 VSS VDD_1V8 LOGIC0HDLL
Xoutput_x_tri VSS enable VDD_1V8 n2 output_x BTHHDLLX2
.ENDS

.SUBCKT tristategate_371 input_x enable output_x VSS VDD_1V8
XU1 n2 VSS VDD_1V8 LOGIC0HDLL
Xoutput_x_tri VSS enable VDD_1V8 n2 output_x BTHHDLLX2
.ENDS

.SUBCKT tristategate_370 input_x enable output_x VSS VDD_1V8
XU1 n2 VSS VDD_1V8 LOGIC0HDLL
Xoutput_x_tri VSS enable VDD_1V8 n2 output_x BTHHDLLX2
.ENDS

.SUBCKT tristategate_369 input_x enable output_x VSS VDD_1V8
XU1 n2 VSS VDD_1V8 LOGIC0HDLL
Xoutput_x_tri VSS enable VDD_1V8 n2 output_x BTHHDLLX2
.ENDS

.SUBCKT tristategate_368 input_x enable output_x VSS VDD_1V8
XU1 n2 VSS VDD_1V8 LOGIC0HDLL
Xoutput_x_tri VSS enable VDD_1V8 n2 output_x BTHHDLLX2
.ENDS

.SUBCKT tristategate_367 input_x enable output_x VSS VDD_1V8
XU1 n2 VSS VDD_1V8 LOGIC0HDLL
Xoutput_x_tri VSS enable VDD_1V8 n2 output_x BTHHDLLX2
.ENDS

.SUBCKT tristategate_366 input_x enable output_x VSS VDD_1V8
XU1 n2 VSS VDD_1V8 LOGIC0HDLL
Xoutput_x_tri VSS enable VDD_1V8 n2 output_x BTHHDLLX2
.ENDS

.SUBCKT tristategate_365 input_x enable output_x VSS VDD_1V8
XU1 n2 VSS VDD_1V8 LOGIC0HDLL
Xoutput_x_tri VSS enable VDD_1V8 n2 output_x BTHHDLLX2
.ENDS

.SUBCKT tristategate_364 input_x enable output_x VSS VDD_1V8
XU1 n2 VSS VDD_1V8 LOGIC0HDLL
Xoutput_x_tri VSS enable VDD_1V8 n2 output_x BTHHDLLX2
.ENDS

.SUBCKT tristategate_363 input_x enable output_x VSS VDD_1V8
XU1 n2 VSS VDD_1V8 LOGIC0HDLL
Xoutput_x_tri VSS enable VDD_1V8 n2 output_x BTHHDLLX2
.ENDS

.SUBCKT tristategate_362 input_x enable output_x VSS VDD_1V8
XU1 n6 VSS VDD_1V8 LOGIC0HDLL
Xoutput_x_tri VSS enable VDD_1V8 n6 output_x BTHHDLLX2
.ENDS

.SUBCKT tristategate_361 input_x enable output_x VSS VDD_1V8
XU1 n6 VSS VDD_1V8 LOGIC0HDLL
Xoutput_x_tri VSS enable VDD_1V8 n6 output_x BTHHDLLX2
.ENDS

.SUBCKT tristategate_239 input_x enable output_x VSS VDD_1V8
Xoutput_x_tri VSS enable VDD_1V8 input_x output_x BTHHDLLX2
.ENDS

.SUBCKT latch_239 clk d q rst VSS VDD_1V8
Xq_reg q VSS rst VDD_1V8 d clk DLHRQHDLLX0
.ENDS

.SUBCKT tristategate_238 input_x enable output_x VSS VDD_1V8
Xoutput_x_tri VSS enable VDD_1V8 input_x output_x BTHHDLLX2
.ENDS

.SUBCKT latch_238 clk d q rst VSS VDD_1V8
Xq_reg q VSS rst VDD_1V8 d clk DLHRQHDLLX0
.ENDS

.SUBCKT tristategate_237 input_x enable output_x VSS VDD_1V8
Xoutput_x_tri VSS enable VDD_1V8 input_x output_x BTHHDLLX2
.ENDS

.SUBCKT latch_237 clk d q rst VSS VDD_1V8
Xq_reg q VSS rst VDD_1V8 d clk DLHRQHDLLX0
.ENDS

.SUBCKT tristategate_236 input_x enable output_x VSS VDD_1V8
Xoutput_x_tri VSS enable VDD_1V8 input_x output_x BTHHDLLX2
.ENDS

.SUBCKT latch_236 clk d q rst VSS VDD_1V8
Xq_reg q VSS rst VDD_1V8 d clk DLHRQHDLLX0
.ENDS

.SUBCKT tristategate_235 input_x enable output_x VSS VDD_1V8
Xoutput_x_tri VSS enable VDD_1V8 input_x output_x BTHHDLLX2
.ENDS

.SUBCKT latch_235 clk d q rst VSS VDD_1V8
Xq_reg q VSS rst VDD_1V8 d clk DLHRQHDLLX0
.ENDS

.SUBCKT tristategate_234 input_x enable output_x VSS VDD_1V8
Xoutput_x_tri VSS enable VDD_1V8 input_x output_x BTHHDLLX2
.ENDS

.SUBCKT latch_234 clk d q rst VSS VDD_1V8
Xq_reg q VSS rst VDD_1V8 d clk DLHRQHDLLX0
.ENDS

.SUBCKT tristategate_233 input_x enable output_x VSS VDD_1V8
Xoutput_x_tri VSS enable VDD_1V8 input_x output_x BTHHDLLX2
.ENDS

.SUBCKT latch_233 clk d q rst VSS VDD_1V8
Xq_reg q VSS rst VDD_1V8 d clk DLHRQHDLLX0
.ENDS

.SUBCKT tristategate_232 input_x enable output_x VSS VDD_1V8
Xoutput_x_tri VSS enable VDD_1V8 input_x output_x BTHHDLLX2
.ENDS

.SUBCKT latch_232 clk d q rst VSS VDD_1V8
Xq_reg q VSS rst VDD_1V8 d clk DLHRQHDLLX0
.ENDS

.SUBCKT tristategate_231 input_x enable output_x VSS VDD_1V8
Xoutput_x_tri VSS enable VDD_1V8 input_x output_x BTHHDLLX2
.ENDS

.SUBCKT latch_231 clk d q rst VSS VDD_1V8
Xq_reg q VSS rst VDD_1V8 d clk DLHRQHDLLX0
.ENDS

.SUBCKT tristategate_230 input_x enable output_x VSS VDD_1V8
Xoutput_x_tri VSS enable VDD_1V8 input_x output_x BTHHDLLX1
.ENDS

.SUBCKT latch_230 clk d q rst VSS VDD_1V8
Xq_reg q VSS rst VDD_1V8 d clk DLHRQHDLLX0
.ENDS

.SUBCKT tristategate_229 input_x enable output_x VSS VDD_1V8
Xoutput_x_tri VSS enable VDD_1V8 input_x output_x BTHHDLLX1
.ENDS

.SUBCKT latch_229 clk d q rst VSS VDD_1V8
Xq_reg q VSS rst VDD_1V8 d clk DLHRQHDLLX0
.ENDS

.SUBCKT tristategate_228 input_x enable output_x VSS VDD_1V8
Xoutput_x_tri VSS enable VDD_1V8 input_x output_x BTHHDLLX1
.ENDS

.SUBCKT latch_228 clk d q rst VSS VDD_1V8
Xq_reg q VSS rst VDD_1V8 d clk DLHRQHDLLX0
.ENDS

.SUBCKT tristategate_227 input_x enable output_x VSS VDD_1V8
Xoutput_x_tri VSS enable VDD_1V8 input_x output_x BTHHDLLX1
.ENDS

.SUBCKT latch_227 clk d q rst VSS VDD_1V8
Xq_reg q VSS rst VDD_1V8 d clk DLHRQHDLLX0
.ENDS

.SUBCKT tristategate_226 input_x enable output_x VSS VDD_1V8
Xoutput_x_tri VSS enable VDD_1V8 input_x output_x BTHHDLLX1
.ENDS

.SUBCKT latch_226 clk d q rst VSS VDD_1V8
Xq_reg q VSS rst VDD_1V8 d clk DLHRQHDLLX0
.ENDS

.SUBCKT tristategate_225 input_x enable output_x VSS VDD_1V8
Xoutput_x_tri VSS enable VDD_1V8 input_x output_x BTHHDLLX2
.ENDS

.SUBCKT latch_225 clk d q rst VSS VDD_1V8
Xq_reg q VSS rst VDD_1V8 d clk DLHRQHDLLX0
.ENDS

.SUBCKT tristategate_224 input_x enable output_x VSS VDD_1V8
Xoutput_x_tri VSS enable VDD_1V8 input_x output_x BTHHDLLX2
.ENDS

.SUBCKT latch_224 clk d q rst VSS VDD_1V8
Xq_reg q VSS rst VDD_1V8 d clk DLHRQHDLLX0
.ENDS

.SUBCKT tristategate_223 input_x enable output_x VSS VDD_1V8
Xoutput_x_tri VSS enable VDD_1V8 input_x output_x BTHHDLLX2
.ENDS

.SUBCKT latch_223 clk d q rst VSS VDD_1V8
Xq_reg q VSS rst VDD_1V8 d clk DLHRQHDLLX0
.ENDS

.SUBCKT tristategate_222 input_x enable output_x VSS VDD_1V8
Xoutput_x_tri VSS enable VDD_1V8 input_x output_x BTHHDLLX2
.ENDS

.SUBCKT latch_222 clk d q rst VSS VDD_1V8
Xq_reg q VSS rst VDD_1V8 d clk DLHRQHDLLX0
.ENDS

.SUBCKT tristategate_221 input_x enable output_x VSS VDD_1V8
Xoutput_x_tri VSS enable VDD_1V8 input_x output_x BTHHDLLX2
.ENDS

.SUBCKT latch_221 clk d q rst VSS VDD_1V8
Xq_reg q VSS rst VDD_1V8 d clk DLHRQHDLLX0
.ENDS

.SUBCKT tristategate_220 input_x enable output_x VSS VDD_1V8
Xoutput_x_tri VSS enable VDD_1V8 input_x output_x BTHHDLLX2
.ENDS

.SUBCKT latch_220 clk d q rst VSS VDD_1V8
Xq_reg q VSS rst VDD_1V8 d clk DLHRQHDLLX0
.ENDS

.SUBCKT tristategate_219 input_x enable output_x VSS VDD_1V8
Xoutput_x_tri VSS enable VDD_1V8 input_x output_x BTHHDLLX2
.ENDS

.SUBCKT latch_219 clk d q rst VSS VDD_1V8
Xq_reg q VSS rst VDD_1V8 d clk DLHRQHDLLX0
.ENDS

.SUBCKT tristategate_218 input_x enable output_x VSS VDD_1V8
Xoutput_x_tri VSS enable VDD_1V8 input_x output_x BTHHDLLX2
.ENDS

.SUBCKT latch_218 clk d q rst VSS VDD_1V8
Xq_reg q VSS rst VDD_1V8 d clk DLHRQHDLLX0
.ENDS

.SUBCKT tristategate_217 input_x enable output_x VSS VDD_1V8
Xoutput_x_tri VSS enable VDD_1V8 input_x output_x BTHHDLLX2
.ENDS

.SUBCKT latch_217 clk d q rst VSS VDD_1V8
Xq_reg q VSS rst VDD_1V8 d clk DLHRQHDLLX0
.ENDS

.SUBCKT tristategate_216 input_x enable output_x VSS VDD_1V8
Xoutput_x_tri VSS enable VDD_1V8 input_x output_x BTHHDLLX2
.ENDS

.SUBCKT latch_216 clk d q rst VSS VDD_1V8
Xq_reg q VSS rst VDD_1V8 d clk DLHRQHDLLX0
.ENDS

.SUBCKT tristategate_215 input_x enable output_x VSS VDD_1V8
Xoutput_x_tri VSS enable VDD_1V8 input_x output_x BTHHDLLX2
.ENDS

.SUBCKT latch_215 clk d q rst VSS VDD_1V8
Xq_reg q VSS rst VDD_1V8 d clk DLHRQHDLLX0
.ENDS

.SUBCKT tristategate_214 input_x enable output_x VSS VDD_1V8
Xoutput_x_tri VSS enable VDD_1V8 input_x output_x BTHHDLLX2
.ENDS

.SUBCKT latch_214 clk d q rst VSS VDD_1V8
Xq_reg q VSS rst VDD_1V8 d clk DLHRQHDLLX0
.ENDS

.SUBCKT tristategate_213 input_x enable output_x VSS VDD_1V8
Xoutput_x_tri VSS enable VDD_1V8 input_x output_x BTHHDLLX2
.ENDS

.SUBCKT latch_213 clk d q rst VSS VDD_1V8
Xq_reg q VSS rst VDD_1V8 d clk DLHRQHDLLX0
.ENDS

.SUBCKT tristategate_212 input_x enable output_x VSS VDD_1V8
Xoutput_x_tri VSS enable VDD_1V8 input_x output_x BTHHDLLX2
.ENDS

.SUBCKT latch_212 clk d q rst VSS VDD_1V8
Xq_reg q VSS rst VDD_1V8 d clk DLHRQHDLLX0
.ENDS

.SUBCKT tristategate_211 input_x enable output_x VSS VDD_1V8
Xoutput_x_tri VSS enable VDD_1V8 input_x output_x BTHHDLLX2
.ENDS

.SUBCKT latch_211 clk d q rst VSS VDD_1V8
Xq_reg q VSS rst VDD_1V8 d clk DLHRQHDLLX0
.ENDS

.SUBCKT tristategate_210 input_x enable output_x VSS VDD_1V8
Xoutput_x_tri VSS enable VDD_1V8 input_x output_x BTHHDLLX2
.ENDS

.SUBCKT latch_210 clk d q rst VSS VDD_1V8
Xq_reg q VSS rst VDD_1V8 d clk DLHRQHDLLX0
.ENDS

.SUBCKT tristategate_209 input_x enable output_x VSS VDD_1V8
Xoutput_x_tri VSS enable VDD_1V8 input_x output_x BTHHDLLX1
.ENDS

.SUBCKT latch_209 clk d q rst VSS VDD_1V8
Xq_reg q VSS rst VDD_1V8 d clk DLHRQHDLLX0
.ENDS

.SUBCKT tristategate_208 input_x enable output_x VSS VDD_1V8
Xoutput_x_tri VSS enable VDD_1V8 input_x output_x BTHHDLLX1
.ENDS

.SUBCKT latch_208 clk d q rst VSS VDD_1V8
Xq_reg q VSS rst VDD_1V8 d clk DLHRQHDLLX0
.ENDS

.SUBCKT tristategate_207 input_x enable output_x VSS VDD_1V8
Xoutput_x_tri VSS enable VDD_1V8 input_x output_x BTHHDLLX1
.ENDS

.SUBCKT latch_207 clk d q rst VSS VDD_1V8
Xq_reg q VSS rst VDD_1V8 d clk DLHRQHDLLX0
.ENDS

.SUBCKT tristategate_206 input_x enable output_x VSS VDD_1V8
Xoutput_x_tri VSS enable VDD_1V8 input_x output_x BTHHDLLX1
.ENDS

.SUBCKT latch_206 clk d q rst VSS VDD_1V8
Xq_reg q VSS rst VDD_1V8 d clk DLHRQHDLLX0
.ENDS

.SUBCKT tristategate_205 input_x enable output_x VSS VDD_1V8
Xoutput_x_tri VSS enable VDD_1V8 input_x output_x BTHHDLLX1
.ENDS

.SUBCKT latch_205 clk d q rst VSS VDD_1V8
Xq_reg q VSS rst VDD_1V8 d clk DLHRQHDLLX0
.ENDS

.SUBCKT tristategate_204 input_x enable output_x VSS VDD_1V8
Xoutput_x_tri VSS enable VDD_1V8 input_x output_x BTHHDLLX1
.ENDS

.SUBCKT latch_204 clk d q rst VSS VDD_1V8
Xq_reg q VSS rst VDD_1V8 d clk DLHRQHDLLX0
.ENDS

.SUBCKT tristategate_203 input_x enable output_x VSS VDD_1V8
Xoutput_x_tri VSS enable VDD_1V8 input_x output_x BTHHDLLX1
.ENDS

.SUBCKT latch_203 clk d q rst VSS VDD_1V8
Xq_reg q VSS rst VDD_1V8 d clk DLHRQHDLLX0
.ENDS

.SUBCKT tristategate_202 input_x enable output_x VSS VDD_1V8
Xoutput_x_tri VSS enable VDD_1V8 input_x output_x BTHHDLLX1
.ENDS

.SUBCKT latch_202 clk d q rst VSS VDD_1V8
Xq_reg q VSS rst VDD_1V8 d clk DLHRQHDLLX0
.ENDS

.SUBCKT tristategate_201 input_x enable output_x VSS VDD_1V8
Xoutput_x_tri VSS enable VDD_1V8 input_x output_x BTHHDLLX1
.ENDS

.SUBCKT latch_201 clk d q rst VSS VDD_1V8
Xq_reg q VSS rst VDD_1V8 d clk DLHRQHDLLX0
.ENDS

.SUBCKT tristategate_200 input_x enable output_x VSS VDD_1V8
Xoutput_x_tri VSS enable VDD_1V8 input_x output_x BTHHDLLX1
.ENDS

.SUBCKT latch_200 clk d q rst VSS VDD_1V8
Xq_reg q VSS rst VDD_1V8 d clk DLHRQHDLLX0
.ENDS

.SUBCKT tristategate_199 input_x enable output_x VSS VDD_1V8
Xoutput_x_tri VSS enable VDD_1V8 input_x output_x BTHHDLLX1
.ENDS

.SUBCKT latch_199 clk d q rst VSS VDD_1V8
Xq_reg q VSS rst VDD_1V8 d clk DLHRQHDLLX0
.ENDS

.SUBCKT tristategate_198 input_x enable output_x VSS VDD_1V8
Xoutput_x_tri VSS enable VDD_1V8 input_x output_x BTHHDLLX1
.ENDS

.SUBCKT latch_198 clk d q rst VSS VDD_1V8
Xq_reg q VSS rst VDD_1V8 d clk DLHRQHDLLX0
.ENDS

.SUBCKT tristategate_197 input_x enable output_x VSS VDD_1V8
Xoutput_x_tri VSS enable VDD_1V8 input_x output_x BTHHDLLX1
.ENDS

.SUBCKT latch_197 clk d q rst VSS VDD_1V8
Xq_reg q VSS rst VDD_1V8 d clk DLHRQHDLLX0
.ENDS

.SUBCKT tristategate_196 input_x enable output_x VSS VDD_1V8
Xoutput_x_tri VSS enable VDD_1V8 input_x output_x BTHHDLLX1
.ENDS

.SUBCKT latch_196 clk d q rst VSS VDD_1V8
Xq_reg q VSS rst VDD_1V8 d clk DLHRQHDLLX0
.ENDS

.SUBCKT tristategate_195 input_x enable output_x VSS VDD_1V8
Xoutput_x_tri VSS enable VDD_1V8 input_x output_x BTHHDLLX1
.ENDS

.SUBCKT latch_195 clk d q rst VSS VDD_1V8
Xq_reg q VSS rst VDD_1V8 d clk DLHRQHDLLX0
.ENDS

.SUBCKT tristategate_194 input_x enable output_x VSS VDD_1V8
Xoutput_x_tri VSS enable VDD_1V8 input_x output_x BTHHDLLX1
.ENDS

.SUBCKT latch_194 clk d q rst VSS VDD_1V8
Xq_reg q VSS rst VDD_1V8 d clk DLHRQHDLLX0
.ENDS

.SUBCKT tristategate_193 input_x enable output_x VSS VDD_1V8
Xoutput_x_tri VSS enable VDD_1V8 input_x output_x BTHHDLLX2
.ENDS

.SUBCKT latch_193 clk d q rst VSS VDD_1V8
Xq_reg q VSS rst VDD_1V8 d clk DLHRQHDLLX0
.ENDS

.SUBCKT tristategate_192 input_x enable output_x VSS VDD_1V8
Xoutput_x_tri VSS enable VDD_1V8 input_x output_x BTHHDLLX2
.ENDS

.SUBCKT latch_192 clk d q rst VSS VDD_1V8
Xq_reg q VSS rst VDD_1V8 d clk DLHRQHDLLX0
.ENDS

.SUBCKT tristategate_191 input_x enable output_x VSS VDD_1V8
Xoutput_x_tri VSS enable VDD_1V8 input_x output_x BTHHDLLX2
.ENDS

.SUBCKT latch_191 clk d q rst VSS VDD_1V8
Xq_reg q VSS rst VDD_1V8 d clk DLHRQHDLLX0
.ENDS

.SUBCKT tristategate_190 input_x enable output_x VSS VDD_1V8
Xoutput_x_tri VSS enable VDD_1V8 input_x output_x BTHHDLLX1
.ENDS

.SUBCKT latch_190 clk d q rst VSS VDD_1V8
Xq_reg q VSS rst VDD_1V8 d clk DLHRQHDLLX0
.ENDS

.SUBCKT tristategate_189 input_x enable output_x VSS VDD_1V8
Xoutput_x_tri VSS enable VDD_1V8 input_x output_x BTHHDLLX2
.ENDS

.SUBCKT latch_189 clk d q rst VSS VDD_1V8
Xq_reg q VSS rst VDD_1V8 d clk DLHRQHDLLX0
.ENDS

.SUBCKT tristategate_188 input_x enable output_x VSS VDD_1V8
Xoutput_x_tri VSS enable VDD_1V8 input_x output_x BTHHDLLX2
.ENDS

.SUBCKT latch_188 clk d q rst VSS VDD_1V8
Xq_reg q VSS rst VDD_1V8 d clk DLHRQHDLLX0
.ENDS

.SUBCKT tristategate_187 input_x enable output_x VSS VDD_1V8
Xoutput_x_tri VSS enable VDD_1V8 input_x output_x BTHHDLLX2
.ENDS

.SUBCKT latch_187 clk d q rst VSS VDD_1V8
Xq_reg q VSS rst VDD_1V8 d clk DLHRQHDLLX0
.ENDS

.SUBCKT tristategate_186 input_x enable output_x VSS VDD_1V8
Xoutput_x_tri VSS enable VDD_1V8 input_x output_x BTHHDLLX2
.ENDS

.SUBCKT latch_186 clk d q rst VSS VDD_1V8
Xq_reg q VSS rst VDD_1V8 d clk DLHRQHDLLX0
.ENDS

.SUBCKT tristategate_185 input_x enable output_x VSS VDD_1V8
Xoutput_x_tri VSS enable VDD_1V8 input_x output_x BTHHDLLX2
.ENDS

.SUBCKT latch_185 clk d q rst VSS VDD_1V8
Xq_reg q VSS rst VDD_1V8 d clk DLHRQHDLLX0
.ENDS

.SUBCKT tristategate_184 input_x enable output_x VSS VDD_1V8
Xoutput_x_tri VSS enable VDD_1V8 input_x output_x BTHHDLLX2
.ENDS

.SUBCKT latch_184 clk d q rst VSS VDD_1V8
Xq_reg q VSS rst VDD_1V8 d clk DLHRQHDLLX0
.ENDS

.SUBCKT tristategate_183 input_x enable output_x VSS VDD_1V8
Xoutput_x_tri VSS enable VDD_1V8 input_x output_x BTHHDLLX2
.ENDS

.SUBCKT latch_183 clk d q rst VSS VDD_1V8
Xq_reg q VSS rst VDD_1V8 d clk DLHRQHDLLX0
.ENDS

.SUBCKT tristategate_182 input_x enable output_x VSS VDD_1V8
Xoutput_x_tri VSS enable VDD_1V8 input_x output_x BTHHDLLX2
.ENDS

.SUBCKT latch_182 clk d q rst VSS VDD_1V8
Xq_reg q VSS rst VDD_1V8 d clk DLHRQHDLLX0
.ENDS

.SUBCKT tristategate_181 input_x enable output_x VSS VDD_1V8
Xoutput_x_tri VSS enable VDD_1V8 input_x output_x BTHHDLLX2
.ENDS

.SUBCKT latch_181 clk d q rst VSS VDD_1V8
Xq_reg q VSS rst VDD_1V8 d clk DLHRQHDLLX0
.ENDS

.SUBCKT tristategate_180 input_x enable output_x VSS VDD_1V8
Xoutput_x_tri VSS enable VDD_1V8 input_x output_x BTHHDLLX2
.ENDS

.SUBCKT latch_180 clk d q rst VSS VDD_1V8
Xq_reg q VSS rst VDD_1V8 d clk DLHRQHDLLX0
.ENDS

.SUBCKT tristategate_179 input_x enable output_x VSS VDD_1V8
Xoutput_x_tri VSS enable VDD_1V8 input_x output_x BTHHDLLX2
.ENDS

.SUBCKT latch_179 clk d q rst VSS VDD_1V8
Xq_reg q VSS rst VDD_1V8 d clk DLHRQHDLLX0
.ENDS

.SUBCKT tristategate_178 input_x enable output_x VSS VDD_1V8
Xoutput_x_tri VSS enable VDD_1V8 input_x output_x BTHHDLLX1
.ENDS

.SUBCKT latch_178 clk d q rst VSS VDD_1V8
Xq_reg q VSS rst VDD_1V8 d clk DLHRQHDLLX0
.ENDS

.SUBCKT tristategate_177 input_x enable output_x VSS VDD_1V8
Xoutput_x_tri VSS enable VDD_1V8 input_x output_x BTHHDLLX1
.ENDS

.SUBCKT latch_177 clk d q rst VSS VDD_1V8
Xq_reg q VSS rst VDD_1V8 d clk DLHRQHDLLX0
.ENDS

.SUBCKT tristategate_176 input_x enable output_x VSS VDD_1V8
Xoutput_x_tri VSS enable VDD_1V8 input_x output_x BTHHDLLX1
.ENDS

.SUBCKT latch_176 clk d q rst VSS VDD_1V8
Xq_reg q VSS rst VDD_1V8 d clk DLHRQHDLLX0
.ENDS

.SUBCKT tristategate_175 input_x enable output_x VSS VDD_1V8
Xoutput_x_tri VSS enable VDD_1V8 input_x output_x BTHHDLLX1
.ENDS

.SUBCKT latch_175 clk d q rst VSS VDD_1V8
Xq_reg q VSS rst VDD_1V8 d clk DLHRQHDLLX0
.ENDS

.SUBCKT tristategate_174 input_x enable output_x VSS VDD_1V8
Xoutput_x_tri VSS enable VDD_1V8 input_x output_x BTHHDLLX1
.ENDS

.SUBCKT latch_174 clk d q rst VSS VDD_1V8
Xq_reg q VSS rst VDD_1V8 d clk DLHRQHDLLX0
.ENDS

.SUBCKT tristategate_173 input_x enable output_x VSS VDD_1V8
Xoutput_x_tri VSS enable VDD_1V8 input_x output_x BTHHDLLX1
.ENDS

.SUBCKT latch_173 clk d q rst VSS VDD_1V8
Xq_reg q VSS rst VDD_1V8 d clk DLHRQHDLLX0
.ENDS

.SUBCKT tristategate_172 input_x enable output_x VSS VDD_1V8
Xoutput_x_tri VSS enable VDD_1V8 input_x output_x BTHHDLLX1
.ENDS

.SUBCKT latch_172 clk d q rst VSS VDD_1V8
Xq_reg q VSS rst VDD_1V8 d clk DLHRQHDLLX0
.ENDS

.SUBCKT tristategate_171 input_x enable output_x VSS VDD_1V8
Xoutput_x_tri VSS enable VDD_1V8 input_x output_x BTHHDLLX1
.ENDS

.SUBCKT latch_171 clk d q rst VSS VDD_1V8
Xq_reg q VSS rst VDD_1V8 d clk DLHRQHDLLX0
.ENDS

.SUBCKT tristategate_170 input_x enable output_x VSS VDD_1V8
Xoutput_x_tri VSS enable VDD_1V8 input_x output_x BTHHDLLX1
.ENDS

.SUBCKT latch_170 clk d q rst VSS VDD_1V8
Xq_reg q VSS rst VDD_1V8 d clk DLHRQHDLLX0
.ENDS

.SUBCKT tristategate_169 input_x enable output_x VSS VDD_1V8
Xoutput_x_tri VSS enable VDD_1V8 input_x output_x BTHHDLLX1
.ENDS

.SUBCKT latch_169 clk d q rst VSS VDD_1V8
Xq_reg q VSS rst VDD_1V8 d clk DLHRQHDLLX0
.ENDS

.SUBCKT tristategate_168 input_x enable output_x VSS VDD_1V8
Xoutput_x_tri VSS enable VDD_1V8 input_x output_x BTHHDLLX1
.ENDS

.SUBCKT latch_168 clk d q rst VSS VDD_1V8
Xq_reg q VSS rst VDD_1V8 d clk DLHRQHDLLX0
.ENDS

.SUBCKT tristategate_167 input_x enable output_x VSS VDD_1V8
Xoutput_x_tri VSS enable VDD_1V8 input_x output_x BTHHDLLX1
.ENDS

.SUBCKT latch_167 clk d q rst VSS VDD_1V8
Xq_reg q VSS rst VDD_1V8 d clk DLHRQHDLLX0
.ENDS

.SUBCKT tristategate_166 input_x enable output_x VSS VDD_1V8
Xoutput_x_tri VSS enable VDD_1V8 input_x output_x BTHHDLLX1
.ENDS

.SUBCKT latch_166 clk d q rst VSS VDD_1V8
Xq_reg q VSS rst VDD_1V8 d clk DLHRQHDLLX0
.ENDS

.SUBCKT tristategate_165 input_x enable output_x VSS VDD_1V8
Xoutput_x_tri VSS enable VDD_1V8 input_x output_x BTHHDLLX1
.ENDS

.SUBCKT latch_165 clk d q rst VSS VDD_1V8
Xq_reg q VSS rst VDD_1V8 d clk DLHRQHDLLX0
.ENDS

.SUBCKT tristategate_164 input_x enable output_x VSS VDD_1V8
Xoutput_x_tri VSS enable VDD_1V8 input_x output_x BTHHDLLX1
.ENDS

.SUBCKT latch_164 clk d q rst VSS VDD_1V8
Xq_reg q VSS rst VDD_1V8 d clk DLHRQHDLLX0
.ENDS

.SUBCKT tristategate_163 input_x enable output_x VSS VDD_1V8
Xoutput_x_tri VSS enable VDD_1V8 input_x output_x BTHHDLLX1
.ENDS

.SUBCKT latch_163 clk d q rst VSS VDD_1V8
Xq_reg q VSS rst VDD_1V8 d clk DLHRQHDLLX0
.ENDS

.SUBCKT tristategate_162 input_x enable output_x VSS VDD_1V8
Xoutput_x_tri VSS enable VDD_1V8 input_x output_x BTHHDLLX1
.ENDS

.SUBCKT latch_162 clk d q rst VSS VDD_1V8
Xq_reg q VSS rst VDD_1V8 d clk DLHRQHDLLX0
.ENDS

.SUBCKT tristategate_161 input_x enable output_x VSS VDD_1V8
Xoutput_x_tri VSS enable VDD_1V8 input_x output_x BTHHDLLX2
.ENDS

.SUBCKT latch_161 clk d q rst VSS VDD_1V8
Xq_reg q VSS rst VDD_1V8 d clk DLHRQHDLLX0
.ENDS

.SUBCKT tristategate_160 input_x enable output_x VSS VDD_1V8
Xoutput_x_tri VSS enable VDD_1V8 input_x output_x BTHHDLLX2
.ENDS

.SUBCKT latch_160 clk d q rst VSS VDD_1V8
Xq_reg q VSS rst VDD_1V8 d clk DLHRQHDLLX0
.ENDS

.SUBCKT tristategate_159 input_x enable output_x VSS VDD_1V8
Xoutput_x_tri VSS enable VDD_1V8 input_x output_x BTHHDLLX2
.ENDS

.SUBCKT latch_159 clk d q rst VSS VDD_1V8
Xq_reg q VSS rst VDD_1V8 d clk DLHRQHDLLX0
.ENDS

.SUBCKT tristategate_158 input_x enable output_x VSS VDD_1V8
Xoutput_x_tri VSS enable VDD_1V8 input_x output_x BTHHDLLX1
.ENDS

.SUBCKT latch_158 clk d q rst VSS VDD_1V8
Xq_reg q VSS rst VDD_1V8 d clk DLHRQHDLLX0
.ENDS

.SUBCKT tristategate_157 input_x enable output_x VSS VDD_1V8
Xoutput_x_tri VSS enable VDD_1V8 input_x output_x BTHHDLLX2
.ENDS

.SUBCKT latch_157 clk d q rst VSS VDD_1V8
Xq_reg q VSS rst VDD_1V8 d clk DLHRQHDLLX0
.ENDS

.SUBCKT tristategate_156 input_x enable output_x VSS VDD_1V8
Xoutput_x_tri VSS enable VDD_1V8 input_x output_x BTHHDLLX2
.ENDS

.SUBCKT latch_156 clk d q rst VSS VDD_1V8
Xq_reg q VSS rst VDD_1V8 d clk DLHRQHDLLX0
.ENDS

.SUBCKT tristategate_155 input_x enable output_x VSS VDD_1V8
Xoutput_x_tri VSS enable VDD_1V8 input_x output_x BTHHDLLX2
.ENDS

.SUBCKT latch_155 clk d q rst VSS VDD_1V8
Xq_reg q VSS rst VDD_1V8 d clk DLHRQHDLLX0
.ENDS

.SUBCKT tristategate_154 input_x enable output_x VSS VDD_1V8
Xoutput_x_tri VSS enable VDD_1V8 input_x output_x BTHHDLLX2
.ENDS

.SUBCKT latch_154 clk d q rst VSS VDD_1V8
Xq_reg q VSS rst VDD_1V8 d clk DLHRQHDLLX0
.ENDS

.SUBCKT tristategate_153 input_x enable output_x VSS VDD_1V8
Xoutput_x_tri VSS enable VDD_1V8 input_x output_x BTHHDLLX2
.ENDS

.SUBCKT latch_153 clk d q rst VSS VDD_1V8
Xq_reg q VSS rst VDD_1V8 d clk DLHRQHDLLX0
.ENDS

.SUBCKT tristategate_152 input_x enable output_x VSS VDD_1V8
Xoutput_x_tri VSS enable VDD_1V8 input_x output_x BTHHDLLX2
.ENDS

.SUBCKT latch_152 clk d q rst VSS VDD_1V8
Xq_reg q VSS rst VDD_1V8 d clk DLHRQHDLLX0
.ENDS

.SUBCKT tristategate_151 input_x enable output_x VSS VDD_1V8
Xoutput_x_tri VSS enable VDD_1V8 input_x output_x BTHHDLLX2
.ENDS

.SUBCKT latch_151 clk d q rst VSS VDD_1V8
Xq_reg q VSS rst VDD_1V8 d clk DLHRQHDLLX0
.ENDS

.SUBCKT tristategate_150 input_x enable output_x VSS VDD_1V8
Xoutput_x_tri VSS enable VDD_1V8 input_x output_x BTHHDLLX2
.ENDS

.SUBCKT latch_150 clk d q rst VSS VDD_1V8
Xq_reg q VSS rst VDD_1V8 d clk DLHRQHDLLX0
.ENDS

.SUBCKT tristategate_149 input_x enable output_x VSS VDD_1V8
Xoutput_x_tri VSS enable VDD_1V8 input_x output_x BTHHDLLX2
.ENDS

.SUBCKT latch_149 clk d q rst VSS VDD_1V8
Xq_reg q VSS rst VDD_1V8 d clk DLHRQHDLLX0
.ENDS

.SUBCKT tristategate_148 input_x enable output_x VSS VDD_1V8
Xoutput_x_tri VSS enable VDD_1V8 input_x output_x BTHHDLLX2
.ENDS

.SUBCKT latch_148 clk d q rst VSS VDD_1V8
Xq_reg q VSS rst VDD_1V8 d clk DLHRQHDLLX0
.ENDS

.SUBCKT tristategate_147 input_x enable output_x VSS VDD_1V8
Xoutput_x_tri VSS enable VDD_1V8 input_x output_x BTHHDLLX2
.ENDS

.SUBCKT latch_147 clk d q rst VSS VDD_1V8
Xq_reg q VSS rst VDD_1V8 d clk DLHRQHDLLX0
.ENDS

.SUBCKT tristategate_146 input_x enable output_x VSS VDD_1V8
Xoutput_x_tri VSS enable VDD_1V8 input_x output_x BTHHDLLX1
.ENDS

.SUBCKT latch_146 clk d q rst VSS VDD_1V8
Xq_reg q VSS rst VDD_1V8 d clk DLHRQHDLLX0
.ENDS

.SUBCKT tristategate_145 input_x enable output_x VSS VDD_1V8
Xoutput_x_tri VSS enable VDD_1V8 input_x output_x BTHHDLLX1
.ENDS

.SUBCKT latch_145 clk d q rst VSS VDD_1V8
Xq_reg q VSS rst VDD_1V8 d clk DLHRQHDLLX0
.ENDS

.SUBCKT tristategate_144 input_x enable output_x VSS VDD_1V8
Xoutput_x_tri VSS enable VDD_1V8 input_x output_x BTHHDLLX1
.ENDS

.SUBCKT latch_144 clk d q rst VSS VDD_1V8
Xq_reg q VSS rst VDD_1V8 d clk DLHRQHDLLX0
.ENDS

.SUBCKT tristategate_143 input_x enable output_x VSS VDD_1V8
Xoutput_x_tri VSS enable VDD_1V8 input_x output_x BTHHDLLX1
.ENDS

.SUBCKT latch_143 clk d q rst VSS VDD_1V8
Xq_reg q VSS rst VDD_1V8 d clk DLHRQHDLLX0
.ENDS

.SUBCKT tristategate_142 input_x enable output_x VSS VDD_1V8
Xoutput_x_tri VSS enable VDD_1V8 input_x output_x BTHHDLLX1
.ENDS

.SUBCKT latch_142 clk d q rst VSS VDD_1V8
Xq_reg q VSS rst VDD_1V8 d clk DLHRQHDLLX0
.ENDS

.SUBCKT tristategate_141 input_x enable output_x VSS VDD_1V8
Xoutput_x_tri VSS enable VDD_1V8 input_x output_x BTHHDLLX1
.ENDS

.SUBCKT latch_141 clk d q rst VSS VDD_1V8
Xq_reg q VSS rst VDD_1V8 d clk DLHRQHDLLX0
.ENDS

.SUBCKT tristategate_140 input_x enable output_x VSS VDD_1V8
Xoutput_x_tri VSS enable VDD_1V8 input_x output_x BTHHDLLX1
.ENDS

.SUBCKT latch_140 clk d q rst VSS VDD_1V8
Xq_reg q VSS rst VDD_1V8 d clk DLHRQHDLLX0
.ENDS

.SUBCKT tristategate_139 input_x enable output_x VSS VDD_1V8
Xoutput_x_tri VSS enable VDD_1V8 input_x output_x BTHHDLLX2
.ENDS

.SUBCKT latch_139 clk d q rst VSS VDD_1V8
Xq_reg q VSS rst VDD_1V8 d clk DLHRQHDLLX0
.ENDS

.SUBCKT tristategate_138 input_x enable output_x VSS VDD_1V8
Xoutput_x_tri VSS enable VDD_1V8 input_x output_x BTHHDLLX2
.ENDS

.SUBCKT latch_138 clk d q rst VSS VDD_1V8
Xq_reg q VSS rst VDD_1V8 d clk DLHRQHDLLX0
.ENDS

.SUBCKT tristategate_360 input_x enable output_x VSS VDD_1V8
XU1 n2 VSS VDD_1V8 LOGIC0HDLL
Xoutput_x_tri VSS enable VDD_1V8 n2 output_x BTHHDLLX1
.ENDS

.SUBCKT tristategate_359 input_x enable output_x VSS VDD_1V8
XU1 n2 VSS VDD_1V8 LOGIC0HDLL
Xoutput_x_tri VSS enable VDD_1V8 n2 output_x BTHHDLLX1
.ENDS

.SUBCKT tristategate_358 input_x enable output_x VSS VDD_1V8
XU1 n2 VSS VDD_1V8 LOGIC0HDLL
Xoutput_x_tri VSS enable VDD_1V8 n2 output_x BTHHDLLX1
.ENDS

.SUBCKT tristategate_357 input_x enable output_x VSS VDD_1V8
XU1 n2 VSS VDD_1V8 LOGIC0HDLL
Xoutput_x_tri VSS enable VDD_1V8 n2 output_x BTHHDLLX1
.ENDS

.SUBCKT tristategate_356 input_x enable output_x VSS VDD_1V8
XU1 n2 VSS VDD_1V8 LOGIC0HDLL
Xoutput_x_tri VSS enable VDD_1V8 n2 output_x BTHHDLLX1
.ENDS

.SUBCKT tristategate_355 input_x enable output_x VSS VDD_1V8
XU1 n2 VSS VDD_1V8 LOGIC0HDLL
Xoutput_x_tri VSS enable VDD_1V8 n2 output_x BTHHDLLX1
.ENDS

.SUBCKT tristategate_354 input_x enable output_x VSS VDD_1V8
XU1 n2 VSS VDD_1V8 LOGIC0HDLL
Xoutput_x_tri VSS enable VDD_1V8 n2 output_x BTHHDLLX1
.ENDS

.SUBCKT tristategate_353 input_x enable output_x VSS VDD_1V8
XU1 n2 VSS VDD_1V8 LOGIC0HDLL
Xoutput_x_tri VSS enable VDD_1V8 n2 output_x BTHHDLLX1
.ENDS

.SUBCKT tristategate_352 input_x enable output_x VSS VDD_1V8
XU1 n2 VSS VDD_1V8 LOGIC0HDLL
Xoutput_x_tri VSS enable VDD_1V8 n2 output_x BTHHDLLX2
.ENDS

.SUBCKT tristategate_351 input_x enable output_x VSS VDD_1V8
XU1 n2 VSS VDD_1V8 LOGIC0HDLL
Xoutput_x_tri VSS enable VDD_1V8 n2 output_x BTHHDLLX2
.ENDS

.SUBCKT tristategate_350 input_x enable output_x VSS VDD_1V8
XU1 n2 VSS VDD_1V8 LOGIC0HDLL
Xoutput_x_tri VSS enable VDD_1V8 n2 output_x BTHHDLLX2
.ENDS

.SUBCKT tristategate_349 input_x enable output_x VSS VDD_1V8
XU1 n2 VSS VDD_1V8 LOGIC0HDLL
Xoutput_x_tri VSS enable VDD_1V8 n2 output_x BTHHDLLX2
.ENDS

.SUBCKT tristategate_348 input_x enable output_x VSS VDD_1V8
XU1 n2 VSS VDD_1V8 LOGIC0HDLL
Xoutput_x_tri VSS enable VDD_1V8 n2 output_x BTHHDLLX2
.ENDS

.SUBCKT tristategate_347 input_x enable output_x VSS VDD_1V8
XU1 n2 VSS VDD_1V8 LOGIC0HDLL
Xoutput_x_tri VSS enable VDD_1V8 n2 output_x BTHHDLLX2
.ENDS

.SUBCKT tristategate_346 input_x enable output_x VSS VDD_1V8
XU1 n2 VSS VDD_1V8 LOGIC0HDLL
Xoutput_x_tri VSS enable VDD_1V8 n2 output_x BTHHDLLX2
.ENDS

.SUBCKT tristategate_345 input_x enable output_x VSS VDD_1V8
XU1 n2 VSS VDD_1V8 LOGIC0HDLL
Xoutput_x_tri VSS enable VDD_1V8 n2 output_x BTHHDLLX2
.ENDS

.SUBCKT tristategate_344 input_x enable output_x VSS VDD_1V8
XU1 n2 VSS VDD_1V8 LOGIC0HDLL
Xoutput_x_tri VSS enable VDD_1V8 n2 output_x BTHHDLLX2
.ENDS

.SUBCKT tristategate_343 input_x enable output_x VSS VDD_1V8
XU1 n2 VSS VDD_1V8 LOGIC0HDLL
Xoutput_x_tri VSS enable VDD_1V8 n2 output_x BTHHDLLX2
.ENDS

.SUBCKT tristategate_342 input_x enable output_x VSS VDD_1V8
XU1 n2 VSS VDD_1V8 LOGIC0HDLL
Xoutput_x_tri VSS enable VDD_1V8 n2 output_x BTHHDLLX2
.ENDS

.SUBCKT tristategate_341 input_x enable output_x VSS VDD_1V8
XU1 n2 VSS VDD_1V8 LOGIC0HDLL
Xoutput_x_tri VSS enable VDD_1V8 n2 output_x BTHHDLLX2
.ENDS

.SUBCKT tristategate_340 input_x enable output_x VSS VDD_1V8
XU1 n2 VSS VDD_1V8 LOGIC0HDLL
Xoutput_x_tri VSS enable VDD_1V8 n2 output_x BTHHDLLX2
.ENDS

.SUBCKT tristategate_339 input_x enable output_x VSS VDD_1V8
XU1 n2 VSS VDD_1V8 LOGIC0HDLL
Xoutput_x_tri VSS enable VDD_1V8 n2 output_x BTHHDLLX2
.ENDS

.SUBCKT tristategate_338 input_x enable output_x VSS VDD_1V8
XU1 n2 VSS VDD_1V8 LOGIC0HDLL
Xoutput_x_tri VSS enable VDD_1V8 n2 output_x BTHHDLLX2
.ENDS

.SUBCKT tristategate_337 input_x enable output_x VSS VDD_1V8
XU1 n2 VSS VDD_1V8 LOGIC0HDLL
Xoutput_x_tri VSS enable VDD_1V8 n2 output_x BTHHDLLX2
.ENDS

.SUBCKT tristategate_336 input_x enable output_x VSS VDD_1V8
XU1 n6 VSS VDD_1V8 LOGIC0HDLL
Xoutput_x_tri VSS enable VDD_1V8 n6 output_x BTHHDLLX1
.ENDS

.SUBCKT tristategate_335 input_x enable output_x VSS VDD_1V8
XU1 n6 VSS VDD_1V8 LOGIC0HDLL
Xoutput_x_tri VSS enable VDD_1V8 n6 output_x BTHHDLLX1
.ENDS

.SUBCKT tristategate_137 input_x enable output_x VSS VDD_1V8
Xoutput_x_tri VSS enable VDD_1V8 input_x output_x BTHHDLLX1
.ENDS

.SUBCKT latch_137 clk d q rst VSS VDD_1V8
Xq_reg q VSS rst VDD_1V8 d clk DLHRQHDLLX0
.ENDS

.SUBCKT tristategate_136 input_x enable output_x VSS VDD_1V8
Xoutput_x_tri VSS enable VDD_1V8 input_x output_x BTHHDLLX1
.ENDS

.SUBCKT latch_136 clk d q rst VSS VDD_1V8
Xq_reg q VSS rst VDD_1V8 d clk DLHRQHDLLX0
.ENDS

.SUBCKT tristategate_135 input_x enable output_x VSS VDD_1V8
Xoutput_x_tri VSS enable VDD_1V8 input_x output_x BTHHDLLX1
.ENDS

.SUBCKT latch_135 clk d q rst VSS VDD_1V8
Xq_reg q VSS rst VDD_1V8 d clk DLHRQHDLLX0
.ENDS

.SUBCKT tristategate_134 input_x enable output_x VSS VDD_1V8
Xoutput_x_tri VSS enable VDD_1V8 input_x output_x BTHHDLLX1
.ENDS

.SUBCKT latch_134 clk d q rst VSS VDD_1V8
Xq_reg q VSS rst VDD_1V8 d clk DLHRQHDLLX0
.ENDS

.SUBCKT tristategate_133 input_x enable output_x VSS VDD_1V8
Xoutput_x_tri VSS enable VDD_1V8 input_x output_x BTHHDLLX1
.ENDS

.SUBCKT latch_133 clk d q rst VSS VDD_1V8
Xq_reg q VSS rst VDD_1V8 d clk DLHRQHDLLX0
.ENDS

.SUBCKT tristategate_132 input_x enable output_x VSS VDD_1V8
Xoutput_x_tri VSS enable VDD_1V8 input_x output_x BTHHDLLX1
.ENDS

.SUBCKT latch_132 clk d q rst VSS VDD_1V8
Xq_reg q VSS rst VDD_1V8 d clk DLHRQHDLLX0
.ENDS

.SUBCKT tristategate_131 input_x enable output_x VSS VDD_1V8
Xoutput_x_tri VSS enable VDD_1V8 input_x output_x BTHHDLLX1
.ENDS

.SUBCKT latch_131 clk d q rst VSS VDD_1V8
Xq_reg q VSS rst VDD_1V8 d clk DLHRQHDLLX0
.ENDS

.SUBCKT tristategate_130 input_x enable output_x VSS VDD_1V8
Xoutput_x_tri VSS enable VDD_1V8 input_x output_x BTHHDLLX1
.ENDS

.SUBCKT latch_130 clk d q rst VSS VDD_1V8
Xq_reg q VSS rst VDD_1V8 d clk DLHRQHDLLX0
.ENDS

.SUBCKT tristategate_129 input_x enable output_x VSS VDD_1V8
Xoutput_x_tri VSS enable VDD_1V8 input_x output_x BTHHDLLX1
.ENDS

.SUBCKT latch_129 clk d q rst VSS VDD_1V8
Xq_reg q VSS rst VDD_1V8 d clk DLHRQHDLLX0
.ENDS

.SUBCKT tristategate_128 input_x enable output_x VSS VDD_1V8
Xoutput_x_tri VSS enable VDD_1V8 input_x output_x BTHHDLLX1
.ENDS

.SUBCKT latch_128 clk d q rst VSS VDD_1V8
Xq_reg q VSS rst VDD_1V8 d clk DLHRQHDLLX0
.ENDS

.SUBCKT tristategate_127 input_x enable output_x VSS VDD_1V8
Xoutput_x_tri VSS enable VDD_1V8 input_x output_x BTHHDLLX1
.ENDS

.SUBCKT latch_127 clk d q rst VSS VDD_1V8
Xq_reg q VSS rst VDD_1V8 d clk DLHRQHDLLX0
.ENDS

.SUBCKT tristategate_126 input_x enable output_x VSS VDD_1V8
Xoutput_x_tri VSS enable VDD_1V8 input_x output_x BTHHDLLX1
.ENDS

.SUBCKT latch_126 clk d q rst VSS VDD_1V8
Xq_reg q VSS rst VDD_1V8 d clk DLHRQHDLLX0
.ENDS

.SUBCKT tristategate_125 input_x enable output_x VSS VDD_1V8
Xoutput_x_tri VSS enable VDD_1V8 input_x output_x BTHHDLLX1
.ENDS

.SUBCKT latch_125 clk d q rst VSS VDD_1V8
Xq_reg q VSS rst VDD_1V8 d clk DLHRQHDLLX0
.ENDS

.SUBCKT tristategate_124 input_x enable output_x VSS VDD_1V8
Xoutput_x_tri VSS enable VDD_1V8 input_x output_x BTHHDLLX1
.ENDS

.SUBCKT latch_124 clk d q rst VSS VDD_1V8
Xq_reg q VSS rst VDD_1V8 d clk DLHRQHDLLX0
.ENDS

.SUBCKT tristategate_123 input_x enable output_x VSS VDD_1V8
Xoutput_x_tri VSS enable VDD_1V8 input_x output_x BTHHDLLX2
.ENDS

.SUBCKT latch_123 clk d q rst VSS VDD_1V8
Xq_reg q VSS rst VDD_1V8 d clk DLHRQHDLLX0
.ENDS

.SUBCKT tristategate_122 input_x enable output_x VSS VDD_1V8
Xoutput_x_tri VSS enable VDD_1V8 input_x output_x BTHHDLLX2
.ENDS

.SUBCKT latch_122 clk d q rst VSS VDD_1V8
Xq_reg q VSS rst VDD_1V8 d clk DLHRQHDLLX0
.ENDS

.SUBCKT tristategate_121 input_x enable output_x VSS VDD_1V8
Xoutput_x_tri VSS enable VDD_1V8 input_x output_x BTHHDLLX2
.ENDS

.SUBCKT latch_121 clk d q rst VSS VDD_1V8
Xq_reg q VSS rst VDD_1V8 d clk DLHRQHDLLX0
.ENDS

.SUBCKT tristategate_120 input_x enable output_x VSS VDD_1V8
Xoutput_x_tri VSS enable VDD_1V8 input_x output_x BTHHDLLX2
.ENDS

.SUBCKT latch_120 clk d q rst VSS VDD_1V8
Xq_reg q VSS rst VDD_1V8 d clk DLHRQHDLLX0
.ENDS

.SUBCKT tristategate_119 input_x enable output_x VSS VDD_1V8
Xoutput_x_tri VSS enable VDD_1V8 input_x output_x BTHHDLLX2
.ENDS

.SUBCKT latch_119 clk d q rst VSS VDD_1V8
Xq_reg q VSS rst VDD_1V8 d clk DLHRQHDLLX0
.ENDS

.SUBCKT tristategate_118 input_x enable output_x VSS VDD_1V8
Xoutput_x_tri VSS enable VDD_1V8 input_x output_x BTHHDLLX2
.ENDS

.SUBCKT latch_118 clk d q rst VSS VDD_1V8
Xq_reg q VSS rst VDD_1V8 d clk DLHRQHDLLX0
.ENDS

.SUBCKT tristategate_117 input_x enable output_x VSS VDD_1V8
Xoutput_x_tri VSS enable VDD_1V8 input_x output_x BTHHDLLX2
.ENDS

.SUBCKT latch_117 clk d q rst VSS VDD_1V8
Xq_reg q VSS rst VDD_1V8 d clk DLHRQHDLLX0
.ENDS

.SUBCKT tristategate_116 input_x enable output_x VSS VDD_1V8
Xoutput_x_tri VSS enable VDD_1V8 input_x output_x BTHHDLLX2
.ENDS

.SUBCKT latch_116 clk d q rst VSS VDD_1V8
Xq_reg q VSS rst VDD_1V8 d clk DLHRQHDLLX0
.ENDS

.SUBCKT tristategate_115 input_x enable output_x VSS VDD_1V8
Xoutput_x_tri VSS enable VDD_1V8 input_x output_x BTHHDLLX2
.ENDS

.SUBCKT latch_115 clk d q rst VSS VDD_1V8
Xq_reg q VSS rst VDD_1V8 d clk DLHRQHDLLX0
.ENDS

.SUBCKT tristategate_114 input_x enable output_x VSS VDD_1V8
Xoutput_x_tri VSS enable VDD_1V8 input_x output_x BTHHDLLX2
.ENDS

.SUBCKT latch_114 clk d q rst VSS VDD_1V8
Xq_reg q VSS rst VDD_1V8 d clk DLHRQHDLLX0
.ENDS

.SUBCKT tristategate_113 input_x enable output_x VSS VDD_1V8
Xoutput_x_tri VSS enable VDD_1V8 input_x output_x BTHHDLLX2
.ENDS

.SUBCKT latch_113 clk d q rst VSS VDD_1V8
Xq_reg q VSS rst VDD_1V8 d clk DLHRQHDLLX0
.ENDS

.SUBCKT tristategate_112 input_x enable output_x VSS VDD_1V8
Xoutput_x_tri VSS enable VDD_1V8 input_x output_x BTHHDLLX2
.ENDS

.SUBCKT latch_112 clk d q rst VSS VDD_1V8
Xq_reg q VSS rst VDD_1V8 d clk DLHRQHDLLX0
.ENDS

.SUBCKT tristategate_111 input_x enable output_x VSS VDD_1V8
Xoutput_x_tri VSS enable VDD_1V8 input_x output_x BTHHDLLX2
.ENDS

.SUBCKT latch_111 clk d q rst VSS VDD_1V8
Xq_reg q VSS rst VDD_1V8 d clk DLHRQHDLLX0
.ENDS

.SUBCKT tristategate_110 input_x enable output_x VSS VDD_1V8
Xoutput_x_tri VSS enable VDD_1V8 input_x output_x BTHHDLLX2
.ENDS

.SUBCKT latch_110 clk d q rst VSS VDD_1V8
Xq_reg q VSS rst VDD_1V8 d clk DLHRQHDLLX0
.ENDS

.SUBCKT tristategate_109 input_x enable output_x VSS VDD_1V8
Xoutput_x_tri VSS enable VDD_1V8 input_x output_x BTHHDLLX2
.ENDS

.SUBCKT latch_109 clk d q rst VSS VDD_1V8
Xq_reg q VSS rst VDD_1V8 d clk DLHRQHDLLX0
.ENDS

.SUBCKT tristategate_108 input_x enable output_x VSS VDD_1V8
Xoutput_x_tri VSS enable VDD_1V8 input_x output_x BTHHDLLX1
.ENDS

.SUBCKT latch_108 clk d q rst VSS VDD_1V8
Xq_reg q VSS rst VDD_1V8 d clk DLHRQHDLLX0
.ENDS

.SUBCKT tristategate_107 input_x enable output_x VSS VDD_1V8
Xoutput_x_tri VSS enable VDD_1V8 input_x output_x BTHHDLLX1
.ENDS

.SUBCKT latch_107 clk d q rst VSS VDD_1V8
Xq_reg q VSS rst VDD_1V8 d clk DLHRQHDLLX0
.ENDS

.SUBCKT tristategate_106 input_x enable output_x VSS VDD_1V8
Xoutput_x_tri VSS enable VDD_1V8 input_x output_x BTHHDLLX1
.ENDS

.SUBCKT latch_106 clk d q rst VSS VDD_1V8
Xq_reg q VSS rst VDD_1V8 d clk DLHRQHDLLX0
.ENDS

.SUBCKT tristategate_105 input_x enable output_x VSS VDD_1V8
Xoutput_x_tri VSS enable VDD_1V8 input_x output_x BTHHDLLX1
.ENDS

.SUBCKT latch_105 clk d q rst VSS VDD_1V8
Xq_reg q VSS rst VDD_1V8 d clk DLHRQHDLLX0
.ENDS

.SUBCKT tristategate_104 input_x enable output_x VSS VDD_1V8
Xoutput_x_tri VSS enable VDD_1V8 input_x output_x BTHHDLLX1
.ENDS

.SUBCKT latch_104 clk d q rst VSS VDD_1V8
Xq_reg q VSS rst VDD_1V8 d clk DLHRQHDLLX0
.ENDS

.SUBCKT tristategate_103 input_x enable output_x VSS VDD_1V8
Xoutput_x_tri VSS enable VDD_1V8 input_x output_x BTHHDLLX1
.ENDS

.SUBCKT latch_103 clk d q rst VSS VDD_1V8
Xq_reg q VSS rst VDD_1V8 d clk DLHRQHDLLX0
.ENDS

.SUBCKT tristategate_102 input_x enable output_x VSS VDD_1V8
Xoutput_x_tri VSS enable VDD_1V8 input_x output_x BTHHDLLX1
.ENDS

.SUBCKT latch_102 clk d q rst VSS VDD_1V8
Xq_reg q VSS rst VDD_1V8 d clk DLHRQHDLLX0
.ENDS

.SUBCKT tristategate_101 input_x enable output_x VSS VDD_1V8
Xoutput_x_tri VSS enable VDD_1V8 input_x output_x BTHHDLLX1
.ENDS

.SUBCKT latch_101 clk d q rst VSS VDD_1V8
Xq_reg q VSS rst VDD_1V8 d clk DLHRQHDLLX0
.ENDS

.SUBCKT tristategate_100 input_x enable output_x VSS VDD_1V8
Xoutput_x_tri VSS enable VDD_1V8 input_x output_x BTHHDLLX1
.ENDS

.SUBCKT latch_100 clk d q rst VSS VDD_1V8
Xq_reg q VSS rst VDD_1V8 d clk DLHRQHDLLX0
.ENDS

.SUBCKT tristategate_99 input_x enable output_x VSS VDD_1V8
Xoutput_x_tri VSS enable VDD_1V8 input_x output_x BTHHDLLX1
.ENDS

.SUBCKT latch_99 clk d q rst VSS VDD_1V8
Xq_reg q VSS rst VDD_1V8 d clk DLHRQHDLLX0
.ENDS

.SUBCKT tristategate_98 input_x enable output_x VSS VDD_1V8
Xoutput_x_tri VSS enable VDD_1V8 input_x output_x BTHHDLLX1
.ENDS

.SUBCKT latch_98 clk d q rst VSS VDD_1V8
Xq_reg q VSS rst VDD_1V8 d clk DLHRQHDLLX0
.ENDS

.SUBCKT tristategate_97 input_x enable output_x VSS VDD_1V8
Xoutput_x_tri VSS enable VDD_1V8 input_x output_x BTHHDLLX1
.ENDS

.SUBCKT latch_97 clk d q rst VSS VDD_1V8
Xq_reg q VSS rst VDD_1V8 d clk DLHRQHDLLX0
.ENDS

.SUBCKT tristategate_96 input_x enable output_x VSS VDD_1V8
Xoutput_x_tri VSS enable VDD_1V8 input_x output_x BTHHDLLX1
.ENDS

.SUBCKT latch_96 clk d q rst VSS VDD_1V8
Xq_reg q VSS rst VDD_1V8 d clk DLHRQHDLLX0
.ENDS

.SUBCKT tristategate_95 input_x enable output_x VSS VDD_1V8
Xoutput_x_tri VSS enable VDD_1V8 input_x output_x BTHHDLLX1
.ENDS

.SUBCKT latch_95 clk d q rst VSS VDD_1V8
Xq_reg q VSS rst VDD_1V8 d clk DLHRQHDLLX0
.ENDS

.SUBCKT tristategate_94 input_x enable output_x VSS VDD_1V8
Xoutput_x_tri VSS enable VDD_1V8 input_x output_x BTHHDLLX1
.ENDS

.SUBCKT latch_94 clk d q rst VSS VDD_1V8
Xq_reg q VSS rst VDD_1V8 d clk DLHRQHDLLX0
.ENDS

.SUBCKT tristategate_93 input_x enable output_x VSS VDD_1V8
Xoutput_x_tri VSS enable VDD_1V8 input_x output_x BTHHDLLX1
.ENDS

.SUBCKT latch_93 clk d q rst VSS VDD_1V8
Xq_reg q VSS rst VDD_1V8 d clk DLHRQHDLLX0
.ENDS

.SUBCKT tristategate_92 input_x enable output_x VSS VDD_1V8
Xoutput_x_tri VSS enable VDD_1V8 input_x output_x BTHHDLLX1
.ENDS

.SUBCKT latch_92 clk d q rst VSS VDD_1V8
Xq_reg q VSS rst VDD_1V8 d clk DLHRQHDLLX0
.ENDS

.SUBCKT tristategate_91 input_x enable output_x VSS VDD_1V8
Xoutput_x_tri VSS enable VDD_1V8 input_x output_x BTHHDLLX2
.ENDS

.SUBCKT latch_91 clk d q rst VSS VDD_1V8
Xq_reg q VSS rst VDD_1V8 d clk DLHRQHDLLX0
.ENDS

.SUBCKT tristategate_90 input_x enable output_x VSS VDD_1V8
Xoutput_x_tri VSS enable VDD_1V8 input_x output_x BTHHDLLX2
.ENDS

.SUBCKT latch_90 clk d q rst VSS VDD_1V8
Xq_reg q VSS rst VDD_1V8 d clk DLHRQHDLLX0
.ENDS

.SUBCKT tristategate_89 input_x enable output_x VSS VDD_1V8
Xoutput_x_tri VSS enable VDD_1V8 input_x output_x BTHHDLLX2
.ENDS

.SUBCKT latch_89 clk d q rst VSS VDD_1V8
Xq_reg q VSS rst VDD_1V8 d clk DLHRQHDLLX0
.ENDS

.SUBCKT tristategate_88 input_x enable output_x VSS VDD_1V8
Xoutput_x_tri VSS enable VDD_1V8 input_x output_x BTHHDLLX2
.ENDS

.SUBCKT latch_88 clk d q rst VSS VDD_1V8
Xq_reg q VSS rst VDD_1V8 d clk DLHRQHDLLX0
.ENDS

.SUBCKT tristategate_87 input_x enable output_x VSS VDD_1V8
Xoutput_x_tri VSS enable VDD_1V8 input_x output_x BTHHDLLX2
.ENDS

.SUBCKT latch_87 clk d q rst VSS VDD_1V8
Xq_reg q VSS rst VDD_1V8 d clk DLHRQHDLLX0
.ENDS

.SUBCKT tristategate_86 input_x enable output_x VSS VDD_1V8
Xoutput_x_tri VSS enable VDD_1V8 input_x output_x BTHHDLLX2
.ENDS

.SUBCKT latch_86 clk d q rst VSS VDD_1V8
Xq_reg q VSS rst VDD_1V8 d clk DLHRQHDLLX0
.ENDS

.SUBCKT tristategate_85 input_x enable output_x VSS VDD_1V8
Xoutput_x_tri VSS enable VDD_1V8 input_x output_x BTHHDLLX2
.ENDS

.SUBCKT latch_85 clk d q rst VSS VDD_1V8
Xq_reg q VSS rst VDD_1V8 d clk DLHRQHDLLX0
.ENDS

.SUBCKT tristategate_84 input_x enable output_x VSS VDD_1V8
Xoutput_x_tri VSS enable VDD_1V8 input_x output_x BTHHDLLX2
.ENDS

.SUBCKT latch_84 clk d q rst VSS VDD_1V8
Xq_reg q VSS rst VDD_1V8 d clk DLHRQHDLLX0
.ENDS

.SUBCKT tristategate_83 input_x enable output_x VSS VDD_1V8
Xoutput_x_tri VSS enable VDD_1V8 input_x output_x BTHHDLLX2
.ENDS

.SUBCKT latch_83 clk d q rst VSS VDD_1V8
Xq_reg q VSS rst VDD_1V8 d clk DLHRQHDLLX0
.ENDS

.SUBCKT tristategate_82 input_x enable output_x VSS VDD_1V8
Xoutput_x_tri VSS enable VDD_1V8 input_x output_x BTHHDLLX2
.ENDS

.SUBCKT latch_82 clk d q rst VSS VDD_1V8
Xq_reg q VSS rst VDD_1V8 d clk DLHRQHDLLX0
.ENDS

.SUBCKT tristategate_81 input_x enable output_x VSS VDD_1V8
Xoutput_x_tri VSS enable VDD_1V8 input_x output_x BTHHDLLX2
.ENDS

.SUBCKT latch_81 clk d q rst VSS VDD_1V8
Xq_reg q VSS rst VDD_1V8 d clk DLHRQHDLLX0
.ENDS

.SUBCKT tristategate_80 input_x enable output_x VSS VDD_1V8
Xoutput_x_tri VSS enable VDD_1V8 input_x output_x BTHHDLLX2
.ENDS

.SUBCKT latch_80 clk d q rst VSS VDD_1V8
Xq_reg q VSS rst VDD_1V8 d clk DLHRQHDLLX0
.ENDS

.SUBCKT tristategate_79 input_x enable output_x VSS VDD_1V8
Xoutput_x_tri VSS enable VDD_1V8 input_x output_x BTHHDLLX2
.ENDS

.SUBCKT latch_79 clk d q rst VSS VDD_1V8
Xq_reg q VSS rst VDD_1V8 d clk DLHRQHDLLX0
.ENDS

.SUBCKT tristategate_78 input_x enable output_x VSS VDD_1V8
Xoutput_x_tri VSS enable VDD_1V8 input_x output_x BTHHDLLX2
.ENDS

.SUBCKT latch_78 clk d q rst VSS VDD_1V8
Xq_reg q VSS rst VDD_1V8 d clk DLHRQHDLLX0
.ENDS

.SUBCKT tristategate_77 input_x enable output_x VSS VDD_1V8
Xoutput_x_tri VSS enable VDD_1V8 input_x output_x BTHHDLLX2
.ENDS

.SUBCKT latch_77 clk d q rst VSS VDD_1V8
Xq_reg q VSS rst VDD_1V8 d clk DLHRQHDLLX0
.ENDS

.SUBCKT tristategate_76 input_x enable output_x VSS VDD_1V8
Xoutput_x_tri VSS enable VDD_1V8 input_x output_x BTHHDLLX1
.ENDS

.SUBCKT latch_76 clk d q rst VSS VDD_1V8
Xq_reg q VSS rst VDD_1V8 d clk DLHRQHDLLX0
.ENDS

.SUBCKT tristategate_334 input_x enable output_x VSS VDD_1V8
Xoutput_x_tri VSS enable VDD_1V8 input_x output_x BTHHDLLX1
.ENDS

.SUBCKT tristategate_333 input_x enable output_x VSS VDD_1V8
Xoutput_x_tri VSS enable VDD_1V8 input_x output_x BTHHDLLX1
.ENDS

.SUBCKT tristategate_332 input_x enable output_x VSS VDD_1V8
Xoutput_x_tri VSS enable VDD_1V8 input_x output_x BTHHDLLX1
.ENDS

.SUBCKT tristategate_331 input_x enable output_x VSS VDD_1V8
Xoutput_x_tri VSS enable VDD_1V8 input_x output_x BTHHDLLX1
.ENDS

.SUBCKT tristategate_330 input_x enable output_x VSS VDD_1V8
Xoutput_x_tri VSS enable VDD_1V8 input_x output_x BTHHDLLX1
.ENDS

.SUBCKT tristategate_329 input_x enable output_x VSS VDD_1V8
Xoutput_x_tri VSS enable VDD_1V8 input_x output_x BTHHDLLX1
.ENDS

.SUBCKT tristategate_328 input_x enable output_x VSS VDD_1V8
Xoutput_x_tri VSS enable VDD_1V8 input_x output_x BTHHDLLX1
.ENDS

.SUBCKT tristategate_327 input_x enable output_x VSS VDD_1V8
Xoutput_x_tri VSS enable VDD_1V8 input_x output_x BTHHDLLX1
.ENDS

.SUBCKT tristategate_326 input_x enable output_x VSS VDD_1V8
Xoutput_x_tri VSS enable VDD_1V8 input_x output_x BTHHDLLX1
.ENDS

.SUBCKT tristategate_325 input_x enable output_x VSS VDD_1V8
Xoutput_x_tri VSS enable VDD_1V8 input_x output_x BTHHDLLX1
.ENDS

.SUBCKT tristategate_324 input_x enable output_x VSS VDD_1V8
Xoutput_x_tri VSS enable VDD_1V8 input_x output_x BTHHDLLX1
.ENDS

.SUBCKT tristategate_323 input_x enable output_x VSS VDD_1V8
Xoutput_x_tri VSS enable VDD_1V8 input_x output_x BTHHDLLX1
.ENDS

.SUBCKT tristategate_322 input_x enable output_x VSS VDD_1V8
Xoutput_x_tri VSS enable VDD_1V8 input_x output_x BTHHDLLX1
.ENDS

.SUBCKT tristategate_321 input_x enable output_x VSS VDD_1V8
Xoutput_x_tri VSS enable VDD_1V8 input_x output_x BTHHDLLX1
.ENDS

.SUBCKT tristategate_320 input_x enable output_x VSS VDD_1V8
Xoutput_x_tri VSS enable VDD_1V8 input_x output_x BTHHDLLX1
.ENDS

.SUBCKT tristategate_319 input_x enable output_x VSS VDD_1V8
Xoutput_x_tri VSS enable VDD_1V8 input_x output_x BTHHDLLX1
.ENDS

.SUBCKT tristategate_318 input_x enable output_x VSS VDD_1V8
Xoutput_x_tri VSS enable VDD_1V8 input_x output_x BTHHDLLX2
.ENDS

.SUBCKT tristategate_317 input_x enable output_x VSS VDD_1V8
Xoutput_x_tri VSS enable VDD_1V8 input_x output_x BTHHDLLX2
.ENDS

.SUBCKT tristategate_316 input_x enable output_x VSS VDD_1V8
Xoutput_x_tri VSS enable VDD_1V8 input_x output_x BTHHDLLX2
.ENDS

.SUBCKT tristategate_315 input_x enable output_x VSS VDD_1V8
Xoutput_x_tri VSS enable VDD_1V8 input_x output_x BTHHDLLX2
.ENDS

.SUBCKT tristategate_314 input_x enable output_x VSS VDD_1V8
Xoutput_x_tri VSS enable VDD_1V8 input_x output_x BTHHDLLX2
.ENDS

.SUBCKT tristategate_313 input_x enable output_x VSS VDD_1V8
Xoutput_x_tri VSS enable VDD_1V8 input_x output_x BTHHDLLX2
.ENDS

.SUBCKT tristategate_312 input_x enable output_x VSS VDD_1V8
Xoutput_x_tri VSS enable VDD_1V8 input_x output_x BTHHDLLX2
.ENDS

.SUBCKT tristategate_311 input_x enable output_x VSS VDD_1V8
Xoutput_x_tri VSS enable VDD_1V8 input_x output_x BTHHDLLX2
.ENDS

.SUBCKT tristategate_310 input_x enable output_x VSS VDD_1V8
Xoutput_x_tri VSS enable VDD_1V8 input_x output_x BTHHDLLX2
.ENDS

.SUBCKT tristategate_309 input_x enable output_x VSS VDD_1V8
Xoutput_x_tri VSS enable VDD_1V8 input_x output_x BTHHDLLX2
.ENDS

.SUBCKT tristategate_308 input_x enable output_x VSS VDD_1V8
Xoutput_x_tri VSS enable VDD_1V8 input_x output_x BTHHDLLX2
.ENDS

.SUBCKT tristategate_307 input_x enable output_x VSS VDD_1V8
Xoutput_x_tri VSS enable VDD_1V8 input_x output_x BTHHDLLX2
.ENDS

.SUBCKT tristategate_306 input_x enable output_x VSS VDD_1V8
Xoutput_x_tri VSS enable VDD_1V8 input_x output_x BTHHDLLX2
.ENDS

.SUBCKT tristategate_305 input_x enable output_x VSS VDD_1V8
Xoutput_x_tri VSS enable VDD_1V8 input_x output_x BTHHDLLX2
.ENDS

.SUBCKT tristategate_304 input_x enable output_x VSS VDD_1V8
Xoutput_x_tri VSS enable VDD_1V8 input_x output_x BTHHDLLX2
.ENDS

.SUBCKT tristategate_303 input_x enable output_x VSS VDD_1V8
Xoutput_x_tri VSS enable VDD_1V8 input_x output_x BTHHDLLX2
.ENDS

.SUBCKT tristategate_75 input_x enable output_x VSS VDD_1V8
Xoutput_x_tri VSS enable VDD_1V8 input_x output_x BTHHDLLX1
.ENDS

.SUBCKT latch_75 clk d q rst VSS VDD_1V8
Xq_reg q VSS rst VDD_1V8 d clk DLHRQHDLLX0
.ENDS

.SUBCKT tristategate_74 input_x enable output_x VSS VDD_1V8
Xoutput_x_tri VSS enable VDD_1V8 input_x output_x BTHHDLLX1
.ENDS

.SUBCKT latch_74 clk d q rst VSS VDD_1V8
Xq_reg q VSS rst VDD_1V8 d clk DLHRQHDLLX0
.ENDS

.SUBCKT tristategate_73 input_x enable output_x VSS VDD_1V8
Xoutput_x_tri VSS enable VDD_1V8 input_x output_x BTHHDLLX1
.ENDS

.SUBCKT latch_73 clk d q rst VSS VDD_1V8
Xq_reg q VSS rst VDD_1V8 d clk DLHRQHDLLX0
.ENDS

.SUBCKT tristategate_72 input_x enable output_x VSS VDD_1V8
Xoutput_x_tri VSS enable VDD_1V8 input_x output_x BTHHDLLX1
.ENDS

.SUBCKT latch_72 clk d q rst VSS VDD_1V8
Xq_reg q VSS rst VDD_1V8 d clk DLHRQHDLLX0
.ENDS

.SUBCKT tristategate_71 input_x enable output_x VSS VDD_1V8
Xoutput_x_tri VSS enable VDD_1V8 input_x output_x BTHHDLLX1
.ENDS

.SUBCKT latch_71 clk d q rst VSS VDD_1V8
Xq_reg q VSS rst VDD_1V8 d clk DLHRQHDLLX0
.ENDS

.SUBCKT tristategate_70 input_x enable output_x VSS VDD_1V8
Xoutput_x_tri VSS enable VDD_1V8 input_x output_x BTHHDLLX1
.ENDS

.SUBCKT latch_70 clk d q rst VSS VDD_1V8
Xq_reg q VSS rst VDD_1V8 d clk DLHRQHDLLX0
.ENDS

.SUBCKT tristategate_69 input_x enable output_x VSS VDD_1V8
Xoutput_x_tri VSS enable VDD_1V8 input_x output_x BTHHDLLX1
.ENDS

.SUBCKT latch_69 clk d q rst VSS VDD_1V8
Xq_reg q VSS rst VDD_1V8 d clk DLHRQHDLLX0
.ENDS

.SUBCKT tristategate_68 input_x enable output_x VSS VDD_1V8
Xoutput_x_tri VSS enable VDD_1V8 input_x output_x BTHHDLLX1
.ENDS

.SUBCKT latch_68 clk d q rst VSS VDD_1V8
Xq_reg q VSS rst VDD_1V8 d clk DLHRQHDLLX0
.ENDS

.SUBCKT tristategate_302 input_x enable output_x VSS VDD_1V8
XU1 n2 VSS VDD_1V8 LOGIC0HDLL
Xoutput_x_tri VSS enable VDD_1V8 n2 output_x BTHHDLLX1
.ENDS

.SUBCKT tristategate_301 input_x enable output_x VSS VDD_1V8
XU1 n2 VSS VDD_1V8 LOGIC0HDLL
Xoutput_x_tri VSS enable VDD_1V8 n2 output_x BTHHDLLX1
.ENDS

.SUBCKT tristategate_300 input_x enable output_x VSS VDD_1V8
XU1 n2 VSS VDD_1V8 LOGIC0HDLL
Xoutput_x_tri VSS enable VDD_1V8 n2 output_x BTHHDLLX1
.ENDS

.SUBCKT tristategate_299 input_x enable output_x VSS VDD_1V8
XU1 n2 VSS VDD_1V8 LOGIC0HDLL
Xoutput_x_tri VSS enable VDD_1V8 n2 output_x BTHHDLLX1
.ENDS

.SUBCKT tristategate_298 input_x enable output_x VSS VDD_1V8
XU1 n2 VSS VDD_1V8 LOGIC0HDLL
Xoutput_x_tri VSS enable VDD_1V8 n2 output_x BTHHDLLX1
.ENDS

.SUBCKT tristategate_297 input_x enable output_x VSS VDD_1V8
XU1 n2 VSS VDD_1V8 LOGIC0HDLL
Xoutput_x_tri VSS enable VDD_1V8 n2 output_x BTHHDLLX1
.ENDS

.SUBCKT tristategate_296 input_x enable output_x VSS VDD_1V8
XU1 n2 VSS VDD_1V8 LOGIC0HDLL
Xoutput_x_tri VSS enable VDD_1V8 n2 output_x BTHHDLLX1
.ENDS

.SUBCKT tristategate_295 input_x enable output_x VSS VDD_1V8
XU1 n2 VSS VDD_1V8 LOGIC0HDLL
Xoutput_x_tri VSS enable VDD_1V8 n2 output_x BTHHDLLX1
.ENDS

.SUBCKT tristategate_294 input_x enable output_x VSS VDD_1V8
XU1 n2 VSS VDD_1V8 LOGIC0HDLL
Xoutput_x_tri VSS enable VDD_1V8 n2 output_x BTHHDLLX2
.ENDS

.SUBCKT tristategate_293 input_x enable output_x VSS VDD_1V8
XU1 n2 VSS VDD_1V8 LOGIC0HDLL
Xoutput_x_tri VSS enable VDD_1V8 n2 output_x BTHHDLLX2
.ENDS

.SUBCKT tristategate_292 input_x enable output_x VSS VDD_1V8
XU1 n2 VSS VDD_1V8 LOGIC0HDLL
Xoutput_x_tri VSS enable VDD_1V8 n2 output_x BTHHDLLX2
.ENDS

.SUBCKT tristategate_291 input_x enable output_x VSS VDD_1V8
XU1 n2 VSS VDD_1V8 LOGIC0HDLL
Xoutput_x_tri VSS enable VDD_1V8 n2 output_x BTHHDLLX2
.ENDS

.SUBCKT tristategate_290 input_x enable output_x VSS VDD_1V8
XU1 n2 VSS VDD_1V8 LOGIC0HDLL
Xoutput_x_tri VSS enable VDD_1V8 n2 output_x BTHHDLLX2
.ENDS

.SUBCKT tristategate_289 input_x enable output_x VSS VDD_1V8
XU1 n2 VSS VDD_1V8 LOGIC0HDLL
Xoutput_x_tri VSS enable VDD_1V8 n2 output_x BTHHDLLX2
.ENDS

.SUBCKT tristategate_288 input_x enable output_x VSS VDD_1V8
XU1 n2 VSS VDD_1V8 LOGIC0HDLL
Xoutput_x_tri VSS enable VDD_1V8 n2 output_x BTHHDLLX2
.ENDS

.SUBCKT tristategate_287 input_x enable output_x VSS VDD_1V8
XU1 n2 VSS VDD_1V8 LOGIC0HDLL
Xoutput_x_tri VSS enable VDD_1V8 n2 output_x BTHHDLLX2
.ENDS

.SUBCKT tristategate_286 input_x enable output_x VSS VDD_1V8
XU1 n2 VSS VDD_1V8 LOGIC0HDLL
Xoutput_x_tri VSS enable VDD_1V8 n2 output_x BTHHDLLX2
.ENDS

.SUBCKT tristategate_285 input_x enable output_x VSS VDD_1V8
XU1 n2 VSS VDD_1V8 LOGIC0HDLL
Xoutput_x_tri VSS enable VDD_1V8 n2 output_x BTHHDLLX2
.ENDS

.SUBCKT tristategate_284 input_x enable output_x VSS VDD_1V8
XU1 n2 VSS VDD_1V8 LOGIC0HDLL
Xoutput_x_tri VSS enable VDD_1V8 n2 output_x BTHHDLLX2
.ENDS

.SUBCKT tristategate_283 input_x enable output_x VSS VDD_1V8
XU1 n2 VSS VDD_1V8 LOGIC0HDLL
Xoutput_x_tri VSS enable VDD_1V8 n2 output_x BTHHDLLX2
.ENDS

.SUBCKT tristategate_282 input_x enable output_x VSS VDD_1V8
XU1 n2 VSS VDD_1V8 LOGIC0HDLL
Xoutput_x_tri VSS enable VDD_1V8 n2 output_x BTHHDLLX2
.ENDS

.SUBCKT tristategate_281 input_x enable output_x VSS VDD_1V8
XU1 n2 VSS VDD_1V8 LOGIC0HDLL
Xoutput_x_tri VSS enable VDD_1V8 n2 output_x BTHHDLLX2
.ENDS

.SUBCKT tristategate_280 input_x enable output_x VSS VDD_1V8
XU1 n2 VSS VDD_1V8 LOGIC0HDLL
Xoutput_x_tri VSS enable VDD_1V8 n2 output_x BTHHDLLX2
.ENDS

.SUBCKT tristategate_279 input_x enable output_x VSS VDD_1V8
XU1 n2 VSS VDD_1V8 LOGIC0HDLL
Xoutput_x_tri VSS enable VDD_1V8 n2 output_x BTHHDLLX2
.ENDS

.SUBCKT tristategate_67 input_x enable output_x VSS VDD_1V8
Xoutput_x_tri VSS enable VDD_1V8 input_x output_x BTHHDLLX1
.ENDS

.SUBCKT latch_67 clk d q rst VSS VDD_1V8
Xq_reg q VSS rst VDD_1V8 d clk DLHRQHDLLX0
.ENDS

.SUBCKT tristategate_66 input_x enable output_x VSS VDD_1V8
Xoutput_x_tri VSS enable VDD_1V8 input_x output_x BTHHDLLX1
.ENDS

.SUBCKT latch_66 clk d q rst VSS VDD_1V8
Xq_reg q VSS rst VDD_1V8 d clk DLHRQHDLLX0
.ENDS

.SUBCKT tristategate_65 input_x enable output_x VSS VDD_1V8
Xoutput_x_tri VSS enable VDD_1V8 input_x output_x BTHHDLLX1
.ENDS

.SUBCKT latch_65 clk d q rst VSS VDD_1V8
Xq_reg q VSS rst VDD_1V8 d clk DLHRQHDLLX0
.ENDS

.SUBCKT tristategate_64 input_x enable output_x VSS VDD_1V8
Xoutput_x_tri VSS enable VDD_1V8 input_x output_x BTHHDLLX1
.ENDS

.SUBCKT latch_64 clk d q rst VSS VDD_1V8
Xq_reg q VSS rst VDD_1V8 d clk DLHRQHDLLX0
.ENDS

.SUBCKT tristategate_63 input_x enable output_x VSS VDD_1V8
Xoutput_x_tri VSS enable VDD_1V8 input_x output_x BTHHDLLX1
.ENDS

.SUBCKT latch_63 clk d q rst VSS VDD_1V8
Xq_reg q VSS rst VDD_1V8 d clk DLHRQHDLLX0
.ENDS

.SUBCKT tristategate_62 input_x enable output_x VSS VDD_1V8
Xoutput_x_tri VSS enable VDD_1V8 input_x output_x BTHHDLLX1
.ENDS

.SUBCKT latch_62 clk d q rst VSS VDD_1V8
Xq_reg q VSS rst VDD_1V8 d clk DLHRQHDLLX0
.ENDS

.SUBCKT tristategate_61 input_x enable output_x VSS VDD_1V8
Xoutput_x_tri VSS enable VDD_1V8 input_x output_x BTHHDLLX1
.ENDS

.SUBCKT latch_61 clk d q rst VSS VDD_1V8
Xq_reg q VSS rst VDD_1V8 d clk DLHRQHDLLX0
.ENDS

.SUBCKT tristategate_60 input_x enable output_x VSS VDD_1V8
Xoutput_x_tri VSS enable VDD_1V8 input_x output_x BTHHDLLX1
.ENDS

.SUBCKT latch_60 clk d q rst VSS VDD_1V8
Xq_reg q VSS rst VDD_1V8 d clk DLHRQHDLLX0
.ENDS

.SUBCKT tristategate_59 input_x enable output_x VSS VDD_1V8
Xoutput_x_tri VSS enable VDD_1V8 input_x output_x BTHHDLLX1
.ENDS

.SUBCKT latch_59 clk d q rst VSS VDD_1V8
Xq_reg q VSS rst VDD_1V8 d clk DLHRQHDLLX0
.ENDS

.SUBCKT tristategate_58 input_x enable output_x VSS VDD_1V8
Xoutput_x_tri VSS enable VDD_1V8 input_x output_x BTHHDLLX1
.ENDS

.SUBCKT latch_58 clk d q rst VSS VDD_1V8
Xq_reg q VSS rst VDD_1V8 d clk DLHRQHDLLX0
.ENDS

.SUBCKT tristategate_57 input_x enable output_x VSS VDD_1V8
Xoutput_x_tri VSS enable VDD_1V8 input_x output_x BTHHDLLX1
.ENDS

.SUBCKT latch_57 clk d q rst VSS VDD_1V8
Xq_reg q VSS rst VDD_1V8 d clk DLHRQHDLLX0
.ENDS

.SUBCKT tristategate_56 input_x enable output_x VSS VDD_1V8
Xoutput_x_tri VSS enable VDD_1V8 input_x output_x BTHHDLLX1
.ENDS

.SUBCKT latch_56 clk d q rst VSS VDD_1V8
Xq_reg q VSS rst VDD_1V8 d clk DLHRQHDLLX0
.ENDS

.SUBCKT tristategate_55 input_x enable output_x VSS VDD_1V8
Xoutput_x_tri VSS enable VDD_1V8 input_x output_x BTHHDLLX1
.ENDS

.SUBCKT latch_55 clk d q rst VSS VDD_1V8
Xq_reg q VSS rst VDD_1V8 d clk DLHRQHDLLX0
.ENDS

.SUBCKT tristategate_54 input_x enable output_x VSS VDD_1V8
Xoutput_x_tri VSS enable VDD_1V8 input_x output_x BTHHDLLX1
.ENDS

.SUBCKT latch_54 clk d q rst VSS VDD_1V8
Xq_reg q VSS rst VDD_1V8 d clk DLHRQHDLLX0
.ENDS

.SUBCKT tristategate_53 input_x enable output_x VSS VDD_1V8
Xoutput_x_tri VSS enable VDD_1V8 input_x output_x BTHHDLLX1
.ENDS

.SUBCKT latch_53 clk d q rst VSS VDD_1V8
Xq_reg q VSS rst VDD_1V8 d clk DLHRQHDLLX0
.ENDS

.SUBCKT tristategate_52 input_x enable output_x VSS VDD_1V8
Xoutput_x_tri VSS enable VDD_1V8 input_x output_x BTHHDLLX1
.ENDS

.SUBCKT latch_52 clk d q rst VSS VDD_1V8
Xq_reg q VSS rst VDD_1V8 d clk DLHRQHDLLX0
.ENDS

.SUBCKT tristategate_51 input_x enable output_x VSS VDD_1V8
Xoutput_x_tri VSS enable VDD_1V8 input_x output_x BTHHDLLX2
.ENDS

.SUBCKT latch_51 clk d q rst VSS VDD_1V8
Xq_reg q VSS rst VDD_1V8 d clk DLHRQHDLLX0
.ENDS

.SUBCKT tristategate_50 input_x enable output_x VSS VDD_1V8
Xoutput_x_tri VSS enable VDD_1V8 input_x output_x BTHHDLLX2
.ENDS

.SUBCKT latch_50 clk d q rst VSS VDD_1V8
Xq_reg q VSS rst VDD_1V8 d clk DLHRQHDLLX0
.ENDS

.SUBCKT tristategate_49 input_x enable output_x VSS VDD_1V8
Xoutput_x_tri VSS enable VDD_1V8 input_x output_x BTHHDLLX2
.ENDS

.SUBCKT latch_49 clk d q rst VSS VDD_1V8
Xq_reg q VSS rst VDD_1V8 d clk DLHRQHDLLX0
.ENDS

.SUBCKT tristategate_48 input_x enable output_x VSS VDD_1V8
Xoutput_x_tri VSS enable VDD_1V8 input_x output_x BTHHDLLX2
.ENDS

.SUBCKT latch_48 clk d q rst VSS VDD_1V8
Xq_reg q VSS rst VDD_1V8 d clk DLHRQHDLLX0
.ENDS

.SUBCKT tristategate_47 input_x enable output_x VSS VDD_1V8
Xoutput_x_tri VSS enable VDD_1V8 input_x output_x BTHHDLLX2
.ENDS

.SUBCKT latch_47 clk d q rst VSS VDD_1V8
Xq_reg q VSS rst VDD_1V8 d clk DLHRQHDLLX0
.ENDS

.SUBCKT tristategate_46 input_x enable output_x VSS VDD_1V8
Xoutput_x_tri VSS enable VDD_1V8 input_x output_x BTHHDLLX2
.ENDS

.SUBCKT latch_46 clk d q rst VSS VDD_1V8
Xq_reg q VSS rst VDD_1V8 d clk DLHRQHDLLX0
.ENDS

.SUBCKT tristategate_45 input_x enable output_x VSS VDD_1V8
Xoutput_x_tri VSS enable VDD_1V8 input_x output_x BTHHDLLX2
.ENDS

.SUBCKT latch_45 clk d q rst VSS VDD_1V8
Xq_reg q VSS rst VDD_1V8 d clk DLHRQHDLLX0
.ENDS

.SUBCKT tristategate_44 input_x enable output_x VSS VDD_1V8
Xoutput_x_tri VSS enable VDD_1V8 input_x output_x BTHHDLLX2
.ENDS

.SUBCKT latch_44 clk d q rst VSS VDD_1V8
Xq_reg q VSS rst VDD_1V8 d clk DLHRQHDLLX0
.ENDS

.SUBCKT tristategate_43 input_x enable output_x VSS VDD_1V8
Xoutput_x_tri VSS enable VDD_1V8 input_x output_x BTHHDLLX2
.ENDS

.SUBCKT latch_43 clk d q rst VSS VDD_1V8
Xq_reg q VSS rst VDD_1V8 d clk DLHRQHDLLX0
.ENDS

.SUBCKT tristategate_42 input_x enable output_x VSS VDD_1V8
Xoutput_x_tri VSS enable VDD_1V8 input_x output_x BTHHDLLX2
.ENDS

.SUBCKT latch_42 clk d q rst VSS VDD_1V8
Xq_reg q VSS rst VDD_1V8 d clk DLHRQHDLLX0
.ENDS

.SUBCKT tristategate_41 input_x enable output_x VSS VDD_1V8
Xoutput_x_tri VSS enable VDD_1V8 input_x output_x BTHHDLLX2
.ENDS

.SUBCKT latch_41 clk d q rst VSS VDD_1V8
Xq_reg q VSS rst VDD_1V8 d clk DLHRQHDLLX0
.ENDS

.SUBCKT tristategate_40 input_x enable output_x VSS VDD_1V8
Xoutput_x_tri VSS enable VDD_1V8 input_x output_x BTHHDLLX2
.ENDS

.SUBCKT latch_40 clk d q rst VSS VDD_1V8
Xq_reg q VSS rst VDD_1V8 d clk DLHRQHDLLX0
.ENDS

.SUBCKT tristategate_39 input_x enable output_x VSS VDD_1V8
Xoutput_x_tri VSS enable VDD_1V8 input_x output_x BTHHDLLX2
.ENDS

.SUBCKT latch_39 clk d q rst VSS VDD_1V8
Xq_reg q VSS rst VDD_1V8 d clk DLHRQHDLLX0
.ENDS

.SUBCKT tristategate_38 input_x enable output_x VSS VDD_1V8
Xoutput_x_tri VSS enable VDD_1V8 input_x output_x BTHHDLLX2
.ENDS

.SUBCKT latch_38 clk d q rst VSS VDD_1V8
Xq_reg q VSS rst VDD_1V8 d clk DLHRQHDLLX0
.ENDS

.SUBCKT tristategate_37 input_x enable output_x VSS VDD_1V8
Xoutput_x_tri VSS enable VDD_1V8 input_x output_x BTHHDLLX2
.ENDS

.SUBCKT latch_37 clk d q rst VSS VDD_1V8
Xq_reg q VSS rst VDD_1V8 d clk DLHRQHDLLX0
.ENDS

.SUBCKT tristategate_36 input_x enable output_x VSS VDD_1V8
Xoutput_x_tri VSS enable VDD_1V8 input_x output_x BTHHDLLX1
.ENDS

.SUBCKT latch_36 clk d q rst VSS VDD_1V8
Xq_reg q VSS rst VDD_1V8 d clk DLHRQHDLLX0
.ENDS

.SUBCKT tristategate_35 input_x enable output_x VSS VDD_1V8
Xoutput_x_tri VSS enable VDD_1V8 input_x output_x BTHHDLLX1
.ENDS

.SUBCKT latch_35 clk d q rst VSS VDD_1V8
Xq_reg q VSS rst VDD_1V8 d clk DLHRQHDLLX0
.ENDS

.SUBCKT tristategate_34 input_x enable output_x VSS VDD_1V8
Xoutput_x_tri VSS enable VDD_1V8 input_x output_x BTHHDLLX1
.ENDS

.SUBCKT latch_34 clk d q rst VSS VDD_1V8
Xq_reg q VSS rst VDD_1V8 d clk DLHRQHDLLX0
.ENDS

.SUBCKT tristategate_33 input_x enable output_x VSS VDD_1V8
Xoutput_x_tri VSS enable VDD_1V8 input_x output_x BTHHDLLX1
.ENDS

.SUBCKT latch_33 clk d q rst VSS VDD_1V8
Xq_reg q VSS rst VDD_1V8 d clk DLHRQHDLLX0
.ENDS

.SUBCKT tristategate_32 input_x enable output_x VSS VDD_1V8
Xoutput_x_tri VSS enable VDD_1V8 input_x output_x BTHHDLLX1
.ENDS

.SUBCKT latch_32 clk d q rst VSS VDD_1V8
Xq_reg q VSS rst VDD_1V8 d clk DLHRQHDLLX0
.ENDS

.SUBCKT tristategate_31 input_x enable output_x VSS VDD_1V8
Xoutput_x_tri VSS enable VDD_1V8 input_x output_x BTHHDLLX1
.ENDS

.SUBCKT latch_31 clk d q rst VSS VDD_1V8
Xq_reg q VSS rst VDD_1V8 d clk DLHRQHDLLX0
.ENDS

.SUBCKT tristategate_30 input_x enable output_x VSS VDD_1V8
Xoutput_x_tri VSS enable VDD_1V8 input_x output_x BTHHDLLX1
.ENDS

.SUBCKT latch_30 clk d q rst VSS VDD_1V8
Xq_reg q VSS rst VDD_1V8 d clk DLHRQHDLLX0
.ENDS

.SUBCKT tristategate_29 input_x enable output_x VSS VDD_1V8
Xoutput_x_tri VSS enable VDD_1V8 input_x output_x BTHHDLLX1
.ENDS

.SUBCKT latch_29 clk d q rst VSS VDD_1V8
Xq_reg q VSS rst VDD_1V8 d clk DLHRQHDLLX0
.ENDS

.SUBCKT tristategate_28 input_x enable output_x VSS VDD_1V8
Xoutput_x_tri VSS enable VDD_1V8 input_x output_x BTHHDLLX1
.ENDS

.SUBCKT latch_28 clk d q rst VSS VDD_1V8
Xq_reg q VSS rst VDD_1V8 d clk DLHRQHDLLX0
.ENDS

.SUBCKT tristategate_27 input_x enable output_x VSS VDD_1V8
Xoutput_x_tri VSS enable VDD_1V8 input_x output_x BTHHDLLX1
.ENDS

.SUBCKT latch_27 clk d q rst VSS VDD_1V8
Xq_reg q VSS rst VDD_1V8 d clk DLHRQHDLLX0
.ENDS

.SUBCKT tristategate_26 input_x enable output_x VSS VDD_1V8
Xoutput_x_tri VSS enable VDD_1V8 input_x output_x BTHHDLLX1
.ENDS

.SUBCKT latch_26 clk d q rst VSS VDD_1V8
Xq_reg q VSS rst VDD_1V8 d clk DLHRQHDLLX0
.ENDS

.SUBCKT tristategate_25 input_x enable output_x VSS VDD_1V8
Xoutput_x_tri VSS enable VDD_1V8 input_x output_x BTHHDLLX1
.ENDS

.SUBCKT latch_25 clk d q rst VSS VDD_1V8
Xq_reg q VSS rst VDD_1V8 d clk DLHRQHDLLX0
.ENDS

.SUBCKT tristategate_24 input_x enable output_x VSS VDD_1V8
Xoutput_x_tri VSS enable VDD_1V8 input_x output_x BTHHDLLX1
.ENDS

.SUBCKT latch_24 clk d q rst VSS VDD_1V8
Xq_reg q VSS rst VDD_1V8 d clk DLHRQHDLLX0
.ENDS

.SUBCKT tristategate_23 input_x enable output_x VSS VDD_1V8
Xoutput_x_tri VSS enable VDD_1V8 input_x output_x BTHHDLLX1
.ENDS

.SUBCKT latch_23 clk d q rst VSS VDD_1V8
Xq_reg q VSS rst VDD_1V8 d clk DLHRQHDLLX0
.ENDS

.SUBCKT tristategate_22 input_x enable output_x VSS VDD_1V8
Xoutput_x_tri VSS enable VDD_1V8 input_x output_x BTHHDLLX1
.ENDS

.SUBCKT latch_22 clk d q rst VSS VDD_1V8
Xq_reg q VSS rst VDD_1V8 d clk DLHRQHDLLX0
.ENDS

.SUBCKT tristategate_21 input_x enable output_x VSS VDD_1V8
Xoutput_x_tri VSS enable VDD_1V8 input_x output_x BTHHDLLX1
.ENDS

.SUBCKT latch_21 clk d q rst VSS VDD_1V8
Xq_reg q VSS rst VDD_1V8 d clk DLHRQHDLLX0
.ENDS

.SUBCKT tristategate_20 input_x enable output_x VSS VDD_1V8
Xoutput_x_tri VSS enable VDD_1V8 input_x output_x BTHHDLLX1
.ENDS

.SUBCKT latch_20 clk d q rst VSS VDD_1V8
Xq_reg q VSS rst VDD_1V8 d clk DLHRQHDLLX0
.ENDS

.SUBCKT tristategate_19 input_x enable output_x VSS VDD_1V8
Xoutput_x_tri VSS enable VDD_1V8 input_x output_x BTHHDLLX2
.ENDS

.SUBCKT latch_19 clk d q rst VSS VDD_1V8
Xq_reg q VSS rst VDD_1V8 d clk DLHRQHDLLX0
.ENDS

.SUBCKT tristategate_18 input_x enable output_x VSS VDD_1V8
Xoutput_x_tri VSS enable VDD_1V8 input_x output_x BTHHDLLX2
.ENDS

.SUBCKT latch_18 clk d q rst VSS VDD_1V8
Xq_reg q VSS rst VDD_1V8 d clk DLHRQHDLLX0
.ENDS

.SUBCKT tristategate_17 input_x enable output_x VSS VDD_1V8
Xoutput_x_tri VSS enable VDD_1V8 input_x output_x BTHHDLLX2
.ENDS

.SUBCKT latch_17 clk d q rst VSS VDD_1V8
Xq_reg q VSS rst VDD_1V8 d clk DLHRQHDLLX0
.ENDS

.SUBCKT tristategate_16 input_x enable output_x VSS VDD_1V8
Xoutput_x_tri VSS enable VDD_1V8 input_x output_x BTHHDLLX2
.ENDS

.SUBCKT latch_16 clk d q rst VSS VDD_1V8
Xq_reg q VSS rst VDD_1V8 d clk DLHRQHDLLX0
.ENDS

.SUBCKT tristategate_15 input_x enable output_x VSS VDD_1V8
Xoutput_x_tri VSS enable VDD_1V8 input_x output_x BTHHDLLX2
.ENDS

.SUBCKT latch_15 clk d q rst VSS VDD_1V8
Xq_reg q VSS rst VDD_1V8 d clk DLHRQHDLLX0
.ENDS

.SUBCKT tristategate_14 input_x enable output_x VSS VDD_1V8
Xoutput_x_tri VSS enable VDD_1V8 input_x output_x BTHHDLLX2
.ENDS

.SUBCKT latch_14 clk d q rst VSS VDD_1V8
Xq_reg q VSS rst VDD_1V8 d clk DLHRQHDLLX0
.ENDS

.SUBCKT tristategate_13 input_x enable output_x VSS VDD_1V8
Xoutput_x_tri VSS enable VDD_1V8 input_x output_x BTHHDLLX2
.ENDS

.SUBCKT latch_13 clk d q rst VSS VDD_1V8
Xq_reg q VSS rst VDD_1V8 d clk DLHRQHDLLX0
.ENDS

.SUBCKT tristategate_12 input_x enable output_x VSS VDD_1V8
Xoutput_x_tri VSS enable VDD_1V8 input_x output_x BTHHDLLX2
.ENDS

.SUBCKT latch_12 clk d q rst VSS VDD_1V8
Xq_reg q VSS rst VDD_1V8 d clk DLHRQHDLLX0
.ENDS

.SUBCKT tristategate_11 input_x enable output_x VSS VDD_1V8
Xoutput_x_tri VSS enable VDD_1V8 input_x output_x BTHHDLLX2
.ENDS

.SUBCKT latch_11 clk d q rst VSS VDD_1V8
Xq_reg q VSS rst VDD_1V8 d clk DLHRQHDLLX0
.ENDS

.SUBCKT tristategate_10 input_x enable output_x VSS VDD_1V8
Xoutput_x_tri VSS enable VDD_1V8 input_x output_x BTHHDLLX2
.ENDS

.SUBCKT latch_10 clk d q rst VSS VDD_1V8
Xq_reg q VSS rst VDD_1V8 d clk DLHRQHDLLX0
.ENDS

.SUBCKT tristategate_9 input_x enable output_x VSS VDD_1V8
Xoutput_x_tri VSS enable VDD_1V8 input_x output_x BTHHDLLX2
.ENDS

.SUBCKT latch_9 clk d q rst VSS VDD_1V8
Xq_reg q VSS rst VDD_1V8 d clk DLHRQHDLLX0
.ENDS

.SUBCKT tristategate_8 input_x enable output_x VSS VDD_1V8
Xoutput_x_tri VSS enable VDD_1V8 input_x output_x BTHHDLLX2
.ENDS

.SUBCKT latch_8 clk d q rst VSS VDD_1V8
Xq_reg q VSS rst VDD_1V8 d clk DLHRQHDLLX0
.ENDS

.SUBCKT tristategate_7 input_x enable output_x VSS VDD_1V8
Xoutput_x_tri VSS enable VDD_1V8 input_x output_x BTHHDLLX2
.ENDS

.SUBCKT latch_7 clk d q rst VSS VDD_1V8
Xq_reg q VSS rst VDD_1V8 d clk DLHRQHDLLX0
.ENDS

.SUBCKT tristategate_6 input_x enable output_x VSS VDD_1V8
Xoutput_x_tri VSS enable VDD_1V8 input_x output_x BTHHDLLX2
.ENDS

.SUBCKT latch_6 clk d q rst VSS VDD_1V8
Xq_reg q VSS rst VDD_1V8 d clk DLHRQHDLLX0
.ENDS

.SUBCKT tristategate_5 input_x enable output_x VSS VDD_1V8
Xoutput_x_tri VSS enable VDD_1V8 input_x output_x BTHHDLLX2
.ENDS

.SUBCKT latch_5 clk d q rst VSS VDD_1V8
Xq_reg q VSS rst VDD_1V8 d clk DLHRQHDLLX0
.ENDS

.SUBCKT tristategate_4 input_x enable output_x VSS VDD_1V8
Xoutput_x_tri VSS enable VDD_1V8 input_x output_x BTHHDLLX2
.ENDS

.SUBCKT latch_4 clk d q rst VSS VDD_1V8
Xq_reg q VSS rst VDD_1V8 d clk DLHRQHDLLX0
.ENDS

.SUBCKT tristategate_3 input_x enable output_x VSS VDD_1V8
Xoutput_x_tri VSS enable VDD_1V8 input_x output_x BTHHDLLX1
.ENDS

.SUBCKT latch_3 clk d q rst VSS VDD_1V8
Xq_reg q VSS rst VDD_1V8 d clk DLHRQHDLLX0
.ENDS

.SUBCKT tristategate_2 input_x enable output_x VSS VDD_1V8
Xoutput_x_tri VSS enable VDD_1V8 input_x output_x BTHHDLLX1
.ENDS

.SUBCKT latch_2 clk d q rst VSS VDD_1V8
Xq_reg q VSS rst VDD_1V8 d clk DLHRQHDLLX0
.ENDS

.SUBCKT tristategate_1 input_x enable output_x VSS VDD_1V8
Xoutput_x_tri VSS enable VDD_1V8 input_x output_x BTHHDLLX1
.ENDS

.SUBCKT latch_1 clk d q rst VSS VDD_1V8
Xq_reg q VSS rst VDD_1V8 d clk DLHRQHDLLX0
.ENDS

.SUBCKT tristategate_0 input_x enable output_x VSS VDD_1V8
Xoutput_x_tri VSS enable VDD_1V8 input_x output_x BTHHDLLX1
.ENDS

.SUBCKT latch_0 clk d q rst VSS VDD_1V8
Xq_reg q VSS rst VDD_1V8 d clk DLHRQHDLLX0
.ENDS

.SUBCKT tristategate_278 input_x enable output_x VSS VDD_1V8
XU1 n6 VSS VDD_1V8 LOGIC0HDLL
Xoutput_x_tri VSS enable VDD_1V8 n6 output_x BTHHDLLX1
.ENDS

.SUBCKT tristategate_277 input_x enable output_x VSS VDD_1V8
XU1 n6 VSS VDD_1V8 LOGIC0HDLL
Xoutput_x_tri VSS enable VDD_1V8 n6 output_x BTHHDLLX1
.ENDS

.SUBCKT tristategate_276 input_x enable output_x VSS VDD_1V8
XU1 n6 VSS VDD_1V8 LOGIC0HDLL
Xoutput_x_tri VSS enable VDD_1V8 n6 output_x BTHHDLLX1
.ENDS

.SUBCKT tristategate_275 input_x enable output_x VSS VDD_1V8
XU1 n6 VSS VDD_1V8 LOGIC0HDLL
Xoutput_x_tri VSS enable VDD_1V8 n6 output_x BTHHDLLX1
.ENDS

.SUBCKT tristategate_274 input_x enable output_x VSS VDD_1V8
XU1 n6 VSS VDD_1V8 LOGIC0HDLL
Xoutput_x_tri VSS enable VDD_1V8 n6 output_x BTHHDLLX1
.ENDS

.SUBCKT tristategate_273 input_x enable output_x VSS VDD_1V8
XU1 n6 VSS VDD_1V8 LOGIC0HDLL
Xoutput_x_tri VSS enable VDD_1V8 n6 output_x BTHHDLLX1
.ENDS

.SUBCKT tristategate_272 input_x enable output_x VSS VDD_1V8
XU1 n6 VSS VDD_1V8 LOGIC0HDLL
Xoutput_x_tri VSS enable VDD_1V8 n6 output_x BTHHDLLX1
.ENDS

.SUBCKT tristategate_271 input_x enable output_x VSS VDD_1V8
XU1 n6 VSS VDD_1V8 LOGIC0HDLL
Xoutput_x_tri VSS enable VDD_1V8 n6 output_x BTHHDLLX1
.ENDS

.SUBCKT tristategate_270 input_x enable output_x VSS VDD_1V8
XU1 n6 VSS VDD_1V8 LOGIC0HDLL
Xoutput_x_tri VSS enable VDD_1V8 n6 output_x BTHHDLLX1
.ENDS

.SUBCKT tristategate_269 input_x enable output_x VSS VDD_1V8
XU1 n6 VSS VDD_1V8 LOGIC0HDLL
Xoutput_x_tri VSS enable VDD_1V8 n6 output_x BTHHDLLX1
.ENDS

.SUBCKT tristategate_268 input_x enable output_x VSS VDD_1V8
XU1 n6 VSS VDD_1V8 LOGIC0HDLL
Xoutput_x_tri VSS enable VDD_1V8 n6 output_x BTHHDLLX1
.ENDS

.SUBCKT tristategate_267 input_x enable output_x VSS VDD_1V8
XU1 n6 VSS VDD_1V8 LOGIC0HDLL
Xoutput_x_tri VSS enable VDD_1V8 n6 output_x BTHHDLLX1
.ENDS

.SUBCKT tristategate_266 input_x enable output_x VSS VDD_1V8
XU1 n6 VSS VDD_1V8 LOGIC0HDLL
Xoutput_x_tri VSS enable VDD_1V8 n6 output_x BTHHDLLX2
.ENDS

.SUBCKT tristategate_265 input_x enable output_x VSS VDD_1V8
XU1 n6 VSS VDD_1V8 LOGIC0HDLL
Xoutput_x_tri VSS enable VDD_1V8 n6 output_x BTHHDLLX2
.ENDS

.SUBCKT tristategate_264 input_x enable output_x VSS VDD_1V8
XU1 n6 VSS VDD_1V8 LOGIC0HDLL
Xoutput_x_tri VSS enable VDD_1V8 n6 output_x BTHHDLLX2
.ENDS

.SUBCKT tristategate_263 input_x enable output_x VSS VDD_1V8
XU1 n6 VSS VDD_1V8 LOGIC0HDLL
Xoutput_x_tri VSS enable VDD_1V8 n6 output_x BTHHDLLX2
.ENDS

.SUBCKT tristategate_262 input_x enable output_x VSS VDD_1V8
XU1 n6 VSS VDD_1V8 LOGIC0HDLL
Xoutput_x_tri VSS enable VDD_1V8 n6 output_x BTHHDLLX2
.ENDS

.SUBCKT tristategate_261 input_x enable output_x VSS VDD_1V8
XU1 n6 VSS VDD_1V8 LOGIC0HDLL
Xoutput_x_tri VSS enable VDD_1V8 n6 output_x BTHHDLLX2
.ENDS

.SUBCKT tristategate_260 input_x enable output_x VSS VDD_1V8
XU1 n6 VSS VDD_1V8 LOGIC0HDLL
Xoutput_x_tri VSS enable VDD_1V8 n6 output_x BTHHDLLX2
.ENDS

.SUBCKT tristategate_259 input_x enable output_x VSS VDD_1V8
XU1 n6 VSS VDD_1V8 LOGIC0HDLL
Xoutput_x_tri VSS enable VDD_1V8 n6 output_x BTHHDLLX2
.ENDS

.SUBCKT tristategate_258 input_x enable output_x VSS VDD_1V8
XU1 n6 VSS VDD_1V8 LOGIC0HDLL
Xoutput_x_tri VSS enable VDD_1V8 n6 output_x BTHHDLLX2
.ENDS

.SUBCKT tristategate_257 input_x enable output_x VSS VDD_1V8
XU1 n6 VSS VDD_1V8 LOGIC0HDLL
Xoutput_x_tri VSS enable VDD_1V8 n6 output_x BTHHDLLX2
.ENDS

.SUBCKT tristategate_256 input_x enable output_x VSS VDD_1V8
XU1 n6 VSS VDD_1V8 LOGIC0HDLL
Xoutput_x_tri VSS enable VDD_1V8 n6 output_x BTHHDLLX2
.ENDS

.SUBCKT tristategate_255 input_x enable output_x VSS VDD_1V8
XU1 n6 VSS VDD_1V8 LOGIC0HDLL
Xoutput_x_tri VSS enable VDD_1V8 n6 output_x BTHHDLLX2
.ENDS

.SUBCKT tristategate_254 input_x enable output_x VSS VDD_1V8
XU1 n6 VSS VDD_1V8 LOGIC0HDLL
Xoutput_x_tri VSS enable VDD_1V8 n6 output_x BTHHDLLX2
.ENDS

.SUBCKT tristategate_253 input_x enable output_x VSS VDD_1V8
XU1 n6 VSS VDD_1V8 LOGIC0HDLL
Xoutput_x_tri VSS enable VDD_1V8 n6 output_x BTHHDLLX2
.ENDS

.SUBCKT tristategate_252 input_x enable output_x VSS VDD_1V8
XU1 n6 VSS VDD_1V8 LOGIC0HDLL
Xoutput_x_tri VSS enable VDD_1V8 n6 output_x BTHHDLLX2
.ENDS

.SUBCKT tristategate_251 input_x enable output_x VSS VDD_1V8
XU1 n6 VSS VDD_1V8 LOGIC0HDLL
Xoutput_x_tri VSS enable VDD_1V8 n6 output_x BTHHDLLX2
.ENDS

.SUBCKT latch_entrada clk d[31] d[30] d[29] d[28] d[27] d[26] d[25] d[24] d[23] d[22]
+ d[21] d[20] d[19] d[18] d[17] d[16] d[15] d[14] d[13] d[12] d[11] d[10] d[9] d[8]
+ d[7] d[6] d[5] d[4] d[3] d[2] d[1] d[0] q[31] q[30] q[29] q[28] q[27] q[26] q[25]
+ q[24] q[23] q[22] q[21] q[20] q[19] q[18] q[17] q[16] q[15] q[14] q[13] q[12]
+ q[11] q[10] q[9] q[8] q[7] q[6] q[5] q[4] q[3] q[2] q[1] q[0] VSS VDD_1V8
Xq_reg_5_ q[5] VSS VDD_1V8 d[5] clk DLHQHDLLX0
Xq_reg_7_ q[7] VSS VDD_1V8 d[7] clk DLHQHDLLX1
Xq_reg_30_ q[30] VSS VDD_1V8 d[30] clk DLHQHDLLX0
Xq_reg_6_ q[6] VSS VDD_1V8 d[6] clk DLHQHDLLX1
Xq_reg_8_ q[8] VSS VDD_1V8 d[8] clk DLHQHDLLX0
Xq_reg_12_ q[12] VSS VDD_1V8 d[12] clk DLHQHDLLX0
Xq_reg_31_ q[31] VSS VDD_1V8 d[31] clk DLHQHDLLX0
Xq_reg_1_ q[1] VSS VDD_1V8 d[1] clk DLHQHDLLX0
Xq_reg_29_ q[29] VSS VDD_1V8 d[29] clk DLHQHDLLX0
Xq_reg_9_ q[9] VSS VDD_1V8 d[9] clk DLHQHDLLX0
Xq_reg_0_ q[0] VSS VDD_1V8 d[0] clk DLHQHDLLX0
Xq_reg_11_ q[11] VSS VDD_1V8 d[11] clk DLHQHDLLX0
Xq_reg_10_ q[10] VSS VDD_1V8 d[10] clk DLHQHDLLX0
Xq_reg_28_ q[28] VSS VDD_1V8 d[28] clk DLHQHDLLX0
Xq_reg_26_ q[26] VSS VDD_1V8 d[26] clk DLHQHDLLX0
Xq_reg_25_ q[25] VSS VDD_1V8 d[25] clk DLHQHDLLX0
Xq_reg_27_ q[27] VSS VDD_1V8 d[27] clk DLHQHDLLX0
Xq_reg_24_ q[24] VSS VDD_1V8 d[24] clk DLHQHDLLX1
Xq_reg_16_ q[16] VSS VDD_1V8 d[16] clk DLHQHDLLX0
Xq_reg_15_ q[15] VSS VDD_1V8 d[15] clk DLHQHDLLX0
Xq_reg_22_ q[22] VSS VDD_1V8 d[22] clk DLHQHDLLX0
Xq_reg_13_ q[13] VSS VDD_1V8 d[13] clk DLHQHDLLX0
Xq_reg_23_ q[23] VSS VDD_1V8 d[23] clk DLHQHDLLX0
Xq_reg_14_ q[14] VSS VDD_1V8 d[14] clk DLHQHDLLX1
Xq_reg_19_ q[19] VSS VDD_1V8 d[19] clk DLHQHDLLX1
Xq_reg_21_ q[21] VSS VDD_1V8 d[21] clk DLHQHDLLX0
Xq_reg_17_ q[17] VSS VDD_1V8 d[17] clk DLHQHDLLX1
Xq_reg_18_ q[18] VSS VDD_1V8 d[18] clk DLHQHDLLX1
Xq_reg_20_ q[20] VSS VDD_1V8 d[20] clk DLHQHDLLX0
Xq_reg_3_ q[3] VSS VDD_1V8 d[3] clk DLHQHDLLX0
Xq_reg_4_ q[4] VSS VDD_1V8 d[4] clk DLHQHDLLX0
Xq_reg_2_ q[2] VSS VDD_1V8 d[2] clk DLHQHDLLX0
.ENDS

.SUBCKT dff_async_rst_1323 data clk reset q VSS VDD_1V8
Xq_reg reset clk data q VSS VDD_1V8 DFRRQHDLLX0
.ENDS

.SUBCKT dff_async_rst_1322 data clk reset q VSS VDD_1V8
Xq_reg reset clk data q VSS VDD_1V8 DFRRQHDLLX0
.ENDS

.SUBCKT dff_async_rst_1321 data clk reset q VSS VDD_1V8
Xq_reg reset clk data q VSS VDD_1V8 DFRRQHDLLX0
.ENDS

.SUBCKT dff_async_rst_1320 data clk reset q VSS VDD_1V8
Xq_reg reset clk data q VSS VDD_1V8 DFRRQHDLLX0
.ENDS

.SUBCKT dff_async_rst_1319 data clk reset q VSS VDD_1V8
Xq_reg reset clk data q VSS VDD_1V8 DFRRQHDLLX0
.ENDS

.SUBCKT dff_async_rst_1318 data clk reset q VSS VDD_1V8
Xq_reg reset clk data q VSS VDD_1V8 DFRRQHDLLX0
.ENDS

.SUBCKT dff_async_rst_1317 data clk reset q VSS VDD_1V8
Xq_reg reset clk data q VSS VDD_1V8 DFRRQHDLLX0
.ENDS

.SUBCKT dff_async_rst_1316 data clk reset q VSS VDD_1V8
Xq_reg reset clk data q VSS VDD_1V8 DFRRQHDLLX0
.ENDS

.SUBCKT dff_async_rst_1315 data clk reset q VSS VDD_1V8
Xq_reg reset clk data q VSS VDD_1V8 DFRRQHDLLX0
.ENDS

.SUBCKT dff_async_rst_1314 data clk reset q VSS VDD_1V8
Xq_reg reset clk data q VSS VDD_1V8 DFRRQHDLLX0
.ENDS

.SUBCKT dff_async_rst_1313 data clk reset q VSS VDD_1V8
Xq_reg reset clk data q VSS VDD_1V8 DFRRQHDLLX0
.ENDS

.SUBCKT dff_async_rst_1312 data clk reset q VSS VDD_1V8
Xq_reg reset clk data q VSS VDD_1V8 DFRRQHDLLX0
.ENDS

.SUBCKT dff_async_rst_1311 data clk reset q VSS VDD_1V8
Xq_reg reset clk data q VSS VDD_1V8 DFRRQHDLLX0
.ENDS

.SUBCKT dff_async_rst_1310 data clk reset q VSS VDD_1V8
Xq_reg reset clk data q VSS VDD_1V8 DFRRQHDLLX0
.ENDS

.SUBCKT dff_async_rst_1309 data clk reset q VSS VDD_1V8
Xq_reg reset clk data q VSS VDD_1V8 DFRRQHDLLX0
.ENDS

.SUBCKT dff_async_rst_1308 data clk reset q VSS VDD_1V8
Xq_reg reset clk data q VSS VDD_1V8 DFRRQHDLLX0
.ENDS

.SUBCKT dff_async_rst_1307 data clk reset q VSS VDD_1V8
Xq_reg reset clk data q VSS VDD_1V8 DFRRQHDLLX0
.ENDS

.SUBCKT dff_async_rst_1306 data clk reset q VSS VDD_1V8
Xq_reg reset clk data q VSS VDD_1V8 DFRRQHDLLX0
.ENDS

.SUBCKT dff_async_rst_1305 data clk reset q VSS VDD_1V8
Xq_reg reset clk data q VSS VDD_1V8 DFRRQHDLLX0
.ENDS

.SUBCKT dff_async_rst_1304 data clk reset q VSS VDD_1V8
Xq_reg reset clk data q VSS VDD_1V8 DFRRQHDLLX0
.ENDS

.SUBCKT dff_async_rst_1303 data clk reset q VSS VDD_1V8
Xq_reg reset clk data q VSS VDD_1V8 DFRRQHDLLX0
.ENDS

.SUBCKT dff_async_rst_1302 data clk reset q VSS VDD_1V8
Xq_reg reset clk data q VSS VDD_1V8 DFRRQHDLLX0
.ENDS

.SUBCKT dff_async_rst_1301 data clk reset q VSS VDD_1V8
Xq_reg reset clk data q VSS VDD_1V8 DFRRQHDLLX0
.ENDS

.SUBCKT dff_async_rst_1300 data clk reset q VSS VDD_1V8
Xq_reg reset clk data q VSS VDD_1V8 DFRRQHDLLX0
.ENDS

.SUBCKT dff_async_rst_1299 data clk reset q VSS VDD_1V8
Xq_reg reset clk data q VSS VDD_1V8 DFRRQHDLLX0
.ENDS

.SUBCKT dff_async_rst_1298 data clk reset q VSS VDD_1V8
Xq_reg reset clk data q VSS VDD_1V8 DFRRQHDLLX0
.ENDS

.SUBCKT dff_async_rst_1297 data clk reset q VSS VDD_1V8
Xq_reg reset clk data q VSS VDD_1V8 DFRRQHDLLX0
.ENDS

.SUBCKT dff_async_rst_1296 data clk reset q VSS VDD_1V8
Xq_reg reset clk data q VSS VDD_1V8 DFRRQHDLLX0
.ENDS

.SUBCKT dff_async_rst_1295 data clk reset q VSS VDD_1V8
Xq_reg reset clk data q VSS VDD_1V8 DFRRQHDLLX0
.ENDS

.SUBCKT dff_async_rst_1294 data clk reset q VSS VDD_1V8
Xq_reg reset clk data q VSS VDD_1V8 DFRRQHDLLX0
.ENDS

.SUBCKT dff_async_rst_1293 data clk reset q VSS VDD_1V8
Xq_reg reset clk data q VSS VDD_1V8 DFRRQHDLLX0
.ENDS

.SUBCKT dff_async_rst_1292 data clk reset q VSS VDD_1V8
Xq_reg reset clk data q VSS VDD_1V8 DFRRQHDLLX0
.ENDS

.SUBCKT dff_async_rst_1291 data clk reset q VSS VDD_1V8
Xq_reg reset clk data q VSS VDD_1V8 DFRRQHDLLX0
.ENDS

.SUBCKT dff_async_rst_1290 data clk reset q VSS VDD_1V8
Xq_reg reset clk data q VSS VDD_1V8 DFRRQHDLLX0
.ENDS

.SUBCKT dff_async_rst_1289 data clk reset q VSS VDD_1V8
Xq_reg reset clk data q VSS VDD_1V8 DFRRQHDLLX0
.ENDS

.SUBCKT dff_async_rst_1288 data clk reset q VSS VDD_1V8
Xq_reg reset clk data q VSS VDD_1V8 DFRRQHDLLX0
.ENDS

.SUBCKT dff_async_rst_1287 data clk reset q VSS VDD_1V8
Xq_reg reset clk data q VSS VDD_1V8 DFRRQHDLLX0
.ENDS

.SUBCKT dff_async_rst_1286 data clk reset q VSS VDD_1V8
Xq_reg reset clk data q VSS VDD_1V8 DFRRQHDLLX0
.ENDS

.SUBCKT dff_async_rst_1285 data clk reset q VSS VDD_1V8
Xq_reg reset clk data q VSS VDD_1V8 DFRRQHDLLX0
.ENDS

.SUBCKT dff_async_rst_1284 data clk reset q VSS VDD_1V8
Xq_reg reset clk data q VSS VDD_1V8 DFRRQHDLLX0
.ENDS

.SUBCKT dff_async_rst_1283 data clk reset q VSS VDD_1V8
Xq_reg reset clk data q VSS VDD_1V8 DFRRQHDLLX0
.ENDS

.SUBCKT dff_async_rst_1282 data clk reset q VSS VDD_1V8
Xq_reg reset clk data q VSS VDD_1V8 DFRRQHDLLX0
.ENDS

.SUBCKT dff_async_rst_1281 data clk reset q VSS VDD_1V8
Xq_reg reset clk data q VSS VDD_1V8 DFRRQHDLLX0
.ENDS

.SUBCKT dff_async_rst_1280 data clk reset q VSS VDD_1V8
Xq_reg reset clk data q VSS VDD_1V8 DFRRQHDLLX0
.ENDS

.SUBCKT dff_async_rst_1279 data clk reset q VSS VDD_1V8
Xq_reg reset clk data q VSS VDD_1V8 DFRRQHDLLX0
.ENDS

.SUBCKT dff_async_rst_1278 data clk reset q VSS VDD_1V8
Xq_reg reset clk data q VSS VDD_1V8 DFRRQHDLLX0
.ENDS

.SUBCKT dff_async_rst_1277 data clk reset q VSS VDD_1V8
Xq_reg reset clk data q VSS VDD_1V8 DFRRQHDLLX0
.ENDS

.SUBCKT dff_async_rst_1276 data clk reset q VSS VDD_1V8
Xq_reg reset clk data q VSS VDD_1V8 DFRRQHDLLX0
.ENDS

.SUBCKT dff_async_rst_1275 data clk reset q VSS VDD_1V8
Xq_reg reset clk data q VSS VDD_1V8 DFRRQHDLLX0
.ENDS

.SUBCKT dff_async_rst_1274 data clk reset q VSS VDD_1V8
Xq_reg reset clk data q VSS VDD_1V8 DFRRQHDLLX0
.ENDS

.SUBCKT dff_async_rst_1273 data clk reset q VSS VDD_1V8
Xq_reg reset clk data q VSS VDD_1V8 DFRRQHDLLX0
.ENDS

.SUBCKT dff_async_rst_1272 data clk reset q VSS VDD_1V8
Xq_reg reset clk data q VSS VDD_1V8 DFRRQHDLLX0
.ENDS

.SUBCKT dff_async_rst_1271 data clk reset q VSS VDD_1V8
Xq_reg reset clk data q VSS VDD_1V8 DFRRQHDLLX0
.ENDS

.SUBCKT dff_async_rst_1270 data clk reset q VSS VDD_1V8
Xq_reg reset clk data q VSS VDD_1V8 DFRRQHDLLX0
.ENDS

.SUBCKT dff_async_rst_1269 data clk reset q VSS VDD_1V8
Xq_reg reset clk data q VSS VDD_1V8 DFRRQHDLLX0
.ENDS

.SUBCKT dff_async_rst_1268 data clk reset q VSS VDD_1V8
Xq_reg reset clk data q VSS VDD_1V8 DFRRQHDLLX0
.ENDS

.SUBCKT dff_async_rst_1267 data clk reset q VSS VDD_1V8
Xq_reg reset clk data q VSS VDD_1V8 DFRRQHDLLX0
.ENDS

.SUBCKT dff_async_rst_1266 data clk reset q VSS VDD_1V8
Xq_reg reset clk data q VSS VDD_1V8 DFRRQHDLLX0
.ENDS

.SUBCKT dff_async_rst_1265 data clk reset q VSS VDD_1V8
Xq_reg reset clk data q VSS VDD_1V8 DFRRQHDLLX0
.ENDS

.SUBCKT dff_async_rst_1264 data clk reset q VSS VDD_1V8
Xq_reg reset clk data q VSS VDD_1V8 DFRRQHDLLX0
.ENDS

.SUBCKT dff_async_rst_1263 data clk reset q VSS VDD_1V8
Xq_reg reset clk data q VSS VDD_1V8 DFRRQHDLLX0
.ENDS

.SUBCKT dff_async_rst_1262 data clk reset q VSS VDD_1V8
Xq_reg reset clk data q VSS VDD_1V8 DFRRQHDLLX0
.ENDS

.SUBCKT dff_async_rst_1261 data clk reset q VSS VDD_1V8
Xq_reg reset clk data q VSS VDD_1V8 DFRRQHDLLX0
.ENDS

.SUBCKT dff_async_rst_1260 data clk reset q VSS VDD_1V8
Xq_reg reset clk data q VSS VDD_1V8 DFRRQHDLLX0
.ENDS

.SUBCKT dff_async_rst_1259 data clk reset q VSS VDD_1V8
Xq_reg reset clk data q VSS VDD_1V8 DFRRQHDLLX0
.ENDS

.SUBCKT dff_async_rst_1258 data clk reset q VSS VDD_1V8
Xq_reg reset clk data q VSS VDD_1V8 DFRRQHDLLX0
.ENDS

.SUBCKT dff_async_rst_1257 data clk reset q VSS VDD_1V8
Xq_reg reset clk data q VSS VDD_1V8 DFRRQHDLLX0
.ENDS

.SUBCKT dff_async_rst_1256 data clk reset q VSS VDD_1V8
Xq_reg reset clk data q VSS VDD_1V8 DFRRQHDLLX0
.ENDS

.SUBCKT dff_async_rst_1255 data clk reset q VSS VDD_1V8
Xq_reg reset clk data q VSS VDD_1V8 DFRRQHDLLX0
.ENDS

.SUBCKT dff_async_rst_1254 data clk reset q VSS VDD_1V8
Xq_reg reset clk data q VSS VDD_1V8 DFRRQHDLLX0
.ENDS

.SUBCKT dff_async_rst_1253 data clk reset q VSS VDD_1V8
Xq_reg reset clk data q VSS VDD_1V8 DFRRQHDLLX0
.ENDS

.SUBCKT dff_async_rst_1252 data clk reset q VSS VDD_1V8
Xq_reg reset clk data q VSS VDD_1V8 DFRRQHDLLX0
.ENDS

.SUBCKT dff_async_rst_1251 data clk reset q VSS VDD_1V8
Xq_reg reset clk data q VSS VDD_1V8 DFRRQHDLLX0
.ENDS

.SUBCKT dff_async_rst_1250 data clk reset q VSS VDD_1V8
Xq_reg reset clk data q VSS VDD_1V8 DFRRQHDLLX0
.ENDS

.SUBCKT dff_async_rst_1249 data clk reset q VSS VDD_1V8
Xq_reg reset clk data q VSS VDD_1V8 DFRRQHDLLX0
.ENDS

.SUBCKT dff_async_rst_1248 data clk reset q VSS VDD_1V8
Xq_reg reset clk data q VSS VDD_1V8 DFRRQHDLLX0
.ENDS

.SUBCKT dff_async_rst_1247 data clk reset q VSS VDD_1V8
Xq_reg reset clk data q VSS VDD_1V8 DFRRQHDLLX0
.ENDS

.SUBCKT dff_async_rst_1246 data clk reset q VSS VDD_1V8
Xq_reg reset clk data q VSS VDD_1V8 DFRRQHDLLX0
.ENDS

.SUBCKT dff_async_rst_1245 data clk reset q VSS VDD_1V8
Xq_reg reset clk data q VSS VDD_1V8 DFRRQHDLLX0
.ENDS

.SUBCKT dff_async_rst_1244 data clk reset q VSS VDD_1V8
Xq_reg reset clk data q VSS VDD_1V8 DFRRQHDLLX0
.ENDS

.SUBCKT dff_async_rst_1243 data clk reset q VSS VDD_1V8
Xq_reg reset clk data q VSS VDD_1V8 DFRRQHDLLX0
.ENDS

.SUBCKT dff_async_rst_1242 data clk reset q VSS VDD_1V8
Xq_reg reset clk data q VSS VDD_1V8 DFRRQHDLLX0
.ENDS

.SUBCKT dff_async_rst_1241 data clk reset q VSS VDD_1V8
Xq_reg reset clk data q VSS VDD_1V8 DFRRQHDLLX0
.ENDS

.SUBCKT dff_async_rst_1240 data clk reset q VSS VDD_1V8
Xq_reg reset clk data q VSS VDD_1V8 DFRRQHDLLX0
.ENDS

.SUBCKT dff_async_rst_1239 data clk reset q VSS VDD_1V8
Xq_reg reset clk data q VSS VDD_1V8 DFRRQHDLLX0
.ENDS

.SUBCKT dff_async_rst_1238 data clk reset q VSS VDD_1V8
Xq_reg reset clk data q VSS VDD_1V8 DFRRQHDLLX0
.ENDS

.SUBCKT dff_async_rst_1237 data clk reset q VSS VDD_1V8
Xq_reg reset clk data q VSS VDD_1V8 DFRRQHDLLX0
.ENDS

.SUBCKT dff_async_rst_1236 data clk reset q VSS VDD_1V8
Xq_reg reset clk data q VSS VDD_1V8 DFRRQHDLLX0
.ENDS

.SUBCKT dff_async_rst_1235 data clk reset q VSS VDD_1V8
Xq_reg reset clk data q VSS VDD_1V8 DFRRQHDLLX0
.ENDS

.SUBCKT dff_async_rst_1234 data clk reset q VSS VDD_1V8
Xq_reg reset clk data q VSS VDD_1V8 DFRRQHDLLX0
.ENDS

.SUBCKT dff_async_rst_1233 data clk reset q VSS VDD_1V8
Xq_reg reset clk data q VSS VDD_1V8 DFRRQHDLLX0
.ENDS

.SUBCKT dff_async_rst_1232 data clk reset q VSS VDD_1V8
Xq_reg reset clk data q VSS VDD_1V8 DFRRQHDLLX0
.ENDS

.SUBCKT dff_async_rst_1231 data clk reset q VSS VDD_1V8
Xq_reg reset clk data q VSS VDD_1V8 DFRRQHDLLX0
.ENDS

.SUBCKT dff_async_rst_1230 data clk reset q VSS VDD_1V8
Xq_reg reset clk data q VSS VDD_1V8 DFRRQHDLLX0
.ENDS

.SUBCKT dff_async_rst_1229 data clk reset q VSS VDD_1V8
Xq_reg reset clk data q VSS VDD_1V8 DFRRQHDLLX0
.ENDS

.SUBCKT dff_async_rst_1228 data clk reset q VSS VDD_1V8
Xq_reg reset clk data q VSS VDD_1V8 DFRRQHDLLX0
.ENDS

.SUBCKT dff_async_rst_1227 data clk reset q VSS VDD_1V8
Xq_reg reset clk data q VSS VDD_1V8 DFRRQHDLLX0
.ENDS

.SUBCKT dff_async_rst_1226 data clk reset q VSS VDD_1V8
Xq_reg reset clk data q VSS VDD_1V8 DFRRQHDLLX0
.ENDS

.SUBCKT dff_async_rst_1225 data clk reset q VSS VDD_1V8
Xq_reg reset clk data q VSS VDD_1V8 DFRRQHDLLX0
.ENDS

.SUBCKT dff_async_rst_1224 data clk reset q VSS VDD_1V8
Xq_reg reset clk data q VSS VDD_1V8 DFRRQHDLLX0
.ENDS

.SUBCKT dff_async_rst_1223 data clk reset q VSS VDD_1V8
Xq_reg reset clk data q VSS VDD_1V8 DFRRQHDLLX0
.ENDS

.SUBCKT dff_async_rst_1222 data clk reset q VSS VDD_1V8
Xq_reg reset clk data q VSS VDD_1V8 DFRRQHDLLX0
.ENDS

.SUBCKT dff_async_rst_1221 data clk reset q VSS VDD_1V8
Xq_reg reset clk data q VSS VDD_1V8 DFRRQHDLLX0
.ENDS

.SUBCKT dff_async_rst_1220 data clk reset q VSS VDD_1V8
Xq_reg reset clk data q VSS VDD_1V8 DFRRQHDLLX0
.ENDS

.SUBCKT dff_async_rst_1219 data clk reset q VSS VDD_1V8
Xq_reg reset clk data q VSS VDD_1V8 DFRRQHDLLX0
.ENDS

.SUBCKT dff_async_rst_1218 data clk reset q VSS VDD_1V8
Xq_reg reset clk data q VSS VDD_1V8 DFRRQHDLLX0
.ENDS

.SUBCKT dff_async_rst_1217 data clk reset q VSS VDD_1V8
Xq_reg reset clk data q VSS VDD_1V8 DFRRQHDLLX0
.ENDS

.SUBCKT dff_async_rst_1216 data clk reset q VSS VDD_1V8
Xq_reg reset clk data q VSS VDD_1V8 DFRRQHDLLX0
.ENDS

.SUBCKT dff_async_rst_1215 data clk reset q VSS VDD_1V8
Xq_reg reset clk data q VSS VDD_1V8 DFRRQHDLLX0
.ENDS

.SUBCKT dff_async_rst_1214 data clk reset q VSS VDD_1V8
Xq_reg reset clk data q VSS VDD_1V8 DFRRQHDLLX0
.ENDS

.SUBCKT dff_async_rst_1213 data clk reset q VSS VDD_1V8
Xq_reg reset clk data q VSS VDD_1V8 DFRRQHDLLX0
.ENDS

.SUBCKT dff_async_rst_1212 data clk reset q VSS VDD_1V8
Xq_reg reset clk data q VSS VDD_1V8 DFRRQHDLLX0
.ENDS

.SUBCKT dff_async_rst_1211 data clk reset q VSS VDD_1V8
Xq_reg reset clk data q VSS VDD_1V8 DFRRQHDLLX0
.ENDS

.SUBCKT dff_async_rst_1210 data clk reset q VSS VDD_1V8
Xq_reg reset clk data q VSS VDD_1V8 DFRRQHDLLX0
.ENDS

.SUBCKT dff_async_rst_1209 data clk reset q VSS VDD_1V8
Xq_reg reset clk data q VSS VDD_1V8 DFRRQHDLLX0
.ENDS

.SUBCKT dff_async_rst_1208 data clk reset q VSS VDD_1V8
Xq_reg reset clk data q VSS VDD_1V8 DFRRQHDLLX0
.ENDS

.SUBCKT dff_async_rst_1207 data clk reset q VSS VDD_1V8
Xq_reg reset clk data q VSS VDD_1V8 DFRRQHDLLX0
.ENDS

.SUBCKT dff_async_rst_1206 data clk reset q VSS VDD_1V8
Xq_reg reset clk data q VSS VDD_1V8 DFRRQHDLLX0
.ENDS

.SUBCKT dff_async_rst_1205 data clk reset q VSS VDD_1V8
Xq_reg reset clk data q VSS VDD_1V8 DFRRQHDLLX0
.ENDS

.SUBCKT dff_async_rst_1204 data clk reset q VSS VDD_1V8
Xq_reg reset clk data q VSS VDD_1V8 DFRRQHDLLX0
.ENDS

.SUBCKT dff_async_rst_1203 data clk reset q VSS VDD_1V8
Xq_reg reset clk data q VSS VDD_1V8 DFRRQHDLLX0
.ENDS

.SUBCKT dff_async_rst_1202 data clk reset q VSS VDD_1V8
Xq_reg reset clk data q VSS VDD_1V8 DFRRQHDLLX0
.ENDS

.SUBCKT dff_async_rst_1201 data clk reset q VSS VDD_1V8
Xq_reg reset clk data q VSS VDD_1V8 DFRRQHDLLX0
.ENDS

.SUBCKT dff_async_rst_1200 data clk reset q VSS VDD_1V8
Xq_reg reset clk data q VSS VDD_1V8 DFRRQHDLLX0
.ENDS

.SUBCKT dff_async_rst_1199 data clk reset q VSS VDD_1V8
Xq_reg reset clk data q VSS VDD_1V8 DFRRQHDLLX0
.ENDS

.SUBCKT dff_async_rst_1196 data clk reset q VSS VDD_1V8
Xq_reg reset clk data q VSS VDD_1V8 DFRRQHDLLX0
.ENDS

.SUBCKT dff_async_rst_1195 data clk reset q VSS VDD_1V8
Xq_reg reset clk data q VSS VDD_1V8 DFRRQHDLLX0
.ENDS

.SUBCKT dff_async_rst_1193 data clk reset q VSS VDD_1V8
Xq_reg reset clk data q VSS VDD_1V8 DFRRQHDLLX0
.ENDS

.SUBCKT Counter_arb_mx_cnt3_2 count[1] count[0] clk rst VSS VDD_1V8
XU5 VSS VDD_1V8 N7 count[0] count[1] NO2I1HDLLX0
XU4 VSS N6 count[1] count[0] VDD_1V8 NO2HDLLX0
Xcount_reg_1_ rst clk N7 count[1] VSS VDD_1V8 DFRRQHDLLX0
Xcount_reg_0_ rst clk N6 count[0] VSS VDD_1V8 DFRRQHDLLX0
.ENDS

.SUBCKT dff_async_rst_20 data clk reset q VSS VDD_1V8
Xq_reg reset clk data q VSS VDD_1V8 DFRRQHDLLX0
.ENDS

.SUBCKT dff_async_rst_19 data clk reset q VSS VDD_1V8
Xq_reg reset clk data q VSS VDD_1V8 DFRRQHDLLX0
.ENDS

.SUBCKT dff_async_rst_18 data clk reset q VSS VDD_1V8
Xq_reg reset clk data q VSS VDD_1V8 DFRRQHDLLX0
.ENDS

.SUBCKT dff_async_rst_17 data clk reset q VSS VDD_1V8
Xq_reg reset clk data q VSS VDD_1V8 DFRRQHDLLX0
.ENDS

.SUBCKT dff_async_rst_16 data clk reset q VSS VDD_1V8
Xq_reg reset clk data q VSS VDD_1V8 DFRRQHDLLX0
.ENDS

.SUBCKT dff_async_rst_15 data clk reset q VSS VDD_1V8
Xq_reg reset clk data q VSS VDD_1V8 DFRRQHDLLX0
.ENDS

.SUBCKT dff_async_rst_14 data clk reset q VSS VDD_1V8
Xq_reg reset clk data q VSS VDD_1V8 DFRRQHDLLX0
.ENDS

.SUBCKT tri_buf_5 a b en VSS VDD_1V8
Xb_tri VSS en VDD_1V8 a b BTHHDLLX1
.ENDS

.SUBCKT tri_buf_4 a b en VSS VDD_1V8
Xb_tri VSS en VDD_1V8 a b BTHHDLLX1
.ENDS

.SUBCKT tri_buf_200 a b en VSS VDD_1V8
Xb_tri VSS en VDD_1V8 a b BTHHDLLX1
.ENDS

.SUBCKT tri_buf_199 a b en VSS VDD_1V8
Xb_tri VSS en VDD_1V8 a b BTHHDLLX1
.ENDS

.SUBCKT tri_buf_198 a b en VSS VDD_1V8
Xb_tri VSS en VDD_1V8 a b BTHHDLLX1
.ENDS

.SUBCKT tri_buf_197 a b en VSS VDD_1V8
Xb_tri VSS en VDD_1V8 a b BTHHDLLX1
.ENDS

.SUBCKT tri_buf_196 a b en VSS VDD_1V8
Xb_tri VSS en VDD_1V8 a b BTHHDLLX1
.ENDS

.SUBCKT tri_buf_195 a b en VSS VDD_1V8
Xb_tri VSS en VDD_1V8 a b BTHHDLLX1
.ENDS

.SUBCKT tri_buf_194 a b en VSS VDD_1V8
Xb_tri VSS en VDD_1V8 a b BTHHDLLX1
.ENDS

.SUBCKT tri_buf_193 a b en VSS VDD_1V8
Xb_tri VSS en VDD_1V8 a b BTHHDLLX1
.ENDS

.SUBCKT tri_buf_192 a b en VSS VDD_1V8
Xb_tri VSS en VDD_1V8 a b BTHHDLLX1
.ENDS

.SUBCKT tri_buf_191 a b en VSS VDD_1V8
Xb_tri VSS en VDD_1V8 a b BTHHDLLX1
.ENDS

.SUBCKT tri_buf_190 a b en VSS VDD_1V8
Xb_tri VSS en VDD_1V8 a b BTHHDLLX1
.ENDS

.SUBCKT tri_buf_189 a b en VSS VDD_1V8
Xb_tri VSS en VDD_1V8 a b BTHHDLLX1
.ENDS

.SUBCKT tri_buf_188 a b en VSS VDD_1V8
Xb_tri VSS en VDD_1V8 a b BTHHDLLX1
.ENDS

.SUBCKT tri_buf_187 a b en VSS VDD_1V8
Xb_tri VSS en VDD_1V8 a b BTHHDLLX1
.ENDS

.SUBCKT tri_buf_186 a b en VSS VDD_1V8
Xb_tri VSS en VDD_1V8 a b BTHHDLLX1
.ENDS

.SUBCKT tri_buf_185 a b en VSS VDD_1V8
Xb_tri VSS en VDD_1V8 a b BTHHDLLX1
.ENDS

.SUBCKT tri_buf_184 a b en VSS VDD_1V8
Xb_tri VSS en VDD_1V8 a b BTHHDLLX1
.ENDS

.SUBCKT tri_buf_183 a b en VSS VDD_1V8
Xb_tri VSS en VDD_1V8 a b BTHHDLLX1
.ENDS

.SUBCKT tri_buf_182 a b en VSS VDD_1V8
Xb_tri VSS en VDD_1V8 a b BTHHDLLX1
.ENDS

.SUBCKT tri_buf_181 a b en VSS VDD_1V8
Xb_tri VSS en VDD_1V8 a b BTHHDLLX1
.ENDS

.SUBCKT tri_buf_180 a b en VSS VDD_1V8
Xb_tri VSS en VDD_1V8 a b BTHHDLLX1
.ENDS

.SUBCKT tri_buf_179 a b en VSS VDD_1V8
Xb_tri VSS en VDD_1V8 a b BTHHDLLX1
.ENDS

.SUBCKT tri_buf_178 a b en VSS VDD_1V8
Xb_tri VSS en VDD_1V8 a b BTHHDLLX1
.ENDS

.SUBCKT tri_buf_177 a b en VSS VDD_1V8
Xb_tri VSS en VDD_1V8 a b BTHHDLLX1
.ENDS

.SUBCKT tri_buf_176 a b en VSS VDD_1V8
Xb_tri VSS en VDD_1V8 a b BTHHDLLX1
.ENDS

.SUBCKT tri_buf_175 a b en VSS VDD_1V8
Xb_tri VSS en VDD_1V8 a b BTHHDLLX1
.ENDS

.SUBCKT tri_buf_174 a b en VSS VDD_1V8
Xb_tri VSS en VDD_1V8 a b BTHHDLLX1
.ENDS

.SUBCKT tri_buf_173 a b en VSS VDD_1V8
Xb_tri VSS en VDD_1V8 a b BTHHDLLX1
.ENDS

.SUBCKT tri_buf_172 a b en VSS VDD_1V8
Xb_tri VSS en VDD_1V8 a b BTHHDLLX1
.ENDS

.SUBCKT tri_buf_171 a b en VSS VDD_1V8
Xb_tri VSS en VDD_1V8 a b BTHHDLLX1
.ENDS

.SUBCKT tri_buf_170 a b en VSS VDD_1V8
Xb_tri VSS en VDD_1V8 a b BTHHDLLX1
.ENDS

.SUBCKT tri_buf_169 a b en VSS VDD_1V8
Xb_tri VSS en VDD_1V8 a b BTHHDLLX1
.ENDS

.SUBCKT tri_buf_168 a b en VSS VDD_1V8
Xb_tri VSS en VDD_1V8 a b BTHHDLLX1
.ENDS

.SUBCKT tri_buf_167 a b en VSS VDD_1V8
Xb_tri VSS en VDD_1V8 a b BTHHDLLX1
.ENDS

.SUBCKT tri_buf_166 a b en VSS VDD_1V8
Xb_tri VSS en VDD_1V8 a b BTHHDLLX1
.ENDS

.SUBCKT tri_buf_165 a b en VSS VDD_1V8
Xb_tri VSS en VDD_1V8 a b BTHHDLLX1
.ENDS

.SUBCKT tri_buf_164 a b en VSS VDD_1V8
Xb_tri VSS en VDD_1V8 a b BTHHDLLX1
.ENDS

.SUBCKT tri_buf_163 a b en VSS VDD_1V8
Xb_tri VSS en VDD_1V8 a b BTHHDLLX1
.ENDS

.SUBCKT tri_buf_162 a b en VSS VDD_1V8
Xb_tri VSS en VDD_1V8 a b BTHHDLLX1
.ENDS

.SUBCKT tri_buf_161 a b en VSS VDD_1V8
Xb_tri VSS en VDD_1V8 a b BTHHDLLX1
.ENDS

.SUBCKT tri_buf_160 a b en VSS VDD_1V8
Xb_tri VSS en VDD_1V8 a b BTHHDLLX1
.ENDS

.SUBCKT tri_buf_159 a b en VSS VDD_1V8
Xb_tri VSS en VDD_1V8 a b BTHHDLLX1
.ENDS

.SUBCKT tri_buf_158 a b en VSS VDD_1V8
Xb_tri VSS en VDD_1V8 a b BTHHDLLX1
.ENDS

.SUBCKT tri_buf_157 a b en VSS VDD_1V8
Xb_tri VSS en VDD_1V8 a b BTHHDLLX1
.ENDS

.SUBCKT tri_buf_156 a b en VSS VDD_1V8
Xb_tri VSS en VDD_1V8 a b BTHHDLLX1
.ENDS

.SUBCKT tri_buf_155 a b en VSS VDD_1V8
Xb_tri VSS en VDD_1V8 a b BTHHDLLX1
.ENDS

.SUBCKT tri_buf_154 a b en VSS VDD_1V8
Xb_tri VSS en VDD_1V8 a b BTHHDLLX1
.ENDS

.SUBCKT tri_buf_153 a b en VSS VDD_1V8
Xb_tri VSS en VDD_1V8 a b BTHHDLLX1
.ENDS

.SUBCKT tri_buf_152 a b en VSS VDD_1V8
Xb_tri VSS en VDD_1V8 a b BTHHDLLX1
.ENDS

.SUBCKT tri_buf_151 a b en VSS VDD_1V8
Xb_tri VSS en VDD_1V8 a b BTHHDLLX1
.ENDS

.SUBCKT tri_buf_150 a b en VSS VDD_1V8
Xb_tri VSS en VDD_1V8 a b BTHHDLLX1
.ENDS

.SUBCKT tri_buf_149 a b en VSS VDD_1V8
Xb_tri VSS en VDD_1V8 a b BTHHDLLX1
.ENDS

.SUBCKT tri_buf_148 a b en VSS VDD_1V8
Xb_tri VSS en VDD_1V8 a b BTHHDLLX1
.ENDS

.SUBCKT tri_buf_147 a b en VSS VDD_1V8
Xb_tri VSS en VDD_1V8 a b BTHHDLLX1
.ENDS

.SUBCKT tri_buf_146 a b en VSS VDD_1V8
Xb_tri VSS en VDD_1V8 a b BTHHDLLX1
.ENDS

.SUBCKT tri_buf_145 a b en VSS VDD_1V8
Xb_tri VSS en VDD_1V8 a b BTHHDLLX1
.ENDS

.SUBCKT tri_buf_144 a b en VSS VDD_1V8
Xb_tri VSS en VDD_1V8 a b BTHHDLLX1
.ENDS

.SUBCKT tri_buf_143 a b en VSS VDD_1V8
Xb_tri VSS en VDD_1V8 a b BTHHDLLX1
.ENDS

.SUBCKT tri_buf_142 a b en VSS VDD_1V8
Xb_tri VSS en VDD_1V8 a b BTHHDLLX1
.ENDS

.SUBCKT tri_buf_141 a b en VSS VDD_1V8
Xb_tri VSS en VDD_1V8 a b BTHHDLLX1
.ENDS

.SUBCKT tri_buf_140 a b en VSS VDD_1V8
XU1 n1 VSS VDD_1V8 LOGIC0HDLL
Xb_tri VSS en VDD_1V8 n1 b BTHHDLLX2
.ENDS

.SUBCKT tri_buf_139 a b en VSS VDD_1V8
XU1 n1 VSS VDD_1V8 LOGIC0HDLL
Xb_tri VSS en VDD_1V8 n1 b BTHHDLLX2
.ENDS

.SUBCKT tri_buf_138 a b en VSS VDD_1V8
Xb_tri VSS en VDD_1V8 a b BTHHDLLX1
.ENDS

.SUBCKT tri_buf_137 a b en VSS VDD_1V8
Xb_tri VSS en VDD_1V8 a b BTHHDLLX1
.ENDS

.SUBCKT tri_buf_136 a b en VSS VDD_1V8
XU1 n1 VSS VDD_1V8 LOGIC0HDLL
Xb_tri VSS en VDD_1V8 n1 b BTHHDLLX1
.ENDS

.SUBCKT dff_async_rst_1192 data clk reset q VSS VDD_1V8
Xq_reg reset clk data q VSS VDD_1V8 DFRRQHDLLX0
.ENDS

.SUBCKT dff_async_rst_1191 data clk reset q VSS VDD_1V8
Xq_reg reset clk data q VSS VDD_1V8 DFRRQHDLLX0
.ENDS

.SUBCKT dff_async_rst_1190 data clk reset q VSS VDD_1V8
Xq_reg reset clk data q VSS VDD_1V8 DFRRQHDLLX0
.ENDS

.SUBCKT dff_async_rst_1189 data clk reset q VSS VDD_1V8
Xq_reg reset clk data q VSS VDD_1V8 DFRRQHDLLX0
.ENDS

.SUBCKT dff_async_rst_1188 data clk reset q VSS VDD_1V8
Xq_reg reset clk data q VSS VDD_1V8 DFRRQHDLLX0
.ENDS

.SUBCKT dff_async_rst_1187 data clk reset q VSS VDD_1V8
Xq_reg reset clk data q VSS VDD_1V8 DFRRQHDLLX0
.ENDS

.SUBCKT dff_async_rst_1186 data clk reset q VSS VDD_1V8
Xq_reg reset clk data q VSS VDD_1V8 DFRRQHDLLX0
.ENDS

.SUBCKT dff_async_rst_1185 data clk reset q VSS VDD_1V8
Xq_reg reset clk data q VSS VDD_1V8 DFRRQHDLLX0
.ENDS

.SUBCKT dff_async_rst_1184 data clk reset q VSS VDD_1V8
Xq_reg reset clk data q VSS VDD_1V8 DFRRQHDLLX0
.ENDS

.SUBCKT dff_async_rst_1183 data clk reset q VSS VDD_1V8
Xq_reg reset clk data q VSS VDD_1V8 DFRRQHDLLX0
.ENDS

.SUBCKT dff_async_rst_1182 data clk reset q VSS VDD_1V8
Xq_reg reset clk data q VSS VDD_1V8 DFRRQHDLLX0
.ENDS

.SUBCKT dff_async_rst_1181 data clk reset q VSS VDD_1V8
Xq_reg reset clk data q VSS VDD_1V8 DFRRQHDLLX0
.ENDS

.SUBCKT dff_async_rst_1180 data clk reset q VSS VDD_1V8
Xq_reg reset clk data q VSS VDD_1V8 DFRRQHDLLX0
.ENDS

.SUBCKT dff_async_rst_1179 data clk reset q VSS VDD_1V8
Xq_reg reset clk data q VSS VDD_1V8 DFRRQHDLLX0
.ENDS

.SUBCKT dff_async_rst_1178 data clk reset q VSS VDD_1V8
Xq_reg reset clk data q VSS VDD_1V8 DFRRQHDLLX0
.ENDS

.SUBCKT dff_async_rst_1177 data clk reset q VSS VDD_1V8
Xq_reg reset clk data q VSS VDD_1V8 DFRRQHDLLX0
.ENDS

.SUBCKT dff_async_rst_1176 data clk reset q VSS VDD_1V8
Xq_reg reset clk data q VSS VDD_1V8 DFRRQHDLLX0
.ENDS

.SUBCKT dff_async_rst_1175 data clk reset q VSS VDD_1V8
Xq_reg reset clk data q VSS VDD_1V8 DFRRQHDLLX0
.ENDS

.SUBCKT dff_async_rst_1174 data clk reset q VSS VDD_1V8
Xq_reg reset clk data q VSS VDD_1V8 DFRRQHDLLX0
.ENDS

.SUBCKT dff_async_rst_1173 data clk reset q VSS VDD_1V8
Xq_reg reset clk data q VSS VDD_1V8 DFRRQHDLLX0
.ENDS

.SUBCKT dff_async_rst_1172 data clk reset q VSS VDD_1V8
Xq_reg reset clk data q VSS VDD_1V8 DFRRQHDLLX0
.ENDS

.SUBCKT dff_async_rst_1171 data clk reset q VSS VDD_1V8
Xq_reg reset clk data q VSS VDD_1V8 DFRRQHDLLX0
.ENDS

.SUBCKT dff_async_rst_1170 data clk reset q VSS VDD_1V8
Xq_reg reset clk data q VSS VDD_1V8 DFRRQHDLLX0
.ENDS

.SUBCKT dff_async_rst_1169 data clk reset q VSS VDD_1V8
Xq_reg reset clk data q VSS VDD_1V8 DFRRQHDLLX0
.ENDS

.SUBCKT dff_async_rst_1168 data clk reset q VSS VDD_1V8
Xq_reg reset clk data q VSS VDD_1V8 DFRRQHDLLX0
.ENDS

.SUBCKT dff_async_rst_1167 data clk reset q VSS VDD_1V8
Xq_reg reset clk data q VSS VDD_1V8 DFRRQHDLLX0
.ENDS

.SUBCKT dff_async_rst_1166 data clk reset q VSS VDD_1V8
Xq_reg reset clk data q VSS VDD_1V8 DFRRQHDLLX0
.ENDS

.SUBCKT dff_async_rst_1165 data clk reset q VSS VDD_1V8
Xq_reg reset clk data q VSS VDD_1V8 DFRRQHDLLX0
.ENDS

.SUBCKT dff_async_rst_1164 data clk reset q VSS VDD_1V8
Xq_reg reset clk data q VSS VDD_1V8 DFRRQHDLLX0
.ENDS

.SUBCKT dff_async_rst_1163 data clk reset q VSS VDD_1V8
Xq_reg reset clk data q VSS VDD_1V8 DFRRQHDLLX0
.ENDS

.SUBCKT dff_async_rst_1162 data clk reset q VSS VDD_1V8
Xq_reg reset clk data q VSS VDD_1V8 DFRRQHDLLX0
.ENDS

.SUBCKT dff_async_rst_1161 data clk reset q VSS VDD_1V8
Xq_reg reset clk data q VSS VDD_1V8 DFRRQHDLLX0
.ENDS

.SUBCKT dff_async_rst_1160 data clk reset q VSS VDD_1V8
Xq_reg reset clk data q VSS VDD_1V8 DFRRQHDLLX0
.ENDS

.SUBCKT dff_async_rst_1159 data clk reset q VSS VDD_1V8
Xq_reg reset clk data q VSS VDD_1V8 DFRRQHDLLX0
.ENDS

.SUBCKT dff_async_rst_1158 data clk reset q VSS VDD_1V8
Xq_reg reset clk data q VSS VDD_1V8 DFRRQHDLLX0
.ENDS

.SUBCKT dff_async_rst_1157 data clk reset q VSS VDD_1V8
Xq_reg reset clk data q VSS VDD_1V8 DFRRQHDLLX0
.ENDS

.SUBCKT dff_async_rst_1156 data clk reset q VSS VDD_1V8
Xq_reg reset clk data q VSS VDD_1V8 DFRRQHDLLX0
.ENDS

.SUBCKT dff_async_rst_1155 data clk reset q VSS VDD_1V8
Xq_reg reset clk data q VSS VDD_1V8 DFRRQHDLLX0
.ENDS

.SUBCKT dff_async_rst_1154 data clk reset q VSS VDD_1V8
Xq_reg reset clk data q VSS VDD_1V8 DFRRQHDLLX0
.ENDS

.SUBCKT dff_async_rst_1153 data clk reset q VSS VDD_1V8
Xq_reg reset clk data q VSS VDD_1V8 DFRRQHDLLX0
.ENDS

.SUBCKT dff_async_rst_1152 data clk reset q VSS VDD_1V8
Xq_reg reset clk data q VSS VDD_1V8 DFRRQHDLLX0
.ENDS

.SUBCKT dff_async_rst_1151 data clk reset q VSS VDD_1V8
Xq_reg reset clk data q VSS VDD_1V8 DFRRQHDLLX0
.ENDS

.SUBCKT dff_async_rst_1150 data clk reset q VSS VDD_1V8
Xq_reg reset clk data q VSS VDD_1V8 DFRRQHDLLX0
.ENDS

.SUBCKT dff_async_rst_1149 data clk reset q VSS VDD_1V8
Xq_reg reset clk data q VSS VDD_1V8 DFRRQHDLLX0
.ENDS

.SUBCKT dff_async_rst_1148 data clk reset q VSS VDD_1V8
Xq_reg reset clk data q VSS VDD_1V8 DFRRQHDLLX0
.ENDS

.SUBCKT dff_async_rst_1147 data clk reset q VSS VDD_1V8
Xq_reg reset clk data q VSS VDD_1V8 DFRRQHDLLX0
.ENDS

.SUBCKT dff_async_rst_1146 data clk reset q VSS VDD_1V8
Xq_reg reset clk data q VSS VDD_1V8 DFRRQHDLLX0
.ENDS

.SUBCKT dff_async_rst_1145 data clk reset q VSS VDD_1V8
Xq_reg reset clk data q VSS VDD_1V8 DFRRQHDLLX0
.ENDS

.SUBCKT dff_async_rst_1144 data clk reset q VSS VDD_1V8
Xq_reg reset clk data q VSS VDD_1V8 DFRRQHDLLX0
.ENDS

.SUBCKT dff_async_rst_1143 data clk reset q VSS VDD_1V8
Xq_reg reset clk data q VSS VDD_1V8 DFRRQHDLLX0
.ENDS

.SUBCKT dff_async_rst_1142 data clk reset q VSS VDD_1V8
Xq_reg reset clk data q VSS VDD_1V8 DFRRQHDLLX0
.ENDS

.SUBCKT dff_async_rst_1141 data clk reset q VSS VDD_1V8
Xq_reg reset clk data q VSS VDD_1V8 DFRRQHDLLX0
.ENDS

.SUBCKT dff_async_rst_1140 data clk reset q VSS VDD_1V8
Xq_reg reset clk data q VSS VDD_1V8 DFRRQHDLLX0
.ENDS

.SUBCKT dff_async_rst_1139 data clk reset q VSS VDD_1V8
Xq_reg reset clk data q VSS VDD_1V8 DFRRQHDLLX0
.ENDS

.SUBCKT dff_async_rst_1138 data clk reset q VSS VDD_1V8
Xq_reg reset clk data q VSS VDD_1V8 DFRRQHDLLX0
.ENDS

.SUBCKT dff_async_rst_1135 data clk reset q VSS VDD_1V8
Xq_reg reset clk data q VSS VDD_1V8 DFRRQHDLLX0
.ENDS

.SUBCKT dff_async_rst_1134 data clk reset q VSS VDD_1V8
Xq_reg reset clk data q VSS VDD_1V8 DFRRQHDLLX0
.ENDS

.SUBCKT dff_async_rst_1133 data clk reset q VSS VDD_1V8
Xq_reg reset clk data q VSS VDD_1V8 DFRRQHDLLX0
.ENDS

.SUBCKT dff_async_rst_1130 data clk reset q VSS VDD_1V8
Xq_reg reset clk data q VSS VDD_1V8 DFRRQHDLLX0
.ENDS

.SUBCKT dff_async_rst_1129 data clk reset q VSS VDD_1V8
Xq_reg reset clk data q VSS VDD_1V8 DFRRQHDLLX0
.ENDS

.SUBCKT dff_async_rst_1128 data clk reset q VSS VDD_1V8
Xq_reg reset clk data q VSS VDD_1V8 DFRRQHDLLX0
.ENDS

.SUBCKT dff_async_rst_1127 data clk reset q VSS VDD_1V8
Xq_reg reset clk data q VSS VDD_1V8 DFRRQHDLLX0
.ENDS

.SUBCKT dff_async_rst_1126 data clk reset q VSS VDD_1V8
Xq_reg reset clk data q VSS VDD_1V8 DFRRQHDLLX0
.ENDS

.SUBCKT dff_async_rst_1125 data clk reset q VSS VDD_1V8
Xq_reg reset clk data q VSS VDD_1V8 DFRRQHDLLX0
.ENDS

.SUBCKT dff_async_rst_1124 data clk reset q VSS VDD_1V8
Xq_reg reset clk data q VSS VDD_1V8 DFRRQHDLLX0
.ENDS

.SUBCKT dff_async_rst_1123 data clk reset q VSS VDD_1V8
Xq_reg reset clk data q VSS VDD_1V8 DFRRQHDLLX0
.ENDS

.SUBCKT dff_async_rst_1122 data clk reset q VSS VDD_1V8
Xq_reg reset clk data q VSS VDD_1V8 DFRRQHDLLX0
.ENDS

.SUBCKT dff_async_rst_1121 data clk reset q VSS VDD_1V8
Xq_reg reset clk data q VSS VDD_1V8 DFRRQHDLLX0
.ENDS

.SUBCKT dff_async_rst_1120 data clk reset q VSS VDD_1V8
Xq_reg reset clk data q VSS VDD_1V8 DFRRQHDLLX0
.ENDS

.SUBCKT dff_async_rst_1119 data clk reset q VSS VDD_1V8
Xq_reg reset clk data q VSS VDD_1V8 DFRRQHDLLX0
.ENDS

.SUBCKT dff_async_rst_1118 data clk reset q VSS VDD_1V8
Xq_reg reset clk data q VSS VDD_1V8 DFRRQHDLLX0
.ENDS

.SUBCKT dff_async_rst_1117 data clk reset q VSS VDD_1V8
Xq_reg reset clk data q VSS VDD_1V8 DFRRQHDLLX0
.ENDS

.SUBCKT dff_async_rst_1116 data clk reset q VSS VDD_1V8
Xq_reg reset clk data q VSS VDD_1V8 DFRRQHDLLX0
.ENDS

.SUBCKT dff_async_rst_1115 data clk reset q VSS VDD_1V8
Xq_reg reset clk data q VSS VDD_1V8 DFRRQHDLLX0
.ENDS

.SUBCKT dff_async_rst_1114 data clk reset q VSS VDD_1V8
Xq_reg reset clk data q VSS VDD_1V8 DFRRQHDLLX0
.ENDS

.SUBCKT dff_async_rst_1113 data clk reset q VSS VDD_1V8
Xq_reg reset clk data q VSS VDD_1V8 DFRRQHDLLX0
.ENDS

.SUBCKT dff_async_rst_1112 data clk reset q VSS VDD_1V8
Xq_reg reset clk data q VSS VDD_1V8 DFRRQHDLLX0
.ENDS

.SUBCKT dff_async_rst_1111 data clk reset q VSS VDD_1V8
Xq_reg reset clk data q VSS VDD_1V8 DFRRQHDLLX0
.ENDS

.SUBCKT dff_async_rst_1110 data clk reset q VSS VDD_1V8
Xq_reg reset clk data q VSS VDD_1V8 DFRRQHDLLX0
.ENDS

.SUBCKT dff_async_rst_1109 data clk reset q VSS VDD_1V8
Xq_reg reset clk data q VSS VDD_1V8 DFRRQHDLLX0
.ENDS

.SUBCKT dff_async_rst_1108 data clk reset q VSS VDD_1V8
Xq_reg reset clk data q VSS VDD_1V8 DFRRQHDLLX0
.ENDS

.SUBCKT dff_async_rst_1107 data clk reset q VSS VDD_1V8
Xq_reg reset clk data q VSS VDD_1V8 DFRRQHDLLX0
.ENDS

.SUBCKT dff_async_rst_1106 data clk reset q VSS VDD_1V8
Xq_reg reset clk data q VSS VDD_1V8 DFRRQHDLLX0
.ENDS

.SUBCKT dff_async_rst_1105 data clk reset q VSS VDD_1V8
Xq_reg reset clk data q VSS VDD_1V8 DFRRQHDLLX0
.ENDS

.SUBCKT dff_async_rst_1104 data clk reset q VSS VDD_1V8
Xq_reg reset clk data q VSS VDD_1V8 DFRRQHDLLX0
.ENDS

.SUBCKT dff_async_rst_1103 data clk reset q VSS VDD_1V8
Xq_reg reset clk data q VSS VDD_1V8 DFRRQHDLLX0
.ENDS

.SUBCKT dff_async_rst_1102 data clk reset q VSS VDD_1V8
Xq_reg reset clk data q VSS VDD_1V8 DFRRQHDLLX0
.ENDS

.SUBCKT dff_async_rst_1101 data clk reset q VSS VDD_1V8
Xq_reg reset clk data q VSS VDD_1V8 DFRRQHDLLX0
.ENDS

.SUBCKT dff_async_rst_1100 data clk reset q VSS VDD_1V8
Xq_reg reset clk data q VSS VDD_1V8 DFRRQHDLLX0
.ENDS

.SUBCKT dff_async_rst_1099 data clk reset q VSS VDD_1V8
Xq_reg reset clk data q VSS VDD_1V8 DFRRQHDLLX0
.ENDS

.SUBCKT dff_async_rst_1098 data clk reset q VSS VDD_1V8
Xq_reg reset clk data q VSS VDD_1V8 DFRRQHDLLX0
.ENDS

.SUBCKT dff_async_rst_1097 data clk reset q VSS VDD_1V8
Xq_reg reset clk data q VSS VDD_1V8 DFRRQHDLLX0
.ENDS

.SUBCKT dff_async_rst_1096 data clk reset q VSS VDD_1V8
Xq_reg reset clk data q VSS VDD_1V8 DFRRQHDLLX0
.ENDS

.SUBCKT dff_async_rst_1095 data clk reset q VSS VDD_1V8
Xq_reg reset clk data q VSS VDD_1V8 DFRRQHDLLX0
.ENDS

.SUBCKT dff_async_rst_1094 data clk reset q VSS VDD_1V8
Xq_reg reset clk data q VSS VDD_1V8 DFRRQHDLLX0
.ENDS

.SUBCKT dff_async_rst_1093 data clk reset q VSS VDD_1V8
Xq_reg reset clk data q VSS VDD_1V8 DFRRQHDLLX0
.ENDS

.SUBCKT dff_async_rst_1092 data clk reset q VSS VDD_1V8
Xq_reg reset clk data q VSS VDD_1V8 DFRRQHDLLX0
.ENDS

.SUBCKT dff_async_rst_1091 data clk reset q VSS VDD_1V8
Xq_reg reset clk data q VSS VDD_1V8 DFRRQHDLLX0
.ENDS

.SUBCKT dff_async_rst_1090 data clk reset q VSS VDD_1V8
Xq_reg reset clk data q VSS VDD_1V8 DFRRQHDLLX0
.ENDS

.SUBCKT dff_async_rst_1089 data clk reset q VSS VDD_1V8
Xq_reg reset clk data q VSS VDD_1V8 DFRRQHDLLX0
.ENDS

.SUBCKT dff_async_rst_1088 data clk reset q VSS VDD_1V8
Xq_reg reset clk data q VSS VDD_1V8 DFRRQHDLLX0
.ENDS

.SUBCKT dff_async_rst_1087 data clk reset q VSS VDD_1V8
Xq_reg reset clk data q VSS VDD_1V8 DFRRQHDLLX0
.ENDS

.SUBCKT dff_async_rst_1086 data clk reset q VSS VDD_1V8
Xq_reg reset clk data q VSS VDD_1V8 DFRRQHDLLX0
.ENDS

.SUBCKT dff_async_rst_1085 data clk reset q VSS VDD_1V8
Xq_reg reset clk data q VSS VDD_1V8 DFRRQHDLLX0
.ENDS

.SUBCKT dff_async_rst_1084 data clk reset q VSS VDD_1V8
Xq_reg reset clk data q VSS VDD_1V8 DFRRQHDLLX0
.ENDS

.SUBCKT dff_async_rst_1083 data clk reset q VSS VDD_1V8
Xq_reg reset clk data q VSS VDD_1V8 DFRRQHDLLX0
.ENDS

.SUBCKT dff_async_rst_1082 data clk reset q VSS VDD_1V8
Xq_reg reset clk data q VSS VDD_1V8 DFRRQHDLLX0
.ENDS

.SUBCKT dff_async_rst_1081 data clk reset q VSS VDD_1V8
Xq_reg reset clk data q VSS VDD_1V8 DFRRQHDLLX0
.ENDS

.SUBCKT dff_async_rst_1080 data clk reset q VSS VDD_1V8
Xq_reg reset clk data q VSS VDD_1V8 DFRRQHDLLX0
.ENDS

.SUBCKT dff_async_rst_1079 data clk reset q VSS VDD_1V8
Xq_reg reset clk data q VSS VDD_1V8 DFRRQHDLLX0
.ENDS

.SUBCKT dff_async_rst_1078 data clk reset q VSS VDD_1V8
Xq_reg reset clk data q VSS VDD_1V8 DFRRQHDLLX0
.ENDS

.SUBCKT dff_async_rst_1077 data clk reset q VSS VDD_1V8
Xq_reg reset clk data q VSS VDD_1V8 DFRRQHDLLX0
.ENDS

.SUBCKT dff_async_rst_1076 data clk reset q VSS VDD_1V8
Xq_reg reset clk data q VSS VDD_1V8 DFRRQHDLLX0
.ENDS

.SUBCKT dff_async_rst_1075 data clk reset q VSS VDD_1V8
Xq_reg reset clk data q VSS VDD_1V8 DFRRQHDLLX0
.ENDS

.SUBCKT dff_async_rst_1074 data clk reset q VSS VDD_1V8
Xq_reg reset clk data q VSS VDD_1V8 DFRRQHDLLX0
.ENDS

.SUBCKT dff_async_rst_1073 data clk reset q VSS VDD_1V8
Xq_reg reset clk data q VSS VDD_1V8 DFRRQHDLLX0
.ENDS

.SUBCKT dff_async_rst_1072 data clk reset q VSS VDD_1V8
Xq_reg reset clk data q VSS VDD_1V8 DFRRQHDLLX0
.ENDS

.SUBCKT dff_async_rst_1071 data clk reset q VSS VDD_1V8
Xq_reg reset clk data q VSS VDD_1V8 DFRRQHDLLX0
.ENDS

.SUBCKT dff_async_rst_1070 data clk reset q VSS VDD_1V8
Xq_reg reset clk data q VSS VDD_1V8 DFRRQHDLLX0
.ENDS

.SUBCKT dff_async_rst_1069 data clk reset q VSS VDD_1V8
Xq_reg reset clk data q VSS VDD_1V8 DFRRQHDLLX0
.ENDS

.SUBCKT dff_async_rst_1068 data clk reset q VSS VDD_1V8
Xq_reg reset clk data q VSS VDD_1V8 DFRRQHDLLX0
.ENDS

.SUBCKT dff_async_rst_1067 data clk reset q VSS VDD_1V8
Xq_reg reset clk data q VSS VDD_1V8 DFRRQHDLLX0
.ENDS

.SUBCKT dff_async_rst_1062 data clk reset q VSS VDD_1V8
Xq_reg reset clk data q VSS VDD_1V8 DFRRQHDLLX0
.ENDS

.SUBCKT Counter_arb_mx_cnt3_1 count[1] count[0] clk rst VSS VDD_1V8
XU4 VSS N6 count[1] count[0] VDD_1V8 NO2HDLLX0
XU5 VSS VDD_1V8 N7 count[0] count[1] NO2I1HDLLX0
Xcount_reg_1_ rst clk N7 count[1] VSS VDD_1V8 DFRRQHDLLX0
Xcount_reg_0_ rst clk N6 count[0] VSS VDD_1V8 DFRRQHDLLX0
.ENDS

.SUBCKT dff_async_rst_13 data clk reset q VSS VDD_1V8
Xq_reg reset clk data q VSS VDD_1V8 DFRRQHDLLX0
.ENDS

.SUBCKT dff_async_rst_12 data clk reset q VSS VDD_1V8
Xq_reg reset clk data q VSS VDD_1V8 DFRRQHDLLX0
.ENDS

.SUBCKT dff_async_rst_11 data clk reset q VSS VDD_1V8
Xq_reg reset clk data q VSS VDD_1V8 DFRRQHDLLX0
.ENDS

.SUBCKT dff_async_rst_10 data clk reset q VSS VDD_1V8
Xq_reg reset clk data q VSS VDD_1V8 DFRRQHDLLX0
.ENDS

.SUBCKT dff_async_rst_9 data clk reset q VSS VDD_1V8
Xq_reg reset clk data q VSS VDD_1V8 DFRRQHDLLX0
.ENDS

.SUBCKT dff_async_rst_8 data clk reset q VSS VDD_1V8
Xq_reg reset clk data q VSS VDD_1V8 DFRRQHDLLX0
.ENDS

.SUBCKT dff_async_rst_7 data clk reset q VSS VDD_1V8
Xq_reg reset clk data q VSS VDD_1V8 DFRRQHDLLX0
.ENDS

.SUBCKT tri_buf_3 a b en VSS VDD_1V8
Xb_tri VSS en VDD_1V8 a b BTHHDLLX1
.ENDS

.SUBCKT tri_buf_2 a b en VSS VDD_1V8
Xb_tri VSS en VDD_1V8 a b BTHHDLLX1
.ENDS

.SUBCKT tri_buf_135 a b en VSS VDD_1V8
Xb_tri VSS en VDD_1V8 a b BTHHDLLX1
.ENDS

.SUBCKT tri_buf_134 a b en VSS VDD_1V8
Xb_tri VSS en VDD_1V8 a b BTHHDLLX1
.ENDS

.SUBCKT tri_buf_133 a b en VSS VDD_1V8
Xb_tri VSS en VDD_1V8 a b BTHHDLLX1
.ENDS

.SUBCKT tri_buf_132 a b en VSS VDD_1V8
Xb_tri VSS en VDD_1V8 a b BTHHDLLX1
.ENDS

.SUBCKT tri_buf_131 a b en VSS VDD_1V8
Xb_tri VSS en VDD_1V8 a b BTHHDLLX1
.ENDS

.SUBCKT tri_buf_130 a b en VSS VDD_1V8
Xb_tri VSS en VDD_1V8 a b BTHHDLLX1
.ENDS

.SUBCKT tri_buf_129 a b en VSS VDD_1V8
Xb_tri VSS en VDD_1V8 a b BTHHDLLX1
.ENDS

.SUBCKT tri_buf_128 a b en VSS VDD_1V8
Xb_tri VSS en VDD_1V8 a b BTHHDLLX1
.ENDS

.SUBCKT tri_buf_127 a b en VSS VDD_1V8
Xb_tri VSS en VDD_1V8 a b BTHHDLLX1
.ENDS

.SUBCKT tri_buf_126 a b en VSS VDD_1V8
Xb_tri VSS en VDD_1V8 a b BTHHDLLX1
.ENDS

.SUBCKT tri_buf_125 a b en VSS VDD_1V8
Xb_tri VSS en VDD_1V8 a b BTHHDLLX1
.ENDS

.SUBCKT tri_buf_124 a b en VSS VDD_1V8
Xb_tri VSS en VDD_1V8 a b BTHHDLLX1
.ENDS

.SUBCKT tri_buf_123 a b en VSS VDD_1V8
Xb_tri VSS en VDD_1V8 a b BTHHDLLX1
.ENDS

.SUBCKT tri_buf_122 a b en VSS VDD_1V8
Xb_tri VSS en VDD_1V8 a b BTHHDLLX1
.ENDS

.SUBCKT tri_buf_121 a b en VSS VDD_1V8
Xb_tri VSS en VDD_1V8 a b BTHHDLLX1
.ENDS

.SUBCKT tri_buf_120 a b en VSS VDD_1V8
Xb_tri VSS en VDD_1V8 a b BTHHDLLX1
.ENDS

.SUBCKT tri_buf_119 a b en VSS VDD_1V8
Xb_tri VSS en VDD_1V8 a b BTHHDLLX1
.ENDS

.SUBCKT tri_buf_118 a b en VSS VDD_1V8
Xb_tri VSS en VDD_1V8 a b BTHHDLLX1
.ENDS

.SUBCKT tri_buf_117 a b en VSS VDD_1V8
Xb_tri VSS en VDD_1V8 a b BTHHDLLX1
.ENDS

.SUBCKT tri_buf_116 a b en VSS VDD_1V8
Xb_tri VSS en VDD_1V8 a b BTHHDLLX1
.ENDS

.SUBCKT tri_buf_115 a b en VSS VDD_1V8
Xb_tri VSS en VDD_1V8 a b BTHHDLLX1
.ENDS

.SUBCKT tri_buf_114 a b en VSS VDD_1V8
Xb_tri VSS en VDD_1V8 a b BTHHDLLX1
.ENDS

.SUBCKT tri_buf_113 a b en VSS VDD_1V8
Xb_tri VSS en VDD_1V8 a b BTHHDLLX1
.ENDS

.SUBCKT tri_buf_112 a b en VSS VDD_1V8
Xb_tri VSS en VDD_1V8 a b BTHHDLLX1
.ENDS

.SUBCKT tri_buf_111 a b en VSS VDD_1V8
Xb_tri VSS en VDD_1V8 a b BTHHDLLX1
.ENDS

.SUBCKT tri_buf_110 a b en VSS VDD_1V8
Xb_tri VSS en VDD_1V8 a b BTHHDLLX1
.ENDS

.SUBCKT tri_buf_109 a b en VSS VDD_1V8
Xb_tri VSS en VDD_1V8 a b BTHHDLLX1
.ENDS

.SUBCKT tri_buf_108 a b en VSS VDD_1V8
Xb_tri VSS en VDD_1V8 a b BTHHDLLX1
.ENDS

.SUBCKT tri_buf_107 a b en VSS VDD_1V8
Xb_tri VSS en VDD_1V8 a b BTHHDLLX1
.ENDS

.SUBCKT tri_buf_106 a b en VSS VDD_1V8
Xb_tri VSS en VDD_1V8 a b BTHHDLLX1
.ENDS

.SUBCKT tri_buf_105 a b en VSS VDD_1V8
Xb_tri VSS en VDD_1V8 a b BTHHDLLX1
.ENDS

.SUBCKT tri_buf_104 a b en VSS VDD_1V8
Xb_tri VSS en VDD_1V8 a b BTHHDLLX1
.ENDS

.SUBCKT tri_buf_103 a b en VSS VDD_1V8
Xb_tri VSS en VDD_1V8 a b BTHHDLLX1
.ENDS

.SUBCKT tri_buf_102 a b en VSS VDD_1V8
Xb_tri VSS en VDD_1V8 a b BTHHDLLX1
.ENDS

.SUBCKT tri_buf_101 a b en VSS VDD_1V8
Xb_tri VSS en VDD_1V8 a b BTHHDLLX1
.ENDS

.SUBCKT tri_buf_100 a b en VSS VDD_1V8
Xb_tri VSS en VDD_1V8 a b BTHHDLLX1
.ENDS

.SUBCKT tri_buf_99 a b en VSS VDD_1V8
Xb_tri VSS en VDD_1V8 a b BTHHDLLX1
.ENDS

.SUBCKT tri_buf_98 a b en VSS VDD_1V8
Xb_tri VSS en VDD_1V8 a b BTHHDLLX1
.ENDS

.SUBCKT tri_buf_97 a b en VSS VDD_1V8
Xb_tri VSS en VDD_1V8 a b BTHHDLLX1
.ENDS

.SUBCKT tri_buf_96 a b en VSS VDD_1V8
Xb_tri VSS en VDD_1V8 a b BTHHDLLX1
.ENDS

.SUBCKT tri_buf_95 a b en VSS VDD_1V8
Xb_tri VSS en VDD_1V8 a b BTHHDLLX1
.ENDS

.SUBCKT tri_buf_94 a b en VSS VDD_1V8
Xb_tri VSS en VDD_1V8 a b BTHHDLLX1
.ENDS

.SUBCKT tri_buf_93 a b en VSS VDD_1V8
Xb_tri VSS en VDD_1V8 a b BTHHDLLX1
.ENDS

.SUBCKT tri_buf_92 a b en VSS VDD_1V8
Xb_tri VSS en VDD_1V8 a b BTHHDLLX1
.ENDS

.SUBCKT tri_buf_91 a b en VSS VDD_1V8
Xb_tri VSS en VDD_1V8 a b BTHHDLLX1
.ENDS

.SUBCKT tri_buf_90 a b en VSS VDD_1V8
Xb_tri VSS en VDD_1V8 a b BTHHDLLX1
.ENDS

.SUBCKT tri_buf_89 a b en VSS VDD_1V8
Xb_tri VSS en VDD_1V8 a b BTHHDLLX1
.ENDS

.SUBCKT tri_buf_88 a b en VSS VDD_1V8
Xb_tri VSS en VDD_1V8 a b BTHHDLLX1
.ENDS

.SUBCKT tri_buf_87 a b en VSS VDD_1V8
Xb_tri VSS en VDD_1V8 a b BTHHDLLX1
.ENDS

.SUBCKT tri_buf_86 a b en VSS VDD_1V8
Xb_tri VSS en VDD_1V8 a b BTHHDLLX1
.ENDS

.SUBCKT tri_buf_85 a b en VSS VDD_1V8
Xb_tri VSS en VDD_1V8 a b BTHHDLLX1
.ENDS

.SUBCKT tri_buf_84 a b en VSS VDD_1V8
Xb_tri VSS en VDD_1V8 a b BTHHDLLX1
.ENDS

.SUBCKT tri_buf_83 a b en VSS VDD_1V8
Xb_tri VSS en VDD_1V8 a b BTHHDLLX1
.ENDS

.SUBCKT tri_buf_82 a b en VSS VDD_1V8
Xb_tri VSS en VDD_1V8 a b BTHHDLLX1
.ENDS

.SUBCKT tri_buf_81 a b en VSS VDD_1V8
Xb_tri VSS en VDD_1V8 a b BTHHDLLX1
.ENDS

.SUBCKT tri_buf_80 a b en VSS VDD_1V8
Xb_tri VSS en VDD_1V8 a b BTHHDLLX1
.ENDS

.SUBCKT tri_buf_79 a b en VSS VDD_1V8
Xb_tri VSS en VDD_1V8 a b BTHHDLLX1
.ENDS

.SUBCKT tri_buf_78 a b en VSS VDD_1V8
Xb_tri VSS en VDD_1V8 a b BTHHDLLX1
.ENDS

.SUBCKT tri_buf_77 a b en VSS VDD_1V8
Xb_tri VSS en VDD_1V8 a b BTHHDLLX1
.ENDS

.SUBCKT tri_buf_76 a b en VSS VDD_1V8
Xb_tri VSS en VDD_1V8 a b BTHHDLLX1
.ENDS

.SUBCKT tri_buf_75 a b en VSS VDD_1V8
Xb_tri VSS en VDD_1V8 a b BTHHDLLX2
.ENDS

.SUBCKT tri_buf_74 a b en VSS VDD_1V8
XU1 n1 VSS VDD_1V8 LOGIC0HDLL
Xb_tri VSS en VDD_1V8 n1 b BTHHDLLX2
.ENDS

.SUBCKT tri_buf_73 a b en VSS VDD_1V8
XU1 n1 VSS VDD_1V8 LOGIC0HDLL
Xb_tri VSS en VDD_1V8 n1 b BTHHDLLX1
.ENDS

.SUBCKT tri_buf_72 a b en VSS VDD_1V8
XU1 n1 VSS VDD_1V8 LOGIC0HDLL
Xb_tri VSS en VDD_1V8 n1 b BTHHDLLX1
.ENDS

.SUBCKT tri_buf_71 a b en VSS VDD_1V8
XU1 n1 VSS VDD_1V8 LOGIC0HDLL
Xb_tri VSS en VDD_1V8 n1 b BTHHDLLX1
.ENDS

.SUBCKT dff_async_rst_1061 data clk reset q VSS VDD_1V8
Xq_reg reset clk data q VSS VDD_1V8 DFRRQHDLLX0
.ENDS

.SUBCKT dff_async_rst_1060 data clk reset q VSS VDD_1V8
Xq_reg reset clk data q VSS VDD_1V8 DFRRQHDLLX0
.ENDS

.SUBCKT dff_async_rst_1059 data clk reset q VSS VDD_1V8
Xq_reg reset clk data q VSS VDD_1V8 DFRRQHDLLX0
.ENDS

.SUBCKT dff_async_rst_1058 data clk reset q VSS VDD_1V8
Xq_reg reset clk data q VSS VDD_1V8 DFRRQHDLLX0
.ENDS

.SUBCKT dff_async_rst_1057 data clk reset q VSS VDD_1V8
Xq_reg reset clk data q VSS VDD_1V8 DFRRQHDLLX0
.ENDS

.SUBCKT dff_async_rst_1056 data clk reset q VSS VDD_1V8
Xq_reg reset clk data q VSS VDD_1V8 DFRRQHDLLX0
.ENDS

.SUBCKT dff_async_rst_1055 data clk reset q VSS VDD_1V8
Xq_reg reset clk data q VSS VDD_1V8 DFRRQHDLLX0
.ENDS

.SUBCKT dff_async_rst_1054 data clk reset q VSS VDD_1V8
Xq_reg reset clk data q VSS VDD_1V8 DFRRQHDLLX0
.ENDS

.SUBCKT dff_async_rst_1053 data clk reset q VSS VDD_1V8
Xq_reg reset clk data q VSS VDD_1V8 DFRRQHDLLX0
.ENDS

.SUBCKT dff_async_rst_1052 data clk reset q VSS VDD_1V8
Xq_reg reset clk data q VSS VDD_1V8 DFRRQHDLLX0
.ENDS

.SUBCKT dff_async_rst_1051 data clk reset q VSS VDD_1V8
Xq_reg reset clk data q VSS VDD_1V8 DFRRQHDLLX0
.ENDS

.SUBCKT dff_async_rst_1050 data clk reset q VSS VDD_1V8
Xq_reg reset clk data q VSS VDD_1V8 DFRRQHDLLX0
.ENDS

.SUBCKT dff_async_rst_1049 data clk reset q VSS VDD_1V8
Xq_reg reset clk data q VSS VDD_1V8 DFRRQHDLLX0
.ENDS

.SUBCKT dff_async_rst_1048 data clk reset q VSS VDD_1V8
Xq_reg reset clk data q VSS VDD_1V8 DFRRQHDLLX0
.ENDS

.SUBCKT dff_async_rst_1047 data clk reset q VSS VDD_1V8
Xq_reg reset clk data q VSS VDD_1V8 DFRRQHDLLX0
.ENDS

.SUBCKT dff_async_rst_1046 data clk reset q VSS VDD_1V8
Xq_reg reset clk data q VSS VDD_1V8 DFRRQHDLLX0
.ENDS

.SUBCKT dff_async_rst_1045 data clk reset q VSS VDD_1V8
Xq_reg reset clk data q VSS VDD_1V8 DFRRQHDLLX0
.ENDS

.SUBCKT dff_async_rst_1044 data clk reset q VSS VDD_1V8
Xq_reg reset clk data q VSS VDD_1V8 DFRRQHDLLX0
.ENDS

.SUBCKT dff_async_rst_1043 data clk reset q VSS VDD_1V8
Xq_reg reset clk data q VSS VDD_1V8 DFRRQHDLLX0
.ENDS

.SUBCKT dff_async_rst_1042 data clk reset q VSS VDD_1V8
Xq_reg reset clk data q VSS VDD_1V8 DFRRQHDLLX0
.ENDS

.SUBCKT dff_async_rst_1041 data clk reset q VSS VDD_1V8
Xq_reg reset clk data q VSS VDD_1V8 DFRRQHDLLX0
.ENDS

.SUBCKT dff_async_rst_1040 data clk reset q VSS VDD_1V8
Xq_reg reset clk data q VSS VDD_1V8 DFRRQHDLLX0
.ENDS

.SUBCKT dff_async_rst_1039 data clk reset q VSS VDD_1V8
Xq_reg reset clk data q VSS VDD_1V8 DFRRQHDLLX0
.ENDS

.SUBCKT dff_async_rst_1038 data clk reset q VSS VDD_1V8
Xq_reg reset clk data q VSS VDD_1V8 DFRRQHDLLX0
.ENDS

.SUBCKT dff_async_rst_1037 data clk reset q VSS VDD_1V8
Xq_reg reset clk data q VSS VDD_1V8 DFRRQHDLLX0
.ENDS

.SUBCKT dff_async_rst_1036 data clk reset q VSS VDD_1V8
Xq_reg reset clk data q VSS VDD_1V8 DFRRQHDLLX0
.ENDS

.SUBCKT dff_async_rst_1035 data clk reset q VSS VDD_1V8
Xq_reg reset clk data q VSS VDD_1V8 DFRRQHDLLX0
.ENDS

.SUBCKT dff_async_rst_1034 data clk reset q VSS VDD_1V8
Xq_reg reset clk data q VSS VDD_1V8 DFRRQHDLLX0
.ENDS

.SUBCKT dff_async_rst_1033 data clk reset q VSS VDD_1V8
Xq_reg reset clk data q VSS VDD_1V8 DFRRQHDLLX0
.ENDS

.SUBCKT dff_async_rst_1032 data clk reset q VSS VDD_1V8
Xq_reg reset clk data q VSS VDD_1V8 DFRRQHDLLX0
.ENDS

.SUBCKT dff_async_rst_1031 data clk reset q VSS VDD_1V8
Xq_reg reset clk data q VSS VDD_1V8 DFRRQHDLLX0
.ENDS

.SUBCKT dff_async_rst_1030 data clk reset q VSS VDD_1V8
Xq_reg reset clk data q VSS VDD_1V8 DFRRQHDLLX0
.ENDS

.SUBCKT dff_async_rst_1029 data clk reset q VSS VDD_1V8
Xq_reg reset clk data q VSS VDD_1V8 DFRRQHDLLX0
.ENDS

.SUBCKT dff_async_rst_1028 data clk reset q VSS VDD_1V8
Xq_reg reset clk data q VSS VDD_1V8 DFRRQHDLLX0
.ENDS

.SUBCKT dff_async_rst_1027 data clk reset q VSS VDD_1V8
Xq_reg reset clk data q VSS VDD_1V8 DFRRQHDLLX0
.ENDS

.SUBCKT dff_async_rst_1026 data clk reset q VSS VDD_1V8
Xq_reg reset clk data q VSS VDD_1V8 DFRRQHDLLX0
.ENDS

.SUBCKT dff_async_rst_1025 data clk reset q VSS VDD_1V8
Xq_reg reset clk data q VSS VDD_1V8 DFRRQHDLLX0
.ENDS

.SUBCKT dff_async_rst_1024 data clk reset q VSS VDD_1V8
Xq_reg reset clk data q VSS VDD_1V8 DFRRQHDLLX0
.ENDS

.SUBCKT dff_async_rst_1023 data clk reset q VSS VDD_1V8
Xq_reg reset clk data q VSS VDD_1V8 DFRRQHDLLX0
.ENDS

.SUBCKT dff_async_rst_1022 data clk reset q VSS VDD_1V8
Xq_reg reset clk data q VSS VDD_1V8 DFRRQHDLLX0
.ENDS

.SUBCKT dff_async_rst_1021 data clk reset q VSS VDD_1V8
Xq_reg reset clk data q VSS VDD_1V8 DFRRQHDLLX0
.ENDS

.SUBCKT dff_async_rst_1020 data clk reset q VSS VDD_1V8
Xq_reg reset clk data q VSS VDD_1V8 DFRRQHDLLX0
.ENDS

.SUBCKT dff_async_rst_1019 data clk reset q VSS VDD_1V8
Xq_reg reset clk data q VSS VDD_1V8 DFRRQHDLLX0
.ENDS

.SUBCKT dff_async_rst_1018 data clk reset q VSS VDD_1V8
Xq_reg reset clk data q VSS VDD_1V8 DFRRQHDLLX0
.ENDS

.SUBCKT dff_async_rst_1017 data clk reset q VSS VDD_1V8
Xq_reg reset clk data q VSS VDD_1V8 DFRRQHDLLX0
.ENDS

.SUBCKT dff_async_rst_1016 data clk reset q VSS VDD_1V8
Xq_reg reset clk data q VSS VDD_1V8 DFRRQHDLLX0
.ENDS

.SUBCKT dff_async_rst_1015 data clk reset q VSS VDD_1V8
Xq_reg reset clk data q VSS VDD_1V8 DFRRQHDLLX0
.ENDS

.SUBCKT dff_async_rst_1014 data clk reset q VSS VDD_1V8
Xq_reg reset clk data q VSS VDD_1V8 DFRRQHDLLX0
.ENDS

.SUBCKT dff_async_rst_1013 data clk reset q VSS VDD_1V8
Xq_reg reset clk data q VSS VDD_1V8 DFRRQHDLLX0
.ENDS

.SUBCKT dff_async_rst_1012 data clk reset q VSS VDD_1V8
Xq_reg reset clk data q VSS VDD_1V8 DFRRQHDLLX0
.ENDS

.SUBCKT dff_async_rst_1011 data clk reset q VSS VDD_1V8
Xq_reg reset clk data q VSS VDD_1V8 DFRRQHDLLX0
.ENDS

.SUBCKT dff_async_rst_1010 data clk reset q VSS VDD_1V8
Xq_reg reset clk data q VSS VDD_1V8 DFRRQHDLLX0
.ENDS

.SUBCKT dff_async_rst_1009 data clk reset q VSS VDD_1V8
Xq_reg reset clk data q VSS VDD_1V8 DFRRQHDLLX0
.ENDS

.SUBCKT dff_async_rst_1008 data clk reset q VSS VDD_1V8
Xq_reg reset clk data q VSS VDD_1V8 DFRRQHDLLX0
.ENDS

.SUBCKT dff_async_rst_1007 data clk reset q VSS VDD_1V8
Xq_reg reset clk data q VSS VDD_1V8 DFRRQHDLLX0
.ENDS

.SUBCKT dff_async_rst_1006 data clk reset q VSS VDD_1V8
Xq_reg reset clk data q VSS VDD_1V8 DFRRQHDLLX0
.ENDS

.SUBCKT dff_async_rst_1005 data clk reset q VSS VDD_1V8
Xq_reg reset clk data q VSS VDD_1V8 DFRRQHDLLX0
.ENDS

.SUBCKT dff_async_rst_1004 data clk reset q VSS VDD_1V8
Xq_reg reset clk data q VSS VDD_1V8 DFRRQHDLLX0
.ENDS

.SUBCKT dff_async_rst_1003 data clk reset q VSS VDD_1V8
Xq_reg reset clk data q VSS VDD_1V8 DFRRQHDLLX0
.ENDS

.SUBCKT dff_async_rst_1002 data clk reset q VSS VDD_1V8
Xq_reg reset clk data q VSS VDD_1V8 DFRRQHDLLX0
.ENDS

.SUBCKT dff_async_rst_1001 data clk reset q VSS VDD_1V8
Xq_reg reset clk data q VSS VDD_1V8 DFRRQHDLLX0
.ENDS

.SUBCKT dff_async_rst_1000 data clk reset q VSS VDD_1V8
Xq_reg reset clk data q VSS VDD_1V8 DFRRQHDLLX0
.ENDS

.SUBCKT dff_async_rst_999 data clk reset q VSS VDD_1V8
Xq_reg reset clk data q VSS VDD_1V8 DFRRQHDLLX0
.ENDS

.SUBCKT dff_async_rst_998 data clk reset q VSS VDD_1V8
Xq_reg reset clk data q VSS VDD_1V8 DFRRQHDLLX0
.ENDS

.SUBCKT dff_async_rst_997 data clk reset q VSS VDD_1V8
Xq_reg reset clk data q VSS VDD_1V8 DFRRQHDLLX0
.ENDS

.SUBCKT dff_async_rst_996 data clk reset q VSS VDD_1V8
Xq_reg reset clk data q VSS VDD_1V8 DFRRQHDLLX0
.ENDS

.SUBCKT dff_async_rst_995 data clk reset q VSS VDD_1V8
Xq_reg reset clk data q VSS VDD_1V8 DFRRQHDLLX0
.ENDS

.SUBCKT dff_async_rst_994 data clk reset q VSS VDD_1V8
Xq_reg reset clk data q VSS VDD_1V8 DFRRQHDLLX0
.ENDS

.SUBCKT dff_async_rst_993 data clk reset q VSS VDD_1V8
Xq_reg reset clk data q VSS VDD_1V8 DFRRQHDLLX0
.ENDS

.SUBCKT dff_async_rst_992 data clk reset q VSS VDD_1V8
Xq_reg reset clk data q VSS VDD_1V8 DFRRQHDLLX0
.ENDS

.SUBCKT dff_async_rst_991 data clk reset q VSS VDD_1V8
Xq_reg reset clk data q VSS VDD_1V8 DFRRQHDLLX0
.ENDS

.SUBCKT dff_async_rst_990 data clk reset q VSS VDD_1V8
Xq_reg reset clk data q VSS VDD_1V8 DFRRQHDLLX0
.ENDS

.SUBCKT dff_async_rst_989 data clk reset q VSS VDD_1V8
Xq_reg reset clk data q VSS VDD_1V8 DFRRQHDLLX0
.ENDS

.SUBCKT dff_async_rst_988 data clk reset q VSS VDD_1V8
Xq_reg reset clk data q VSS VDD_1V8 DFRRQHDLLX0
.ENDS

.SUBCKT dff_async_rst_987 data clk reset q VSS VDD_1V8
Xq_reg reset clk data q VSS VDD_1V8 DFRRQHDLLX0
.ENDS

.SUBCKT dff_async_rst_986 data clk reset q VSS VDD_1V8
Xq_reg reset clk data q VSS VDD_1V8 DFRRQHDLLX0
.ENDS

.SUBCKT dff_async_rst_985 data clk reset q VSS VDD_1V8
Xq_reg reset clk data q VSS VDD_1V8 DFRRQHDLLX0
.ENDS

.SUBCKT dff_async_rst_984 data clk reset q VSS VDD_1V8
Xq_reg reset clk data q VSS VDD_1V8 DFRRQHDLLX0
.ENDS

.SUBCKT dff_async_rst_983 data clk reset q VSS VDD_1V8
Xq_reg reset clk data q VSS VDD_1V8 DFRRQHDLLX0
.ENDS

.SUBCKT dff_async_rst_982 data clk reset q VSS VDD_1V8
Xq_reg reset clk data q VSS VDD_1V8 DFRRQHDLLX0
.ENDS

.SUBCKT dff_async_rst_981 data clk reset q VSS VDD_1V8
Xq_reg reset clk data q VSS VDD_1V8 DFRRQHDLLX0
.ENDS

.SUBCKT dff_async_rst_980 data clk reset q VSS VDD_1V8
Xq_reg reset clk data q VSS VDD_1V8 DFRRQHDLLX0
.ENDS

.SUBCKT dff_async_rst_979 data clk reset q VSS VDD_1V8
Xq_reg reset clk data q VSS VDD_1V8 DFRRQHDLLX0
.ENDS

.SUBCKT dff_async_rst_978 data clk reset q VSS VDD_1V8
Xq_reg reset clk data q VSS VDD_1V8 DFRRQHDLLX0
.ENDS

.SUBCKT dff_async_rst_977 data clk reset q VSS VDD_1V8
Xq_reg reset clk data q VSS VDD_1V8 DFRRQHDLLX0
.ENDS

.SUBCKT dff_async_rst_976 data clk reset q VSS VDD_1V8
Xq_reg reset clk data q VSS VDD_1V8 DFRRQHDLLX0
.ENDS

.SUBCKT dff_async_rst_975 data clk reset q VSS VDD_1V8
Xq_reg reset clk data q VSS VDD_1V8 DFRRQHDLLX0
.ENDS

.SUBCKT dff_async_rst_974 data clk reset q VSS VDD_1V8
Xq_reg reset clk data q VSS VDD_1V8 DFRRQHDLLX0
.ENDS

.SUBCKT dff_async_rst_973 data clk reset q VSS VDD_1V8
Xq_reg reset clk data q VSS VDD_1V8 DFRRQHDLLX0
.ENDS

.SUBCKT dff_async_rst_972 data clk reset q VSS VDD_1V8
Xq_reg reset clk data q VSS VDD_1V8 DFRRQHDLLX0
.ENDS

.SUBCKT dff_async_rst_971 data clk reset q VSS VDD_1V8
Xq_reg reset clk data q VSS VDD_1V8 DFRRQHDLLX0
.ENDS

.SUBCKT dff_async_rst_970 data clk reset q VSS VDD_1V8
Xq_reg reset clk data q VSS VDD_1V8 DFRRQHDLLX0
.ENDS

.SUBCKT dff_async_rst_969 data clk reset q VSS VDD_1V8
Xq_reg reset clk data q VSS VDD_1V8 DFRRQHDLLX0
.ENDS

.SUBCKT dff_async_rst_968 data clk reset q VSS VDD_1V8
Xq_reg reset clk data q VSS VDD_1V8 DFRRQHDLLX0
.ENDS

.SUBCKT dff_async_rst_967 data clk reset q VSS VDD_1V8
Xq_reg reset clk data q VSS VDD_1V8 DFRRQHDLLX0
.ENDS

.SUBCKT dff_async_rst_966 data clk reset q VSS VDD_1V8
Xq_reg reset clk data q VSS VDD_1V8 DFRRQHDLLX0
.ENDS

.SUBCKT dff_async_rst_965 data clk reset q VSS VDD_1V8
Xq_reg reset clk data q VSS VDD_1V8 DFRRQHDLLX0
.ENDS

.SUBCKT dff_async_rst_964 data clk reset q VSS VDD_1V8
Xq_reg reset clk data q VSS VDD_1V8 DFRRQHDLLX0
.ENDS

.SUBCKT dff_async_rst_963 data clk reset q VSS VDD_1V8
Xq_reg reset clk data q VSS VDD_1V8 DFRRQHDLLX0
.ENDS

.SUBCKT dff_async_rst_962 data clk reset q VSS VDD_1V8
Xq_reg reset clk data q VSS VDD_1V8 DFRRQHDLLX0
.ENDS

.SUBCKT dff_async_rst_961 data clk reset q VSS VDD_1V8
Xq_reg reset clk data q VSS VDD_1V8 DFRRQHDLLX0
.ENDS

.SUBCKT dff_async_rst_960 data clk reset q VSS VDD_1V8
Xq_reg reset clk data q VSS VDD_1V8 DFRRQHDLLX0
.ENDS

.SUBCKT dff_async_rst_959 data clk reset q VSS VDD_1V8
Xq_reg reset clk data q VSS VDD_1V8 DFRRQHDLLX0
.ENDS

.SUBCKT dff_async_rst_958 data clk reset q VSS VDD_1V8
Xq_reg reset clk data q VSS VDD_1V8 DFRRQHDLLX0
.ENDS

.SUBCKT dff_async_rst_957 data clk reset q VSS VDD_1V8
Xq_reg reset clk data q VSS VDD_1V8 DFRRQHDLLX0
.ENDS

.SUBCKT dff_async_rst_956 data clk reset q VSS VDD_1V8
Xq_reg reset clk data q VSS VDD_1V8 DFRRQHDLLX0
.ENDS

.SUBCKT dff_async_rst_955 data clk reset q VSS VDD_1V8
Xq_reg reset clk data q VSS VDD_1V8 DFRRQHDLLX0
.ENDS

.SUBCKT dff_async_rst_954 data clk reset q VSS VDD_1V8
Xq_reg reset clk data q VSS VDD_1V8 DFRRQHDLLX0
.ENDS

.SUBCKT dff_async_rst_953 data clk reset q VSS VDD_1V8
Xq_reg reset clk data q VSS VDD_1V8 DFRRQHDLLX0
.ENDS

.SUBCKT dff_async_rst_952 data clk reset q VSS VDD_1V8
Xq_reg reset clk data q VSS VDD_1V8 DFRRQHDLLX0
.ENDS

.SUBCKT dff_async_rst_951 data clk reset q VSS VDD_1V8
Xq_reg reset clk data q VSS VDD_1V8 DFRRQHDLLX0
.ENDS

.SUBCKT dff_async_rst_950 data clk reset q VSS VDD_1V8
Xq_reg reset clk data q VSS VDD_1V8 DFRRQHDLLX0
.ENDS

.SUBCKT dff_async_rst_949 data clk reset q VSS VDD_1V8
Xq_reg reset clk data q VSS VDD_1V8 DFRRQHDLLX0
.ENDS

.SUBCKT dff_async_rst_948 data clk reset q VSS VDD_1V8
Xq_reg reset clk data q VSS VDD_1V8 DFRRQHDLLX0
.ENDS

.SUBCKT dff_async_rst_947 data clk reset q VSS VDD_1V8
Xq_reg reset clk data q VSS VDD_1V8 DFRRQHDLLX0
.ENDS

.SUBCKT dff_async_rst_946 data clk reset q VSS VDD_1V8
Xq_reg reset clk data q VSS VDD_1V8 DFRRQHDLLX0
.ENDS

.SUBCKT dff_async_rst_945 data clk reset q VSS VDD_1V8
Xq_reg reset clk data q VSS VDD_1V8 DFRRQHDLLX0
.ENDS

.SUBCKT dff_async_rst_944 data clk reset q VSS VDD_1V8
Xq_reg reset clk data q VSS VDD_1V8 DFRRQHDLLX0
.ENDS

.SUBCKT dff_async_rst_943 data clk reset q VSS VDD_1V8
Xq_reg reset clk data q VSS VDD_1V8 DFRRQHDLLX0
.ENDS

.SUBCKT dff_async_rst_942 data clk reset q VSS VDD_1V8
Xq_reg reset clk data q VSS VDD_1V8 DFRRQHDLLX0
.ENDS

.SUBCKT dff_async_rst_941 data clk reset q VSS VDD_1V8
Xq_reg reset clk data q VSS VDD_1V8 DFRRQHDLLX0
.ENDS

.SUBCKT dff_async_rst_940 data clk reset q VSS VDD_1V8
Xq_reg reset clk data q VSS VDD_1V8 DFRRQHDLLX0
.ENDS

.SUBCKT dff_async_rst_939 data clk reset q VSS VDD_1V8
Xq_reg reset clk data q VSS VDD_1V8 DFRRQHDLLX0
.ENDS

.SUBCKT dff_async_rst_938 data clk reset q VSS VDD_1V8
Xq_reg reset clk data q VSS VDD_1V8 DFRRQHDLLX0
.ENDS

.SUBCKT dff_async_rst_937 data clk reset q VSS VDD_1V8
Xq_reg reset clk data q VSS VDD_1V8 DFRRQHDLLX0
.ENDS

.SUBCKT dff_async_rst_936 data clk reset q VSS VDD_1V8
Xq_reg reset clk data q VSS VDD_1V8 DFRRQHDLLX0
.ENDS

.SUBCKT dff_async_rst_935 data clk reset q VSS VDD_1V8
Xq_reg reset clk data q VSS VDD_1V8 DFRRQHDLLX0
.ENDS

.SUBCKT dff_async_rst_934 data clk reset q VSS VDD_1V8
Xq_reg reset clk data q VSS VDD_1V8 DFRRQHDLLX0
.ENDS

.SUBCKT dff_async_rst_933 data clk reset q VSS VDD_1V8
Xq_reg reset clk data q VSS VDD_1V8 DFRRQHDLLX0
.ENDS

.SUBCKT dff_async_rst_931 data clk reset q VSS VDD_1V8
Xq_reg reset clk data q VSS VDD_1V8 DFRRQHDLLX0
.ENDS

.SUBCKT Counter_arb_mx_cnt3_0 count[1] count[0] clk rst VSS VDD_1V8
XU4 VSS N6 count[1] count[0] VDD_1V8 NO2HDLLX0
XU5 VSS VDD_1V8 N7 count[0] count[1] NO2I1HDLLX0
Xcount_reg_1_ rst clk N7 count[1] VSS VDD_1V8 DFRRQHDLLX0
Xcount_reg_0_ rst clk N6 count[0] VSS VDD_1V8 DFRRQHDLLX0
.ENDS

.SUBCKT dff_async_rst_6 data clk reset q VSS VDD_1V8
Xq_reg reset clk data q VSS VDD_1V8 DFRRQHDLLX0
.ENDS

.SUBCKT dff_async_rst_5 data clk reset q VSS VDD_1V8
Xq_reg reset clk data q VSS VDD_1V8 DFRRQHDLLX0
.ENDS

.SUBCKT dff_async_rst_4 data clk reset q VSS VDD_1V8
Xq_reg reset clk data q VSS VDD_1V8 DFRRQHDLLX0
.ENDS

.SUBCKT dff_async_rst_3 data clk reset q VSS VDD_1V8
Xq_reg reset clk data q VSS VDD_1V8 DFRRQHDLLX0
.ENDS

.SUBCKT dff_async_rst_2 data clk reset q VSS VDD_1V8
Xq_reg reset clk data q VSS VDD_1V8 DFRRQHDLLX0
.ENDS

.SUBCKT dff_async_rst_1 data clk reset q VSS VDD_1V8
Xq_reg reset clk data q VSS VDD_1V8 DFRRQHDLLX0
.ENDS

.SUBCKT dff_async_rst_0 data clk reset q VSS VDD_1V8
Xq_reg reset clk data q VSS VDD_1V8 DFRRQHDLLX0
.ENDS

.SUBCKT tri_buf_1 a b en VSS VDD_1V8
Xb_tri VSS en VDD_1V8 a b BTHHDLLX1
.ENDS

.SUBCKT tri_buf_0 a b en VSS VDD_1V8
Xb_tri VSS en VDD_1V8 a b BTHHDLLX1
.ENDS

.SUBCKT tri_buf_70 a b en VSS VDD_1V8
Xb_tri VSS en VDD_1V8 a b BTHHDLLX1
.ENDS

.SUBCKT tri_buf_69 a b en VSS VDD_1V8
Xb_tri VSS en VDD_1V8 a b BTHHDLLX1
.ENDS

.SUBCKT tri_buf_68 a b en VSS VDD_1V8
Xb_tri VSS en VDD_1V8 a b BTHHDLLX1
.ENDS

.SUBCKT tri_buf_67 a b en VSS VDD_1V8
Xb_tri VSS en VDD_1V8 a b BTHHDLLX1
.ENDS

.SUBCKT tri_buf_66 a b en VSS VDD_1V8
Xb_tri VSS en VDD_1V8 a b BTHHDLLX1
.ENDS

.SUBCKT tri_buf_65 a b en VSS VDD_1V8
Xb_tri VSS en VDD_1V8 a b BTHHDLLX1
.ENDS

.SUBCKT tri_buf_64 a b en VSS VDD_1V8
Xb_tri VSS en VDD_1V8 a b BTHHDLLX1
.ENDS

.SUBCKT tri_buf_63 a b en VSS VDD_1V8
Xb_tri VSS en VDD_1V8 a b BTHHDLLX1
.ENDS

.SUBCKT tri_buf_62 a b en VSS VDD_1V8
Xb_tri VSS en VDD_1V8 a b BTHHDLLX1
.ENDS

.SUBCKT tri_buf_61 a b en VSS VDD_1V8
Xb_tri VSS en VDD_1V8 a b BTHHDLLX1
.ENDS

.SUBCKT tri_buf_60 a b en VSS VDD_1V8
Xb_tri VSS en VDD_1V8 a b BTHHDLLX1
.ENDS

.SUBCKT tri_buf_59 a b en VSS VDD_1V8
Xb_tri VSS en VDD_1V8 a b BTHHDLLX1
.ENDS

.SUBCKT tri_buf_58 a b en VSS VDD_1V8
Xb_tri VSS en VDD_1V8 a b BTHHDLLX1
.ENDS

.SUBCKT tri_buf_57 a b en VSS VDD_1V8
Xb_tri VSS en VDD_1V8 a b BTHHDLLX1
.ENDS

.SUBCKT tri_buf_56 a b en VSS VDD_1V8
Xb_tri VSS en VDD_1V8 a b BTHHDLLX1
.ENDS

.SUBCKT tri_buf_55 a b en VSS VDD_1V8
Xb_tri VSS en VDD_1V8 a b BTHHDLLX1
.ENDS

.SUBCKT tri_buf_54 a b en VSS VDD_1V8
Xb_tri VSS en VDD_1V8 a b BTHHDLLX1
.ENDS

.SUBCKT tri_buf_53 a b en VSS VDD_1V8
Xb_tri VSS en VDD_1V8 a b BTHHDLLX1
.ENDS

.SUBCKT tri_buf_52 a b en VSS VDD_1V8
Xb_tri VSS en VDD_1V8 a b BTHHDLLX1
.ENDS

.SUBCKT tri_buf_51 a b en VSS VDD_1V8
Xb_tri VSS en VDD_1V8 a b BTHHDLLX1
.ENDS

.SUBCKT tri_buf_50 a b en VSS VDD_1V8
Xb_tri VSS en VDD_1V8 a b BTHHDLLX1
.ENDS

.SUBCKT tri_buf_49 a b en VSS VDD_1V8
Xb_tri VSS en VDD_1V8 a b BTHHDLLX1
.ENDS

.SUBCKT tri_buf_48 a b en VSS VDD_1V8
Xb_tri VSS en VDD_1V8 a b BTHHDLLX1
.ENDS

.SUBCKT tri_buf_47 a b en VSS VDD_1V8
Xb_tri VSS en VDD_1V8 a b BTHHDLLX1
.ENDS

.SUBCKT tri_buf_46 a b en VSS VDD_1V8
Xb_tri VSS en VDD_1V8 a b BTHHDLLX1
.ENDS

.SUBCKT tri_buf_45 a b en VSS VDD_1V8
Xb_tri VSS en VDD_1V8 a b BTHHDLLX1
.ENDS

.SUBCKT tri_buf_44 a b en VSS VDD_1V8
Xb_tri VSS en VDD_1V8 a b BTHHDLLX1
.ENDS

.SUBCKT tri_buf_43 a b en VSS VDD_1V8
Xb_tri VSS en VDD_1V8 a b BTHHDLLX1
.ENDS

.SUBCKT tri_buf_42 a b en VSS VDD_1V8
Xb_tri VSS en VDD_1V8 a b BTHHDLLX1
.ENDS

.SUBCKT tri_buf_41 a b en VSS VDD_1V8
Xb_tri VSS en VDD_1V8 a b BTHHDLLX1
.ENDS

.SUBCKT tri_buf_40 a b en VSS VDD_1V8
Xb_tri VSS en VDD_1V8 a b BTHHDLLX1
.ENDS

.SUBCKT tri_buf_39 a b en VSS VDD_1V8
Xb_tri VSS en VDD_1V8 a b BTHHDLLX1
.ENDS

.SUBCKT tri_buf_38 a b en VSS VDD_1V8
Xb_tri VSS en VDD_1V8 a b BTHHDLLX1
.ENDS

.SUBCKT tri_buf_37 a b en VSS VDD_1V8
Xb_tri VSS en VDD_1V8 a b BTHHDLLX1
.ENDS

.SUBCKT tri_buf_36 a b en VSS VDD_1V8
Xb_tri VSS en VDD_1V8 a b BTHHDLLX1
.ENDS

.SUBCKT tri_buf_35 a b en VSS VDD_1V8
Xb_tri VSS en VDD_1V8 a b BTHHDLLX1
.ENDS

.SUBCKT tri_buf_34 a b en VSS VDD_1V8
Xb_tri VSS en VDD_1V8 a b BTHHDLLX1
.ENDS

.SUBCKT tri_buf_33 a b en VSS VDD_1V8
Xb_tri VSS en VDD_1V8 a b BTHHDLLX1
.ENDS

.SUBCKT tri_buf_32 a b en VSS VDD_1V8
Xb_tri VSS en VDD_1V8 a b BTHHDLLX1
.ENDS

.SUBCKT tri_buf_31 a b en VSS VDD_1V8
Xb_tri VSS en VDD_1V8 a b BTHHDLLX1
.ENDS

.SUBCKT tri_buf_30 a b en VSS VDD_1V8
Xb_tri VSS en VDD_1V8 a b BTHHDLLX1
.ENDS

.SUBCKT tri_buf_29 a b en VSS VDD_1V8
Xb_tri VSS en VDD_1V8 a b BTHHDLLX1
.ENDS

.SUBCKT tri_buf_28 a b en VSS VDD_1V8
Xb_tri VSS en VDD_1V8 a b BTHHDLLX1
.ENDS

.SUBCKT tri_buf_27 a b en VSS VDD_1V8
Xb_tri VSS en VDD_1V8 a b BTHHDLLX1
.ENDS

.SUBCKT tri_buf_26 a b en VSS VDD_1V8
Xb_tri VSS en VDD_1V8 a b BTHHDLLX1
.ENDS

.SUBCKT tri_buf_25 a b en VSS VDD_1V8
Xb_tri VSS en VDD_1V8 a b BTHHDLLX1
.ENDS

.SUBCKT tri_buf_24 a b en VSS VDD_1V8
Xb_tri VSS en VDD_1V8 a b BTHHDLLX1
.ENDS

.SUBCKT tri_buf_23 a b en VSS VDD_1V8
Xb_tri VSS en VDD_1V8 a b BTHHDLLX1
.ENDS

.SUBCKT tri_buf_22 a b en VSS VDD_1V8
Xb_tri VSS en VDD_1V8 a b BTHHDLLX1
.ENDS

.SUBCKT tri_buf_21 a b en VSS VDD_1V8
Xb_tri VSS en VDD_1V8 a b BTHHDLLX1
.ENDS

.SUBCKT tri_buf_20 a b en VSS VDD_1V8
Xb_tri VSS en VDD_1V8 a b BTHHDLLX1
.ENDS

.SUBCKT tri_buf_19 a b en VSS VDD_1V8
Xb_tri VSS en VDD_1V8 a b BTHHDLLX1
.ENDS

.SUBCKT tri_buf_18 a b en VSS VDD_1V8
Xb_tri VSS en VDD_1V8 a b BTHHDLLX1
.ENDS

.SUBCKT tri_buf_17 a b en VSS VDD_1V8
Xb_tri VSS en VDD_1V8 a b BTHHDLLX1
.ENDS

.SUBCKT tri_buf_16 a b en VSS VDD_1V8
Xb_tri VSS en VDD_1V8 a b BTHHDLLX1
.ENDS

.SUBCKT tri_buf_15 a b en VSS VDD_1V8
Xb_tri VSS en VDD_1V8 a b BTHHDLLX1
.ENDS

.SUBCKT tri_buf_14 a b en VSS VDD_1V8
Xb_tri VSS en VDD_1V8 a b BTHHDLLX1
.ENDS

.SUBCKT tri_buf_13 a b en VSS VDD_1V8
Xb_tri VSS en VDD_1V8 a b BTHHDLLX1
.ENDS

.SUBCKT tri_buf_12 a b en VSS VDD_1V8
Xb_tri VSS en VDD_1V8 a b BTHHDLLX1
.ENDS

.SUBCKT tri_buf_11 a b en VSS VDD_1V8
Xb_tri VSS en VDD_1V8 a b BTHHDLLX1
.ENDS

.SUBCKT tri_buf_10 a b en VSS VDD_1V8
Xb_tri VSS en VDD_1V8 a b BTHHDLLX2
.ENDS

.SUBCKT tri_buf_9 a b en VSS VDD_1V8
Xb_tri VSS en VDD_1V8 a b BTHHDLLX2
.ENDS

.SUBCKT tri_buf_8 a b en VSS VDD_1V8
Xb_tri VSS en VDD_1V8 a b BTHHDLLX1
.ENDS

.SUBCKT tri_buf_7 a b en VSS VDD_1V8
Xb_tri VSS en VDD_1V8 a b BTHHDLLX1
.ENDS

.SUBCKT tri_buf_6 a b en VSS VDD_1V8
XU1 n1 VSS VDD_1V8 LOGIC0HDLL
Xb_tri VSS en VDD_1V8 n1 b BTHHDLLX1
.ENDS

.SUBCKT dff_async_rst_930 data clk reset q VSS VDD_1V8
Xq_reg reset clk data q VSS VDD_1V8 DFRRQHDLLX0
.ENDS

.SUBCKT dff_async_rst_929 data clk reset q VSS VDD_1V8
Xq_reg reset clk data q VSS VDD_1V8 DFRRQHDLLX0
.ENDS

.SUBCKT dff_async_rst_928 data clk reset q VSS VDD_1V8
Xq_reg reset clk data q VSS VDD_1V8 DFRRQHDLLX0
.ENDS

.SUBCKT dff_async_rst_927 data clk reset q VSS VDD_1V8
Xq_reg reset clk data q VSS VDD_1V8 DFRRQHDLLX0
.ENDS

.SUBCKT dff_async_rst_926 data clk reset q VSS VDD_1V8
Xq_reg reset clk data q VSS VDD_1V8 DFRRQHDLLX0
.ENDS

.SUBCKT dff_async_rst_925 data clk reset q VSS VDD_1V8
Xq_reg reset clk data q VSS VDD_1V8 DFRRQHDLLX0
.ENDS

.SUBCKT dff_async_rst_924 data clk reset q VSS VDD_1V8
Xq_reg reset clk data q VSS VDD_1V8 DFRRQHDLLX0
.ENDS

.SUBCKT dff_async_rst_923 data clk reset q VSS VDD_1V8
Xq_reg reset clk data q VSS VDD_1V8 DFRRQHDLLX0
.ENDS

.SUBCKT dff_async_rst_922 data clk reset q VSS VDD_1V8
Xq_reg reset clk data q VSS VDD_1V8 DFRRQHDLLX0
.ENDS

.SUBCKT dff_async_rst_921 data clk reset q VSS VDD_1V8
Xq_reg reset clk data q VSS VDD_1V8 DFRRQHDLLX0
.ENDS

.SUBCKT dff_async_rst_920 data clk reset q VSS VDD_1V8
Xq_reg reset clk data q VSS VDD_1V8 DFRRQHDLLX0
.ENDS

.SUBCKT dff_async_rst_919 data clk reset q VSS VDD_1V8
Xq_reg reset clk data q VSS VDD_1V8 DFRRQHDLLX0
.ENDS

.SUBCKT dff_async_rst_918 data clk reset q VSS VDD_1V8
Xq_reg reset clk data q VSS VDD_1V8 DFRRQHDLLX0
.ENDS

.SUBCKT dff_async_rst_917 data clk reset q VSS VDD_1V8
Xq_reg reset clk data q VSS VDD_1V8 DFRRQHDLLX0
.ENDS

.SUBCKT dff_async_rst_916 data clk reset q VSS VDD_1V8
Xq_reg reset clk data q VSS VDD_1V8 DFRRQHDLLX0
.ENDS

.SUBCKT dff_async_rst_915 data clk reset q VSS VDD_1V8
Xq_reg reset clk data q VSS VDD_1V8 DFRRQHDLLX0
.ENDS

.SUBCKT dff_async_rst_914 data clk reset q VSS VDD_1V8
Xq_reg reset clk data q VSS VDD_1V8 DFRRQHDLLX0
.ENDS

.SUBCKT dff_async_rst_913 data clk reset q VSS VDD_1V8
Xq_reg reset clk data q VSS VDD_1V8 DFRRQHDLLX0
.ENDS

.SUBCKT dff_async_rst_912 data clk reset q VSS VDD_1V8
Xq_reg reset clk data q VSS VDD_1V8 DFRRQHDLLX0
.ENDS

.SUBCKT dff_async_rst_911 data clk reset q VSS VDD_1V8
Xq_reg reset clk data q VSS VDD_1V8 DFRRQHDLLX0
.ENDS

.SUBCKT dff_async_rst_910 data clk reset q VSS VDD_1V8
Xq_reg reset clk data q VSS VDD_1V8 DFRRQHDLLX0
.ENDS

.SUBCKT dff_async_rst_909 data clk reset q VSS VDD_1V8
Xq_reg reset clk data q VSS VDD_1V8 DFRRQHDLLX0
.ENDS

.SUBCKT dff_async_rst_908 data clk reset q VSS VDD_1V8
Xq_reg reset clk data q VSS VDD_1V8 DFRRQHDLLX0
.ENDS

.SUBCKT dff_async_rst_907 data clk reset q VSS VDD_1V8
Xq_reg reset clk data q VSS VDD_1V8 DFRRQHDLLX0
.ENDS

.SUBCKT dff_async_rst_906 data clk reset q VSS VDD_1V8
Xq_reg reset clk data q VSS VDD_1V8 DFRRQHDLLX0
.ENDS

.SUBCKT dff_async_rst_905 data clk reset q VSS VDD_1V8
Xq_reg reset clk data q VSS VDD_1V8 DFRRQHDLLX0
.ENDS

.SUBCKT dff_async_rst_904 data clk reset q VSS VDD_1V8
Xq_reg reset clk data q VSS VDD_1V8 DFRRQHDLLX0
.ENDS

.SUBCKT dff_async_rst_903 data clk reset q VSS VDD_1V8
Xq_reg reset clk data q VSS VDD_1V8 DFRRQHDLLX0
.ENDS

.SUBCKT dff_async_rst_902 data clk reset q VSS VDD_1V8
Xq_reg reset clk data q VSS VDD_1V8 DFRRQHDLLX0
.ENDS

.SUBCKT dff_async_rst_901 data clk reset q VSS VDD_1V8
Xq_reg reset clk data q VSS VDD_1V8 DFRRQHDLLX0
.ENDS

.SUBCKT dff_async_rst_900 data clk reset q VSS VDD_1V8
Xq_reg reset clk data q VSS VDD_1V8 DFRRQHDLLX0
.ENDS

.SUBCKT dff_async_rst_899 data clk reset q VSS VDD_1V8
Xq_reg reset clk data q VSS VDD_1V8 DFRRQHDLLX0
.ENDS

.SUBCKT dff_async_rst_898 data clk reset q VSS VDD_1V8
Xq_reg reset clk data q VSS VDD_1V8 DFRRQHDLLX0
.ENDS

.SUBCKT dff_async_rst_897 data clk reset q VSS VDD_1V8
Xq_reg reset clk data q VSS VDD_1V8 DFRRQHDLLX0
.ENDS

.SUBCKT dff_async_rst_896 data clk reset q VSS VDD_1V8
Xq_reg reset clk data q VSS VDD_1V8 DFRRQHDLLX0
.ENDS

.SUBCKT dff_async_rst_895 data clk reset q VSS VDD_1V8
Xq_reg reset clk data q VSS VDD_1V8 DFRRQHDLLX0
.ENDS

.SUBCKT dff_async_rst_894 data clk reset q VSS VDD_1V8
Xq_reg reset clk data q VSS VDD_1V8 DFRRQHDLLX0
.ENDS

.SUBCKT dff_async_rst_893 data clk reset q VSS VDD_1V8
Xq_reg reset clk data q VSS VDD_1V8 DFRRQHDLLX0
.ENDS

.SUBCKT dff_async_rst_892 data clk reset q VSS VDD_1V8
Xq_reg reset clk data q VSS VDD_1V8 DFRRQHDLLX0
.ENDS

.SUBCKT dff_async_rst_891 data clk reset q VSS VDD_1V8
Xq_reg reset clk data q VSS VDD_1V8 DFRRQHDLLX0
.ENDS

.SUBCKT dff_async_rst_890 data clk reset q VSS VDD_1V8
Xq_reg reset clk data q VSS VDD_1V8 DFRRQHDLLX0
.ENDS

.SUBCKT dff_async_rst_889 data clk reset q VSS VDD_1V8
Xq_reg reset clk data q VSS VDD_1V8 DFRRQHDLLX0
.ENDS

.SUBCKT dff_async_rst_888 data clk reset q VSS VDD_1V8
Xq_reg reset clk data q VSS VDD_1V8 DFRRQHDLLX0
.ENDS

.SUBCKT dff_async_rst_887 data clk reset q VSS VDD_1V8
Xq_reg reset clk data q VSS VDD_1V8 DFRRQHDLLX0
.ENDS

.SUBCKT dff_async_rst_886 data clk reset q VSS VDD_1V8
Xq_reg reset clk data q VSS VDD_1V8 DFRRQHDLLX0
.ENDS

.SUBCKT dff_async_rst_885 data clk reset q VSS VDD_1V8
Xq_reg reset clk data q VSS VDD_1V8 DFRRQHDLLX0
.ENDS

.SUBCKT dff_async_rst_884 data clk reset q VSS VDD_1V8
Xq_reg reset clk data q VSS VDD_1V8 DFRRQHDLLX0
.ENDS

.SUBCKT dff_async_rst_883 data clk reset q VSS VDD_1V8
Xq_reg reset clk data q VSS VDD_1V8 DFRRQHDLLX0
.ENDS

.SUBCKT dff_async_rst_882 data clk reset q VSS VDD_1V8
Xq_reg reset clk data q VSS VDD_1V8 DFRRQHDLLX0
.ENDS

.SUBCKT dff_async_rst_881 data clk reset q VSS VDD_1V8
Xq_reg reset clk data q VSS VDD_1V8 DFRRQHDLLX0
.ENDS

.SUBCKT dff_async_rst_880 data clk reset q VSS VDD_1V8
Xq_reg reset clk data q VSS VDD_1V8 DFRRQHDLLX0
.ENDS

.SUBCKT dff_async_rst_879 data clk reset q VSS VDD_1V8
Xq_reg reset clk data q VSS VDD_1V8 DFRRQHDLLX0
.ENDS

.SUBCKT dff_async_rst_878 data clk reset q VSS VDD_1V8
Xq_reg reset clk data q VSS VDD_1V8 DFRRQHDLLX0
.ENDS

.SUBCKT dff_async_rst_877 data clk reset q VSS VDD_1V8
Xq_reg reset clk data q VSS VDD_1V8 DFRRQHDLLX0
.ENDS

.SUBCKT dff_async_rst_876 data clk reset q VSS VDD_1V8
Xq_reg reset clk data q VSS VDD_1V8 DFRRQHDLLX0
.ENDS

.SUBCKT dff_async_rst_875 data clk reset q VSS VDD_1V8
Xq_reg reset clk data q VSS VDD_1V8 DFRRQHDLLX0
.ENDS

.SUBCKT dff_async_rst_874 data clk reset q VSS VDD_1V8
Xq_reg reset clk data q VSS VDD_1V8 DFRRQHDLLX0
.ENDS

.SUBCKT dff_async_rst_873 data clk reset q VSS VDD_1V8
Xq_reg reset clk data q VSS VDD_1V8 DFRRQHDLLX0
.ENDS

.SUBCKT dff_async_rst_872 data clk reset q VSS VDD_1V8
Xq_reg reset clk data q VSS VDD_1V8 DFRRQHDLLX0
.ENDS

.SUBCKT dff_async_rst_871 data clk reset q VSS VDD_1V8
Xq_reg reset clk data q VSS VDD_1V8 DFRRQHDLLX0
.ENDS

.SUBCKT dff_async_rst_870 data clk reset q VSS VDD_1V8
Xq_reg reset clk data q VSS VDD_1V8 DFRRQHDLLX0
.ENDS

.SUBCKT dff_async_rst_869 data clk reset q VSS VDD_1V8
Xq_reg reset clk data q VSS VDD_1V8 DFRRQHDLLX0
.ENDS

.SUBCKT dff_async_rst_865 data clk reset q VSS VDD_1V8
Xq_reg reset clk data q VSS VDD_1V8 DFRRQHDLLX0
.ENDS

.SUBCKT dff_async_rst_864 data clk reset q VSS VDD_1V8
Xq_reg reset clk data q VSS VDD_1V8 DFRRQHDLLX0
.ENDS

.SUBCKT dff_async_rst_863 data clk reset q VSS VDD_1V8
Xq_reg reset clk data q VSS VDD_1V8 DFRRQHDLLX0
.ENDS

.SUBCKT dff_async_rst_862 data clk reset q VSS VDD_1V8
Xq_reg reset clk data q VSS VDD_1V8 DFRRQHDLLX0
.ENDS

.SUBCKT dff_async_rst_861 data clk reset q VSS VDD_1V8
Xq_reg reset clk data q VSS VDD_1V8 DFRRQHDLLX0
.ENDS

.SUBCKT dff_async_rst_860 data clk reset q VSS VDD_1V8
Xq_reg reset clk data q VSS VDD_1V8 DFRRQHDLLX0
.ENDS

.SUBCKT dff_async_rst_859 data clk reset q VSS VDD_1V8
Xq_reg reset clk data q VSS VDD_1V8 DFRRQHDLLX0
.ENDS

.SUBCKT dff_async_rst_858 data clk reset q VSS VDD_1V8
Xq_reg reset clk data q VSS VDD_1V8 DFRRQHDLLX0
.ENDS

.SUBCKT dff_async_rst_857 data clk reset q VSS VDD_1V8
Xq_reg reset clk data q VSS VDD_1V8 DFRRQHDLLX0
.ENDS

.SUBCKT dff_async_rst_856 data clk reset q VSS VDD_1V8
Xq_reg reset clk data q VSS VDD_1V8 DFRRQHDLLX0
.ENDS

.SUBCKT dff_async_rst_855 data clk reset q VSS VDD_1V8
Xq_reg reset clk data q VSS VDD_1V8 DFRRQHDLLX0
.ENDS

.SUBCKT dff_async_rst_854 data clk reset q VSS VDD_1V8
Xq_reg reset clk data q VSS VDD_1V8 DFRRQHDLLX0
.ENDS

.SUBCKT dff_async_rst_853 data clk reset q VSS VDD_1V8
Xq_reg reset clk data q VSS VDD_1V8 DFRRQHDLLX0
.ENDS

.SUBCKT dff_async_rst_852 data clk reset q VSS VDD_1V8
Xq_reg reset clk data q VSS VDD_1V8 DFRRQHDLLX0
.ENDS

.SUBCKT dff_async_rst_851 data clk reset q VSS VDD_1V8
Xq_reg reset clk data q VSS VDD_1V8 DFRRQHDLLX0
.ENDS

.SUBCKT dff_async_rst_850 data clk reset q VSS VDD_1V8
Xq_reg reset clk data q VSS VDD_1V8 DFRRQHDLLX0
.ENDS

.SUBCKT dff_async_rst_849 data clk reset q VSS VDD_1V8
Xq_reg reset clk data q VSS VDD_1V8 DFRRQHDLLX0
.ENDS

.SUBCKT dff_async_rst_848 data clk reset q VSS VDD_1V8
Xq_reg reset clk data q VSS VDD_1V8 DFRRQHDLLX0
.ENDS

.SUBCKT dff_async_rst_847 data clk reset q VSS VDD_1V8
Xq_reg reset clk data q VSS VDD_1V8 DFRRQHDLLX0
.ENDS

.SUBCKT dff_async_rst_846 data clk reset q VSS VDD_1V8
Xq_reg reset clk data q VSS VDD_1V8 DFRRQHDLLX0
.ENDS

.SUBCKT dff_async_rst_845 data clk reset q VSS VDD_1V8
Xq_reg reset clk data q VSS VDD_1V8 DFRRQHDLLX0
.ENDS

.SUBCKT dff_async_rst_844 data clk reset q VSS VDD_1V8
Xq_reg reset clk data q VSS VDD_1V8 DFRRQHDLLX0
.ENDS

.SUBCKT dff_async_rst_843 data clk reset q VSS VDD_1V8
Xq_reg reset clk data q VSS VDD_1V8 DFRRQHDLLX0
.ENDS

.SUBCKT dff_async_rst_842 data clk reset q VSS VDD_1V8
Xq_reg reset clk data q VSS VDD_1V8 DFRRQHDLLX0
.ENDS

.SUBCKT dff_async_rst_841 data clk reset q VSS VDD_1V8
Xq_reg reset clk data q VSS VDD_1V8 DFRRQHDLLX0
.ENDS

.SUBCKT dff_async_rst_840 data clk reset q VSS VDD_1V8
Xq_reg reset clk data q VSS VDD_1V8 DFRRQHDLLX0
.ENDS

.SUBCKT dff_async_rst_839 data clk reset q VSS VDD_1V8
Xq_reg reset clk data q VSS VDD_1V8 DFRRQHDLLX0
.ENDS

.SUBCKT dff_async_rst_838 data clk reset q VSS VDD_1V8
Xq_reg reset clk data q VSS VDD_1V8 DFRRQHDLLX0
.ENDS

.SUBCKT dff_async_rst_837 data clk reset q VSS VDD_1V8
Xq_reg reset clk data q VSS VDD_1V8 DFRRQHDLLX0
.ENDS

.SUBCKT dff_async_rst_836 data clk reset q VSS VDD_1V8
Xq_reg reset clk data q VSS VDD_1V8 DFRRQHDLLX0
.ENDS

.SUBCKT dff_async_rst_835 data clk reset q VSS VDD_1V8
Xq_reg reset clk data q VSS VDD_1V8 DFRRQHDLLX0
.ENDS

.SUBCKT dff_async_rst_834 data clk reset q VSS VDD_1V8
Xq_reg reset clk data q VSS VDD_1V8 DFRRQHDLLX0
.ENDS

.SUBCKT dff_async_rst_833 data clk reset q VSS VDD_1V8
Xq_reg reset clk data q VSS VDD_1V8 DFRRQHDLLX0
.ENDS

.SUBCKT dff_async_rst_832 data clk reset q VSS VDD_1V8
Xq_reg reset clk data q VSS VDD_1V8 DFRRQHDLLX0
.ENDS

.SUBCKT dff_async_rst_831 data clk reset q VSS VDD_1V8
Xq_reg reset clk data q VSS VDD_1V8 DFRRQHDLLX0
.ENDS

.SUBCKT dff_async_rst_830 data clk reset q VSS VDD_1V8
Xq_reg reset clk data q VSS VDD_1V8 DFRRQHDLLX0
.ENDS

.SUBCKT dff_async_rst_829 data clk reset q VSS VDD_1V8
Xq_reg reset clk data q VSS VDD_1V8 DFRRQHDLLX0
.ENDS

.SUBCKT dff_async_rst_828 data clk reset q VSS VDD_1V8
Xq_reg reset clk data q VSS VDD_1V8 DFRRQHDLLX0
.ENDS

.SUBCKT dff_async_rst_827 data clk reset q VSS VDD_1V8
Xq_reg reset clk data q VSS VDD_1V8 DFRRQHDLLX0
.ENDS

.SUBCKT dff_async_rst_826 data clk reset q VSS VDD_1V8
Xq_reg reset clk data q VSS VDD_1V8 DFRRQHDLLX0
.ENDS

.SUBCKT dff_async_rst_825 data clk reset q VSS VDD_1V8
Xq_reg reset clk data q VSS VDD_1V8 DFRRQHDLLX0
.ENDS

.SUBCKT dff_async_rst_824 data clk reset q VSS VDD_1V8
Xq_reg reset clk data q VSS VDD_1V8 DFRRQHDLLX0
.ENDS

.SUBCKT dff_async_rst_823 data clk reset q VSS VDD_1V8
Xq_reg reset clk data q VSS VDD_1V8 DFRRQHDLLX0
.ENDS

.SUBCKT dff_async_rst_822 data clk reset q VSS VDD_1V8
Xq_reg reset clk data q VSS VDD_1V8 DFRRQHDLLX0
.ENDS

.SUBCKT dff_async_rst_821 data clk reset q VSS VDD_1V8
Xq_reg reset clk data q VSS VDD_1V8 DFRRQHDLLX0
.ENDS

.SUBCKT dff_async_rst_820 data clk reset q VSS VDD_1V8
Xq_reg reset clk data q VSS VDD_1V8 DFRRQHDLLX0
.ENDS

.SUBCKT dff_async_rst_819 data clk reset q VSS VDD_1V8
Xq_reg reset clk data q VSS VDD_1V8 DFRRQHDLLX0
.ENDS

.SUBCKT dff_async_rst_818 data clk reset q VSS VDD_1V8
Xq_reg reset clk data q VSS VDD_1V8 DFRRQHDLLX0
.ENDS

.SUBCKT dff_async_rst_817 data clk reset q VSS VDD_1V8
Xq_reg reset clk data q VSS VDD_1V8 DFRRQHDLLX0
.ENDS

.SUBCKT dff_async_rst_816 data clk reset q VSS VDD_1V8
Xq_reg reset clk data q VSS VDD_1V8 DFRRQHDLLX0
.ENDS

.SUBCKT dff_async_rst_815 data clk reset q VSS VDD_1V8
Xq_reg reset clk data q VSS VDD_1V8 DFRRQHDLLX0
.ENDS

.SUBCKT dff_async_rst_814 data clk reset q VSS VDD_1V8
Xq_reg reset clk data q VSS VDD_1V8 DFRRQHDLLX0
.ENDS

.SUBCKT dff_async_rst_813 data clk reset q VSS VDD_1V8
Xq_reg reset clk data q VSS VDD_1V8 DFRRQHDLLX0
.ENDS

.SUBCKT dff_async_rst_812 data clk reset q VSS VDD_1V8
Xq_reg reset clk data q VSS VDD_1V8 DFRRQHDLLX0
.ENDS

.SUBCKT dff_async_rst_811 data clk reset q VSS VDD_1V8
Xq_reg reset clk data q VSS VDD_1V8 DFRRQHDLLX0
.ENDS

.SUBCKT dff_async_rst_810 data clk reset q VSS VDD_1V8
Xq_reg reset clk data q VSS VDD_1V8 DFRRQHDLLX0
.ENDS

.SUBCKT dff_async_rst_809 data clk reset q VSS VDD_1V8
Xq_reg reset clk data q VSS VDD_1V8 DFRRQHDLLX0
.ENDS

.SUBCKT dff_async_rst_808 data clk reset q VSS VDD_1V8
Xq_reg reset clk data q VSS VDD_1V8 DFRRQHDLLX0
.ENDS

.SUBCKT dff_async_rst_807 data clk reset q VSS VDD_1V8
Xq_reg reset clk data q VSS VDD_1V8 DFRRQHDLLX0
.ENDS

.SUBCKT dff_async_rst_806 data clk reset q VSS VDD_1V8
Xq_reg reset clk data q VSS VDD_1V8 DFRRQHDLLX0
.ENDS

.SUBCKT dff_async_rst_805 data clk reset q VSS VDD_1V8
Xq_reg reset clk data q VSS VDD_1V8 DFRRQHDLLX0
.ENDS

.SUBCKT dff_async_rst_804 data clk reset q VSS VDD_1V8
Xq_reg reset clk data q VSS VDD_1V8 DFRRQHDLLX0
.ENDS

.SUBCKT dff_async_rst_800 data clk reset q VSS VDD_1V8
Xq_reg reset clk data q VSS VDD_1V8 DFRRQHDLLX0
.ENDS

.SUBCKT dff_async_rst_799 data clk reset q VSS VDD_1V8
Xq_reg reset clk data q VSS VDD_1V8 DFRRQHDLLX0
.ENDS

.SUBCKT dff_async_rst_798 data clk reset q VSS VDD_1V8
Xq_reg reset clk data q VSS VDD_1V8 DFRRQHDLLX0
.ENDS

.SUBCKT dff_async_rst_797 data clk reset q VSS VDD_1V8
Xq_reg reset clk data q VSS VDD_1V8 DFRRQHDLLX0
.ENDS

.SUBCKT dff_async_rst_796 data clk reset q VSS VDD_1V8
Xq_reg reset clk data q VSS VDD_1V8 DFRRQHDLLX0
.ENDS

.SUBCKT dff_async_rst_795 data clk reset q VSS VDD_1V8
Xq_reg reset clk data q VSS VDD_1V8 DFRRQHDLLX0
.ENDS

.SUBCKT dff_async_rst_794 data clk reset q VSS VDD_1V8
Xq_reg reset clk data q VSS VDD_1V8 DFRRQHDLLX0
.ENDS

.SUBCKT dff_async_rst_793 data clk reset q VSS VDD_1V8
Xq_reg reset clk data q VSS VDD_1V8 DFRRQHDLLX0
.ENDS

.SUBCKT dff_async_rst_792 data clk reset q VSS VDD_1V8
Xq_reg reset clk data q VSS VDD_1V8 DFRRQHDLLX0
.ENDS

.SUBCKT dff_async_rst_791 data clk reset q VSS VDD_1V8
Xq_reg reset clk data q VSS VDD_1V8 DFRRQHDLLX0
.ENDS

.SUBCKT dff_async_rst_790 data clk reset q VSS VDD_1V8
Xq_reg reset clk data q VSS VDD_1V8 DFRRQHDLLX0
.ENDS

.SUBCKT dff_async_rst_789 data clk reset q VSS VDD_1V8
Xq_reg reset clk data q VSS VDD_1V8 DFRRQHDLLX0
.ENDS

.SUBCKT dff_async_rst_788 data clk reset q VSS VDD_1V8
Xq_reg reset clk data q VSS VDD_1V8 DFRRQHDLLX0
.ENDS

.SUBCKT dff_async_rst_787 data clk reset q VSS VDD_1V8
Xq_reg reset clk data q VSS VDD_1V8 DFRRQHDLLX0
.ENDS

.SUBCKT dff_async_rst_786 data clk reset q VSS VDD_1V8
Xq_reg reset clk data q VSS VDD_1V8 DFRRQHDLLX0
.ENDS

.SUBCKT dff_async_rst_785 data clk reset q VSS VDD_1V8
Xq_reg reset clk data q VSS VDD_1V8 DFRRQHDLLX0
.ENDS

.SUBCKT dff_async_rst_784 data clk reset q VSS VDD_1V8
Xq_reg reset clk data q VSS VDD_1V8 DFRRQHDLLX0
.ENDS

.SUBCKT dff_async_rst_783 data clk reset q VSS VDD_1V8
Xq_reg reset clk data q VSS VDD_1V8 DFRRQHDLLX0
.ENDS

.SUBCKT dff_async_rst_782 data clk reset q VSS VDD_1V8
Xq_reg reset clk data q VSS VDD_1V8 DFRRQHDLLX0
.ENDS

.SUBCKT dff_async_rst_781 data clk reset q VSS VDD_1V8
Xq_reg reset clk data q VSS VDD_1V8 DFRRQHDLLX0
.ENDS

.SUBCKT dff_async_rst_780 data clk reset q VSS VDD_1V8
Xq_reg reset clk data q VSS VDD_1V8 DFRRQHDLLX0
.ENDS

.SUBCKT dff_async_rst_779 data clk reset q VSS VDD_1V8
Xq_reg reset clk data q VSS VDD_1V8 DFRRQHDLLX0
.ENDS

.SUBCKT dff_async_rst_778 data clk reset q VSS VDD_1V8
Xq_reg reset clk data q VSS VDD_1V8 DFRRQHDLLX0
.ENDS

.SUBCKT dff_async_rst_777 data clk reset q VSS VDD_1V8
Xq_reg reset clk data q VSS VDD_1V8 DFRRQHDLLX0
.ENDS

.SUBCKT dff_async_rst_776 data clk reset q VSS VDD_1V8
Xq_reg reset clk data q VSS VDD_1V8 DFRRQHDLLX0
.ENDS

.SUBCKT dff_async_rst_775 data clk reset q VSS VDD_1V8
Xq_reg reset clk data q VSS VDD_1V8 DFRRQHDLLX0
.ENDS

.SUBCKT dff_async_rst_774 data clk reset q VSS VDD_1V8
Xq_reg reset clk data q VSS VDD_1V8 DFRRQHDLLX0
.ENDS

.SUBCKT dff_async_rst_773 data clk reset q VSS VDD_1V8
Xq_reg reset clk data q VSS VDD_1V8 DFRRQHDLLX0
.ENDS

.SUBCKT dff_async_rst_772 data clk reset q VSS VDD_1V8
Xq_reg reset clk data q VSS VDD_1V8 DFRRQHDLLX0
.ENDS

.SUBCKT dff_async_rst_771 data clk reset q VSS VDD_1V8
Xq_reg reset clk data q VSS VDD_1V8 DFRRQHDLLX0
.ENDS

.SUBCKT dff_async_rst_770 data clk reset q VSS VDD_1V8
Xq_reg reset clk data q VSS VDD_1V8 DFRRQHDLLX0
.ENDS

.SUBCKT dff_async_rst_769 data clk reset q VSS VDD_1V8
Xq_reg reset clk data q VSS VDD_1V8 DFRRQHDLLX0
.ENDS

.SUBCKT dff_async_rst_768 data clk reset q VSS VDD_1V8
Xq_reg reset clk data q VSS VDD_1V8 DFRRQHDLLX0
.ENDS

.SUBCKT dff_async_rst_767 data clk reset q VSS VDD_1V8
Xq_reg reset clk data q VSS VDD_1V8 DFRRQHDLLX0
.ENDS

.SUBCKT dff_async_rst_766 data clk reset q VSS VDD_1V8
Xq_reg reset clk data q VSS VDD_1V8 DFRRQHDLLX0
.ENDS

.SUBCKT dff_async_rst_765 data clk reset q VSS VDD_1V8
Xq_reg reset clk data q VSS VDD_1V8 DFRRQHDLLX0
.ENDS

.SUBCKT dff_async_rst_764 data clk reset q VSS VDD_1V8
Xq_reg reset clk data q VSS VDD_1V8 DFRRQHDLLX0
.ENDS

.SUBCKT dff_async_rst_763 data clk reset q VSS VDD_1V8
Xq_reg reset clk data q VSS VDD_1V8 DFRRQHDLLX0
.ENDS

.SUBCKT dff_async_rst_762 data clk reset q VSS VDD_1V8
Xq_reg reset clk data q VSS VDD_1V8 DFRRQHDLLX0
.ENDS

.SUBCKT dff_async_rst_761 data clk reset q VSS VDD_1V8
Xq_reg reset clk data q VSS VDD_1V8 DFRRQHDLLX0
.ENDS

.SUBCKT dff_async_rst_760 data clk reset q VSS VDD_1V8
Xq_reg reset clk data q VSS VDD_1V8 DFRRQHDLLX0
.ENDS

.SUBCKT dff_async_rst_759 data clk reset q VSS VDD_1V8
Xq_reg reset clk data q VSS VDD_1V8 DFRRQHDLLX0
.ENDS

.SUBCKT dff_async_rst_758 data clk reset q VSS VDD_1V8
Xq_reg reset clk data q VSS VDD_1V8 DFRRQHDLLX0
.ENDS

.SUBCKT dff_async_rst_757 data clk reset q VSS VDD_1V8
Xq_reg reset clk data q VSS VDD_1V8 DFRRQHDLLX0
.ENDS

.SUBCKT dff_async_rst_756 data clk reset q VSS VDD_1V8
Xq_reg reset clk data q VSS VDD_1V8 DFRRQHDLLX0
.ENDS

.SUBCKT dff_async_rst_755 data clk reset q VSS VDD_1V8
Xq_reg reset clk data q VSS VDD_1V8 DFRRQHDLLX0
.ENDS

.SUBCKT dff_async_rst_754 data clk reset q VSS VDD_1V8
Xq_reg reset clk data q VSS VDD_1V8 DFRRQHDLLX0
.ENDS

.SUBCKT dff_async_rst_753 data clk reset q VSS VDD_1V8
Xq_reg reset clk data q VSS VDD_1V8 DFRRQHDLLX0
.ENDS

.SUBCKT dff_async_rst_752 data clk reset q VSS VDD_1V8
Xq_reg reset clk data q VSS VDD_1V8 DFRRQHDLLX0
.ENDS

.SUBCKT dff_async_rst_751 data clk reset q VSS VDD_1V8
Xq_reg reset clk data q VSS VDD_1V8 DFRRQHDLLX0
.ENDS

.SUBCKT dff_async_rst_750 data clk reset q VSS VDD_1V8
Xq_reg reset clk data q VSS VDD_1V8 DFRRQHDLLX0
.ENDS

.SUBCKT dff_async_rst_749 data clk reset q VSS VDD_1V8
Xq_reg reset clk data q VSS VDD_1V8 DFRRQHDLLX0
.ENDS

.SUBCKT dff_async_rst_748 data clk reset q VSS VDD_1V8
Xq_reg reset clk data q VSS VDD_1V8 DFRRQHDLLX0
.ENDS

.SUBCKT dff_async_rst_747 data clk reset q VSS VDD_1V8
Xq_reg reset clk data q VSS VDD_1V8 DFRRQHDLLX0
.ENDS

.SUBCKT dff_async_rst_746 data clk reset q VSS VDD_1V8
Xq_reg reset clk data q VSS VDD_1V8 DFRRQHDLLX0
.ENDS

.SUBCKT dff_async_rst_745 data clk reset q VSS VDD_1V8
Xq_reg reset clk data q VSS VDD_1V8 DFRRQHDLLX0
.ENDS

.SUBCKT dff_async_rst_744 data clk reset q VSS VDD_1V8
Xq_reg reset clk data q VSS VDD_1V8 DFRRQHDLLX0
.ENDS

.SUBCKT dff_async_rst_743 data clk reset q VSS VDD_1V8
Xq_reg reset clk data q VSS VDD_1V8 DFRRQHDLLX0
.ENDS

.SUBCKT dff_async_rst_742 data clk reset q VSS VDD_1V8
Xq_reg reset clk data q VSS VDD_1V8 DFRRQHDLLX0
.ENDS

.SUBCKT dff_async_rst_741 data clk reset q VSS VDD_1V8
Xq_reg reset clk data q VSS VDD_1V8 DFRRQHDLLX0
.ENDS

.SUBCKT dff_async_rst_740 data clk reset q VSS VDD_1V8
Xq_reg reset clk data q VSS VDD_1V8 DFRRQHDLLX0
.ENDS

.SUBCKT dff_async_rst_739 data clk reset q VSS VDD_1V8
Xq_reg reset clk data q VSS VDD_1V8 DFRRQHDLLX0
.ENDS

.SUBCKT dff_async_rst_735 data clk reset q VSS VDD_1V8
Xq_reg reset clk data q VSS VDD_1V8 DFRRQHDLLX0
.ENDS

.SUBCKT dff_async_rst_734 data clk reset q VSS VDD_1V8
Xq_reg reset clk data q VSS VDD_1V8 DFRRQHDLLX0
.ENDS

.SUBCKT dff_async_rst_733 data clk reset q VSS VDD_1V8
Xq_reg reset clk data q VSS VDD_1V8 DFRRQHDLLX0
.ENDS

.SUBCKT dff_async_rst_732 data clk reset q VSS VDD_1V8
Xq_reg reset clk data q VSS VDD_1V8 DFRRQHDLLX0
.ENDS

.SUBCKT dff_async_rst_731 data clk reset q VSS VDD_1V8
Xq_reg reset clk data q VSS VDD_1V8 DFRRQHDLLX0
.ENDS

.SUBCKT dff_async_rst_730 data clk reset q VSS VDD_1V8
Xq_reg reset clk data q VSS VDD_1V8 DFRRQHDLLX0
.ENDS

.SUBCKT dff_async_rst_729 data clk reset q VSS VDD_1V8
Xq_reg reset clk data q VSS VDD_1V8 DFRRQHDLLX0
.ENDS

.SUBCKT dff_async_rst_728 data clk reset q VSS VDD_1V8
Xq_reg reset clk data q VSS VDD_1V8 DFRRQHDLLX0
.ENDS

.SUBCKT dff_async_rst_727 data clk reset q VSS VDD_1V8
Xq_reg reset clk data q VSS VDD_1V8 DFRRQHDLLX0
.ENDS

.SUBCKT dff_async_rst_726 data clk reset q VSS VDD_1V8
Xq_reg reset clk data q VSS VDD_1V8 DFRRQHDLLX0
.ENDS

.SUBCKT dff_async_rst_725 data clk reset q VSS VDD_1V8
Xq_reg reset clk data q VSS VDD_1V8 DFRRQHDLLX0
.ENDS

.SUBCKT dff_async_rst_724 data clk reset q VSS VDD_1V8
Xq_reg reset clk data q VSS VDD_1V8 DFRRQHDLLX0
.ENDS

.SUBCKT dff_async_rst_723 data clk reset q VSS VDD_1V8
Xq_reg reset clk data q VSS VDD_1V8 DFRRQHDLLX0
.ENDS

.SUBCKT dff_async_rst_722 data clk reset q VSS VDD_1V8
Xq_reg reset clk data q VSS VDD_1V8 DFRRQHDLLX0
.ENDS

.SUBCKT dff_async_rst_721 data clk reset q VSS VDD_1V8
Xq_reg reset clk data q VSS VDD_1V8 DFRRQHDLLX0
.ENDS

.SUBCKT dff_async_rst_720 data clk reset q VSS VDD_1V8
Xq_reg reset clk data q VSS VDD_1V8 DFRRQHDLLX0
.ENDS

.SUBCKT dff_async_rst_719 data clk reset q VSS VDD_1V8
Xq_reg reset clk data q VSS VDD_1V8 DFRRQHDLLX0
.ENDS

.SUBCKT dff_async_rst_718 data clk reset q VSS VDD_1V8
Xq_reg reset clk data q VSS VDD_1V8 DFRRQHDLLX0
.ENDS

.SUBCKT dff_async_rst_717 data clk reset q VSS VDD_1V8
Xq_reg reset clk data q VSS VDD_1V8 DFRRQHDLLX0
.ENDS

.SUBCKT dff_async_rst_716 data clk reset q VSS VDD_1V8
Xq_reg reset clk data q VSS VDD_1V8 DFRRQHDLLX0
.ENDS

.SUBCKT dff_async_rst_715 data clk reset q VSS VDD_1V8
Xq_reg reset clk data q VSS VDD_1V8 DFRRQHDLLX0
.ENDS

.SUBCKT dff_async_rst_714 data clk reset q VSS VDD_1V8
Xq_reg reset clk data q VSS VDD_1V8 DFRRQHDLLX0
.ENDS

.SUBCKT dff_async_rst_713 data clk reset q VSS VDD_1V8
Xq_reg reset clk data q VSS VDD_1V8 DFRRQHDLLX0
.ENDS

.SUBCKT dff_async_rst_712 data clk reset q VSS VDD_1V8
Xq_reg reset clk data q VSS VDD_1V8 DFRRQHDLLX0
.ENDS

.SUBCKT dff_async_rst_711 data clk reset q VSS VDD_1V8
Xq_reg reset clk data q VSS VDD_1V8 DFRRQHDLLX0
.ENDS

.SUBCKT dff_async_rst_710 data clk reset q VSS VDD_1V8
Xq_reg reset clk data q VSS VDD_1V8 DFRRQHDLLX0
.ENDS

.SUBCKT dff_async_rst_709 data clk reset q VSS VDD_1V8
Xq_reg reset clk data q VSS VDD_1V8 DFRRQHDLLX0
.ENDS

.SUBCKT dff_async_rst_708 data clk reset q VSS VDD_1V8
Xq_reg reset clk data q VSS VDD_1V8 DFRRQHDLLX0
.ENDS

.SUBCKT dff_async_rst_707 data clk reset q VSS VDD_1V8
Xq_reg reset clk data q VSS VDD_1V8 DFRRQHDLLX0
.ENDS

.SUBCKT dff_async_rst_706 data clk reset q VSS VDD_1V8
Xq_reg reset clk data q VSS VDD_1V8 DFRRQHDLLX0
.ENDS

.SUBCKT dff_async_rst_705 data clk reset q VSS VDD_1V8
Xq_reg reset clk data q VSS VDD_1V8 DFRRQHDLLX0
.ENDS

.SUBCKT dff_async_rst_704 data clk reset q VSS VDD_1V8
Xq_reg reset clk data q VSS VDD_1V8 DFRRQHDLLX0
.ENDS

.SUBCKT dff_async_rst_703 data clk reset q VSS VDD_1V8
Xq_reg reset clk data q VSS VDD_1V8 DFRRQHDLLX0
.ENDS

.SUBCKT dff_async_rst_702 data clk reset q VSS VDD_1V8
Xq_reg reset clk data q VSS VDD_1V8 DFRRQHDLLX0
.ENDS

.SUBCKT dff_async_rst_701 data clk reset q VSS VDD_1V8
Xq_reg reset clk data q VSS VDD_1V8 DFRRQHDLLX0
.ENDS

.SUBCKT dff_async_rst_700 data clk reset q VSS VDD_1V8
Xq_reg reset clk data q VSS VDD_1V8 DFRRQHDLLX0
.ENDS

.SUBCKT dff_async_rst_699 data clk reset q VSS VDD_1V8
Xq_reg reset clk data q VSS VDD_1V8 DFRRQHDLLX0
.ENDS

.SUBCKT dff_async_rst_698 data clk reset q VSS VDD_1V8
Xq_reg reset clk data q VSS VDD_1V8 DFRRQHDLLX0
.ENDS

.SUBCKT dff_async_rst_697 data clk reset q VSS VDD_1V8
Xq_reg reset clk data q VSS VDD_1V8 DFRRQHDLLX0
.ENDS

.SUBCKT dff_async_rst_696 data clk reset q VSS VDD_1V8
Xq_reg reset clk data q VSS VDD_1V8 DFRRQHDLLX0
.ENDS

.SUBCKT dff_async_rst_695 data clk reset q VSS VDD_1V8
Xq_reg reset clk data q VSS VDD_1V8 DFRRQHDLLX0
.ENDS

.SUBCKT dff_async_rst_694 data clk reset q VSS VDD_1V8
Xq_reg reset clk data q VSS VDD_1V8 DFRRQHDLLX0
.ENDS

.SUBCKT dff_async_rst_693 data clk reset q VSS VDD_1V8
Xq_reg reset clk data q VSS VDD_1V8 DFRRQHDLLX0
.ENDS

.SUBCKT dff_async_rst_692 data clk reset q VSS VDD_1V8
Xq_reg reset clk data q VSS VDD_1V8 DFRRQHDLLX0
.ENDS

.SUBCKT dff_async_rst_691 data clk reset q VSS VDD_1V8
Xq_reg reset clk data q VSS VDD_1V8 DFRRQHDLLX0
.ENDS

.SUBCKT dff_async_rst_690 data clk reset q VSS VDD_1V8
Xq_reg reset clk data q VSS VDD_1V8 DFRRQHDLLX0
.ENDS

.SUBCKT dff_async_rst_689 data clk reset q VSS VDD_1V8
Xq_reg reset clk data q VSS VDD_1V8 DFRRQHDLLX0
.ENDS

.SUBCKT dff_async_rst_688 data clk reset q VSS VDD_1V8
Xq_reg reset clk data q VSS VDD_1V8 DFRRQHDLLX0
.ENDS

.SUBCKT dff_async_rst_687 data clk reset q VSS VDD_1V8
Xq_reg reset clk data q VSS VDD_1V8 DFRRQHDLLX0
.ENDS

.SUBCKT dff_async_rst_686 data clk reset q VSS VDD_1V8
Xq_reg reset clk data q VSS VDD_1V8 DFRRQHDLLX0
.ENDS

.SUBCKT dff_async_rst_685 data clk reset q VSS VDD_1V8
Xq_reg reset clk data q VSS VDD_1V8 DFRRQHDLLX0
.ENDS

.SUBCKT dff_async_rst_684 data clk reset q VSS VDD_1V8
Xq_reg reset clk data q VSS VDD_1V8 DFRRQHDLLX0
.ENDS

.SUBCKT dff_async_rst_683 data clk reset q VSS VDD_1V8
Xq_reg reset clk data q VSS VDD_1V8 DFRRQHDLLX0
.ENDS

.SUBCKT dff_async_rst_682 data clk reset q VSS VDD_1V8
Xq_reg reset clk data q VSS VDD_1V8 DFRRQHDLLX0
.ENDS

.SUBCKT dff_async_rst_681 data clk reset q VSS VDD_1V8
Xq_reg reset clk data q VSS VDD_1V8 DFRRQHDLLX0
.ENDS

.SUBCKT dff_async_rst_680 data clk reset q VSS VDD_1V8
Xq_reg reset clk data q VSS VDD_1V8 DFRRQHDLLX0
.ENDS

.SUBCKT dff_async_rst_679 data clk reset q VSS VDD_1V8
Xq_reg reset clk data q VSS VDD_1V8 DFRRQHDLLX0
.ENDS

.SUBCKT dff_async_rst_678 data clk reset q VSS VDD_1V8
Xq_reg reset clk data q VSS VDD_1V8 DFRRQHDLLX0
.ENDS

.SUBCKT dff_async_rst_677 data clk reset q VSS VDD_1V8
Xq_reg reset clk data q VSS VDD_1V8 DFRRQHDLLX0
.ENDS

.SUBCKT dff_async_rst_676 data clk reset q VSS VDD_1V8
Xq_reg reset clk data q VSS VDD_1V8 DFRRQHDLLX0
.ENDS

.SUBCKT dff_async_rst_673 data clk reset q VSS VDD_1V8
Xq_reg reset clk data q VSS VDD_1V8 DFRRQHDLLX0
.ENDS

.SUBCKT dff_async_rst_672 data clk reset q VSS VDD_1V8
Xq_reg reset clk data q VSS VDD_1V8 DFRRQHDLLX0
.ENDS

.SUBCKT dff_async_rst_670 data clk reset q VSS VDD_1V8
Xq_reg reset clk data q VSS VDD_1V8 DFRRQHDLLX0
.ENDS

.SUBCKT dff_async_rst_669 data clk reset q VSS VDD_1V8
Xq_reg reset clk data q VSS VDD_1V8 DFRRQHDLLX0
.ENDS

.SUBCKT dff_async_rst_668 data clk reset q VSS VDD_1V8
Xq_reg reset clk data q VSS VDD_1V8 DFRRQHDLLX0
.ENDS

.SUBCKT dff_async_rst_667 data clk reset q VSS VDD_1V8
Xq_reg reset clk data q VSS VDD_1V8 DFRRQHDLLX0
.ENDS

.SUBCKT dff_async_rst_666 data clk reset q VSS VDD_1V8
Xq_reg reset clk data q VSS VDD_1V8 DFRRQHDLLX0
.ENDS

.SUBCKT dff_async_rst_665 data clk reset q VSS VDD_1V8
Xq_reg reset clk data q VSS VDD_1V8 DFRRQHDLLX0
.ENDS

.SUBCKT dff_async_rst_664 data clk reset q VSS VDD_1V8
Xq_reg reset clk data q VSS VDD_1V8 DFRRQHDLLX0
.ENDS

.SUBCKT dff_async_rst_663 data clk reset q VSS VDD_1V8
Xq_reg reset clk data q VSS VDD_1V8 DFRRQHDLLX0
.ENDS

.SUBCKT dff_async_rst_662 data clk reset q VSS VDD_1V8
Xq_reg reset clk data q VSS VDD_1V8 DFRRQHDLLX0
.ENDS

.SUBCKT dff_async_rst_661 data clk reset q VSS VDD_1V8
Xq_reg reset clk data q VSS VDD_1V8 DFRRQHDLLX0
.ENDS

.SUBCKT dff_async_rst_660 data clk reset q VSS VDD_1V8
Xq_reg reset clk data q VSS VDD_1V8 DFRRQHDLLX0
.ENDS

.SUBCKT dff_async_rst_659 data clk reset q VSS VDD_1V8
Xq_reg reset clk data q VSS VDD_1V8 DFRRQHDLLX0
.ENDS

.SUBCKT dff_async_rst_658 data clk reset q VSS VDD_1V8
Xq_reg reset clk data q VSS VDD_1V8 DFRRQHDLLX0
.ENDS

.SUBCKT dff_async_rst_657 data clk reset q VSS VDD_1V8
Xq_reg reset clk data q VSS VDD_1V8 DFRRQHDLLX0
.ENDS

.SUBCKT dff_async_rst_656 data clk reset q VSS VDD_1V8
Xq_reg reset clk data q VSS VDD_1V8 DFRRQHDLLX0
.ENDS

.SUBCKT dff_async_rst_655 data clk reset q VSS VDD_1V8
Xq_reg reset clk data q VSS VDD_1V8 DFRRQHDLLX0
.ENDS

.SUBCKT dff_async_rst_654 data clk reset q VSS VDD_1V8
Xq_reg reset clk data q VSS VDD_1V8 DFRRQHDLLX0
.ENDS

.SUBCKT dff_async_rst_653 data clk reset q VSS VDD_1V8
Xq_reg reset clk data q VSS VDD_1V8 DFRRQHDLLX0
.ENDS

.SUBCKT dff_async_rst_652 data clk reset q VSS VDD_1V8
Xq_reg reset clk data q VSS VDD_1V8 DFRRQHDLLX0
.ENDS

.SUBCKT dff_async_rst_651 data clk reset q VSS VDD_1V8
Xq_reg reset clk data q VSS VDD_1V8 DFRRQHDLLX0
.ENDS

.SUBCKT dff_async_rst_650 data clk reset q VSS VDD_1V8
Xq_reg reset clk data q VSS VDD_1V8 DFRRQHDLLX0
.ENDS

.SUBCKT dff_async_rst_649 data clk reset q VSS VDD_1V8
Xq_reg reset clk data q VSS VDD_1V8 DFRRQHDLLX0
.ENDS

.SUBCKT dff_async_rst_648 data clk reset q VSS VDD_1V8
Xq_reg reset clk data q VSS VDD_1V8 DFRRQHDLLX0
.ENDS

.SUBCKT dff_async_rst_647 data clk reset q VSS VDD_1V8
Xq_reg reset clk data q VSS VDD_1V8 DFRRQHDLLX0
.ENDS

.SUBCKT dff_async_rst_646 data clk reset q VSS VDD_1V8
Xq_reg reset clk data q VSS VDD_1V8 DFRRQHDLLX0
.ENDS

.SUBCKT dff_async_rst_645 data clk reset q VSS VDD_1V8
Xq_reg reset clk data q VSS VDD_1V8 DFRRQHDLLX0
.ENDS

.SUBCKT dff_async_rst_644 data clk reset q VSS VDD_1V8
Xq_reg reset clk data q VSS VDD_1V8 DFRRQHDLLX0
.ENDS

.SUBCKT dff_async_rst_643 data clk reset q VSS VDD_1V8
Xq_reg reset clk data q VSS VDD_1V8 DFRRQHDLLX0
.ENDS

.SUBCKT dff_async_rst_642 data clk reset q VSS VDD_1V8
Xq_reg reset clk data q VSS VDD_1V8 DFRRQHDLLX0
.ENDS

.SUBCKT dff_async_rst_641 data clk reset q VSS VDD_1V8
Xq_reg reset clk data q VSS VDD_1V8 DFRRQHDLLX0
.ENDS

.SUBCKT dff_async_rst_640 data clk reset q VSS VDD_1V8
Xq_reg reset clk data q VSS VDD_1V8 DFRRQHDLLX0
.ENDS

.SUBCKT dff_async_rst_639 data clk reset q VSS VDD_1V8
Xq_reg reset clk data q VSS VDD_1V8 DFRRQHDLLX0
.ENDS

.SUBCKT dff_async_rst_638 data clk reset q VSS VDD_1V8
Xq_reg reset clk data q VSS VDD_1V8 DFRRQHDLLX0
.ENDS

.SUBCKT dff_async_rst_637 data clk reset q VSS VDD_1V8
Xq_reg reset clk data q VSS VDD_1V8 DFRRQHDLLX0
.ENDS

.SUBCKT dff_async_rst_636 data clk reset q VSS VDD_1V8
Xq_reg reset clk data q VSS VDD_1V8 DFRRQHDLLX0
.ENDS

.SUBCKT dff_async_rst_635 data clk reset q VSS VDD_1V8
Xq_reg reset clk data q VSS VDD_1V8 DFRRQHDLLX0
.ENDS

.SUBCKT dff_async_rst_634 data clk reset q VSS VDD_1V8
Xq_reg reset clk data q VSS VDD_1V8 DFRRQHDLLX0
.ENDS

.SUBCKT dff_async_rst_633 data clk reset q VSS VDD_1V8
Xq_reg reset clk data q VSS VDD_1V8 DFRRQHDLLX0
.ENDS

.SUBCKT dff_async_rst_632 data clk reset q VSS VDD_1V8
Xq_reg reset clk data q VSS VDD_1V8 DFRRQHDLLX0
.ENDS

.SUBCKT dff_async_rst_631 data clk reset q VSS VDD_1V8
Xq_reg reset clk data q VSS VDD_1V8 DFRRQHDLLX0
.ENDS

.SUBCKT dff_async_rst_630 data clk reset q VSS VDD_1V8
Xq_reg reset clk data q VSS VDD_1V8 DFRRQHDLLX0
.ENDS

.SUBCKT dff_async_rst_629 data clk reset q VSS VDD_1V8
Xq_reg reset clk data q VSS VDD_1V8 DFRRQHDLLX0
.ENDS

.SUBCKT dff_async_rst_628 data clk reset q VSS VDD_1V8
Xq_reg reset clk data q VSS VDD_1V8 DFRRQHDLLX0
.ENDS

.SUBCKT dff_async_rst_627 data clk reset q VSS VDD_1V8
Xq_reg reset clk data q VSS VDD_1V8 DFRRQHDLLX0
.ENDS

.SUBCKT dff_async_rst_626 data clk reset q VSS VDD_1V8
Xq_reg reset clk data q VSS VDD_1V8 DFRRQHDLLX0
.ENDS

.SUBCKT dff_async_rst_625 data clk reset q VSS VDD_1V8
Xq_reg reset clk data q VSS VDD_1V8 DFRRQHDLLX0
.ENDS

.SUBCKT dff_async_rst_624 data clk reset q VSS VDD_1V8
Xq_reg reset clk data q VSS VDD_1V8 DFRRQHDLLX0
.ENDS

.SUBCKT dff_async_rst_623 data clk reset q VSS VDD_1V8
Xq_reg reset clk data q VSS VDD_1V8 DFRRQHDLLX0
.ENDS

.SUBCKT dff_async_rst_622 data clk reset q VSS VDD_1V8
Xq_reg reset clk data q VSS VDD_1V8 DFRRQHDLLX0
.ENDS

.SUBCKT dff_async_rst_621 data clk reset q VSS VDD_1V8
Xq_reg reset clk data q VSS VDD_1V8 DFRRQHDLLX0
.ENDS

.SUBCKT dff_async_rst_620 data clk reset q VSS VDD_1V8
Xq_reg reset clk data q VSS VDD_1V8 DFRRQHDLLX0
.ENDS

.SUBCKT dff_async_rst_619 data clk reset q VSS VDD_1V8
Xq_reg reset clk data q VSS VDD_1V8 DFRRQHDLLX0
.ENDS

.SUBCKT dff_async_rst_618 data clk reset q VSS VDD_1V8
Xq_reg reset clk data q VSS VDD_1V8 DFRRQHDLLX0
.ENDS

.SUBCKT dff_async_rst_617 data clk reset q VSS VDD_1V8
Xq_reg reset clk data q VSS VDD_1V8 DFRRQHDLLX0
.ENDS

.SUBCKT dff_async_rst_616 data clk reset q VSS VDD_1V8
Xq_reg reset clk data q VSS VDD_1V8 DFRRQHDLLX0
.ENDS

.SUBCKT dff_async_rst_615 data clk reset q VSS VDD_1V8
Xq_reg reset clk data q VSS VDD_1V8 DFRRQHDLLX0
.ENDS

.SUBCKT dff_async_rst_614 data clk reset q VSS VDD_1V8
Xq_reg reset clk data q VSS VDD_1V8 DFRRQHDLLX0
.ENDS

.SUBCKT dff_async_rst_613 data clk reset q VSS VDD_1V8
Xq_reg reset clk data q VSS VDD_1V8 DFRRQHDLLX0
.ENDS

.SUBCKT dff_async_rst_612 data clk reset q VSS VDD_1V8
Xq_reg reset clk data q VSS VDD_1V8 DFRRQHDLLX0
.ENDS

.SUBCKT dff_async_rst_611 data clk reset q VSS VDD_1V8
Xq_reg reset clk data q VSS VDD_1V8 DFRRQHDLLX0
.ENDS

.SUBCKT dff_async_rst_608 data clk reset q VSS VDD_1V8
Xq_reg reset clk data q VSS VDD_1V8 DFRRQHDLLX0
.ENDS

.SUBCKT dff_async_rst_607 data clk reset q VSS VDD_1V8
Xq_reg reset clk data q VSS VDD_1V8 DFRRQHDLLX0
.ENDS

.SUBCKT dff_async_rst_605 data clk reset q VSS VDD_1V8
Xq_reg reset clk data q VSS VDD_1V8 DFRRQHDLLX0
.ENDS

.SUBCKT dff_async_rst_604 data clk reset q VSS VDD_1V8
Xq_reg reset clk data q VSS VDD_1V8 DFRRQHDLLX0
.ENDS

.SUBCKT dff_async_rst_603 data clk reset q VSS VDD_1V8
Xq_reg reset clk data q VSS VDD_1V8 DFRRQHDLLX0
.ENDS

.SUBCKT dff_async_rst_602 data clk reset q VSS VDD_1V8
Xq_reg reset clk data q VSS VDD_1V8 DFRRQHDLLX0
.ENDS

.SUBCKT dff_async_rst_601 data clk reset q VSS VDD_1V8
Xq_reg reset clk data q VSS VDD_1V8 DFRRQHDLLX0
.ENDS

.SUBCKT dff_async_rst_600 data clk reset q VSS VDD_1V8
Xq_reg reset clk data q VSS VDD_1V8 DFRRQHDLLX0
.ENDS

.SUBCKT dff_async_rst_599 data clk reset q VSS VDD_1V8
Xq_reg reset clk data q VSS VDD_1V8 DFRRQHDLLX0
.ENDS

.SUBCKT dff_async_rst_598 data clk reset q VSS VDD_1V8
Xq_reg reset clk data q VSS VDD_1V8 DFRRQHDLLX0
.ENDS

.SUBCKT dff_async_rst_597 data clk reset q VSS VDD_1V8
Xq_reg reset clk data q VSS VDD_1V8 DFRRQHDLLX0
.ENDS

.SUBCKT dff_async_rst_596 data clk reset q VSS VDD_1V8
Xq_reg reset clk data q VSS VDD_1V8 DFRRQHDLLX0
.ENDS

.SUBCKT dff_async_rst_595 data clk reset q VSS VDD_1V8
Xq_reg reset clk data q VSS VDD_1V8 DFRRQHDLLX0
.ENDS

.SUBCKT dff_async_rst_594 data clk reset q VSS VDD_1V8
Xq_reg reset clk data q VSS VDD_1V8 DFRRQHDLLX0
.ENDS

.SUBCKT dff_async_rst_593 data clk reset q VSS VDD_1V8
Xq_reg reset clk data q VSS VDD_1V8 DFRRQHDLLX0
.ENDS

.SUBCKT dff_async_rst_592 data clk reset q VSS VDD_1V8
Xq_reg reset clk data q VSS VDD_1V8 DFRRQHDLLX0
.ENDS

.SUBCKT dff_async_rst_591 data clk reset q VSS VDD_1V8
Xq_reg reset clk data q VSS VDD_1V8 DFRRQHDLLX0
.ENDS

.SUBCKT dff_async_rst_590 data clk reset q VSS VDD_1V8
Xq_reg reset clk data q VSS VDD_1V8 DFRRQHDLLX0
.ENDS

.SUBCKT dff_async_rst_589 data clk reset q VSS VDD_1V8
Xq_reg reset clk data q VSS VDD_1V8 DFRRQHDLLX0
.ENDS

.SUBCKT dff_async_rst_588 data clk reset q VSS VDD_1V8
Xq_reg reset clk data q VSS VDD_1V8 DFRRQHDLLX0
.ENDS

.SUBCKT dff_async_rst_587 data clk reset q VSS VDD_1V8
Xq_reg reset clk data q VSS VDD_1V8 DFRRQHDLLX0
.ENDS

.SUBCKT dff_async_rst_586 data clk reset q VSS VDD_1V8
Xq_reg reset clk data q VSS VDD_1V8 DFRRQHDLLX0
.ENDS

.SUBCKT dff_async_rst_585 data clk reset q VSS VDD_1V8
Xq_reg reset clk data q VSS VDD_1V8 DFRRQHDLLX0
.ENDS

.SUBCKT dff_async_rst_584 data clk reset q VSS VDD_1V8
Xq_reg reset clk data q VSS VDD_1V8 DFRRQHDLLX0
.ENDS

.SUBCKT dff_async_rst_583 data clk reset q VSS VDD_1V8
Xq_reg reset clk data q VSS VDD_1V8 DFRRQHDLLX0
.ENDS

.SUBCKT dff_async_rst_582 data clk reset q VSS VDD_1V8
Xq_reg reset clk data q VSS VDD_1V8 DFRRQHDLLX0
.ENDS

.SUBCKT dff_async_rst_581 data clk reset q VSS VDD_1V8
Xq_reg reset clk data q VSS VDD_1V8 DFRRQHDLLX0
.ENDS

.SUBCKT dff_async_rst_580 data clk reset q VSS VDD_1V8
Xq_reg reset clk data q VSS VDD_1V8 DFRRQHDLLX0
.ENDS

.SUBCKT dff_async_rst_579 data clk reset q VSS VDD_1V8
Xq_reg reset clk data q VSS VDD_1V8 DFRRQHDLLX0
.ENDS

.SUBCKT dff_async_rst_578 data clk reset q VSS VDD_1V8
Xq_reg reset clk data q VSS VDD_1V8 DFRRQHDLLX0
.ENDS

.SUBCKT dff_async_rst_577 data clk reset q VSS VDD_1V8
Xq_reg reset clk data q VSS VDD_1V8 DFRRQHDLLX0
.ENDS

.SUBCKT dff_async_rst_576 data clk reset q VSS VDD_1V8
Xq_reg reset clk data q VSS VDD_1V8 DFRRQHDLLX0
.ENDS

.SUBCKT dff_async_rst_575 data clk reset q VSS VDD_1V8
Xq_reg reset clk data q VSS VDD_1V8 DFRRQHDLLX0
.ENDS

.SUBCKT dff_async_rst_574 data clk reset q VSS VDD_1V8
Xq_reg reset clk data q VSS VDD_1V8 DFRRQHDLLX0
.ENDS

.SUBCKT dff_async_rst_573 data clk reset q VSS VDD_1V8
Xq_reg reset clk data q VSS VDD_1V8 DFRRQHDLLX0
.ENDS

.SUBCKT dff_async_rst_572 data clk reset q VSS VDD_1V8
Xq_reg reset clk data q VSS VDD_1V8 DFRRQHDLLX0
.ENDS

.SUBCKT dff_async_rst_571 data clk reset q VSS VDD_1V8
Xq_reg reset clk data q VSS VDD_1V8 DFRRQHDLLX0
.ENDS

.SUBCKT dff_async_rst_570 data clk reset q VSS VDD_1V8
Xq_reg reset clk data q VSS VDD_1V8 DFRRQHDLLX0
.ENDS

.SUBCKT dff_async_rst_569 data clk reset q VSS VDD_1V8
Xq_reg reset clk data q VSS VDD_1V8 DFRRQHDLLX0
.ENDS

.SUBCKT dff_async_rst_568 data clk reset q VSS VDD_1V8
Xq_reg reset clk data q VSS VDD_1V8 DFRRQHDLLX0
.ENDS

.SUBCKT dff_async_rst_567 data clk reset q VSS VDD_1V8
Xq_reg reset clk data q VSS VDD_1V8 DFRRQHDLLX0
.ENDS

.SUBCKT dff_async_rst_566 data clk reset q VSS VDD_1V8
Xq_reg reset clk data q VSS VDD_1V8 DFRRQHDLLX0
.ENDS

.SUBCKT dff_async_rst_565 data clk reset q VSS VDD_1V8
Xq_reg reset clk data q VSS VDD_1V8 DFRRQHDLLX0
.ENDS

.SUBCKT dff_async_rst_564 data clk reset q VSS VDD_1V8
Xq_reg reset clk data q VSS VDD_1V8 DFRRQHDLLX0
.ENDS

.SUBCKT dff_async_rst_563 data clk reset q VSS VDD_1V8
Xq_reg reset clk data q VSS VDD_1V8 DFRRQHDLLX0
.ENDS

.SUBCKT dff_async_rst_562 data clk reset q VSS VDD_1V8
Xq_reg reset clk data q VSS VDD_1V8 DFRRQHDLLX0
.ENDS

.SUBCKT dff_async_rst_561 data clk reset q VSS VDD_1V8
Xq_reg reset clk data q VSS VDD_1V8 DFRRQHDLLX0
.ENDS

.SUBCKT dff_async_rst_560 data clk reset q VSS VDD_1V8
Xq_reg reset clk data q VSS VDD_1V8 DFRRQHDLLX0
.ENDS

.SUBCKT dff_async_rst_559 data clk reset q VSS VDD_1V8
Xq_reg reset clk data q VSS VDD_1V8 DFRRQHDLLX0
.ENDS

.SUBCKT dff_async_rst_558 data clk reset q VSS VDD_1V8
Xq_reg reset clk data q VSS VDD_1V8 DFRRQHDLLX0
.ENDS

.SUBCKT dff_async_rst_557 data clk reset q VSS VDD_1V8
Xq_reg reset clk data q VSS VDD_1V8 DFRRQHDLLX0
.ENDS

.SUBCKT dff_async_rst_556 data clk reset q VSS VDD_1V8
Xq_reg reset clk data q VSS VDD_1V8 DFRRQHDLLX0
.ENDS

.SUBCKT dff_async_rst_555 data clk reset q VSS VDD_1V8
Xq_reg reset clk data q VSS VDD_1V8 DFRRQHDLLX0
.ENDS

.SUBCKT dff_async_rst_554 data clk reset q VSS VDD_1V8
Xq_reg reset clk data q VSS VDD_1V8 DFRRQHDLLX0
.ENDS

.SUBCKT dff_async_rst_553 data clk reset q VSS VDD_1V8
Xq_reg reset clk data q VSS VDD_1V8 DFRRQHDLLX0
.ENDS

.SUBCKT dff_async_rst_552 data clk reset q VSS VDD_1V8
Xq_reg reset clk data q VSS VDD_1V8 DFRRQHDLLX0
.ENDS

.SUBCKT dff_async_rst_551 data clk reset q VSS VDD_1V8
Xq_reg reset clk data q VSS VDD_1V8 DFRRQHDLLX0
.ENDS

.SUBCKT dff_async_rst_550 data clk reset q VSS VDD_1V8
Xq_reg reset clk data q VSS VDD_1V8 DFRRQHDLLX0
.ENDS

.SUBCKT dff_async_rst_549 data clk reset q VSS VDD_1V8
Xq_reg reset clk data q VSS VDD_1V8 DFRRQHDLLX0
.ENDS

.SUBCKT dff_async_rst_548 data clk reset q VSS VDD_1V8
Xq_reg reset clk data q VSS VDD_1V8 DFRRQHDLLX0
.ENDS

.SUBCKT dff_async_rst_547 data clk reset q VSS VDD_1V8
Xq_reg reset clk data q VSS VDD_1V8 DFRRQHDLLX0
.ENDS

.SUBCKT dff_async_rst_546 data clk reset q VSS VDD_1V8
Xq_reg reset clk data q VSS VDD_1V8 DFRRQHDLLX0
.ENDS

.SUBCKT dff_async_rst_543 data clk reset q VSS VDD_1V8
Xq_reg reset clk data q VSS VDD_1V8 DFRRQHDLLX0
.ENDS

.SUBCKT dff_async_rst_542 data clk reset q VSS VDD_1V8
Xq_reg reset clk data q VSS VDD_1V8 DFRRQHDLLX0
.ENDS

.SUBCKT dff_async_rst_540 data clk reset q VSS VDD_1V8
Xq_reg reset clk data q VSS VDD_1V8 DFRRQHDLLX0
.ENDS

.SUBCKT dff_async_rst_539 data clk reset q VSS VDD_1V8
Xq_reg reset clk data q VSS VDD_1V8 DFRRQHDLLX0
.ENDS

.SUBCKT dff_async_rst_538 data clk reset q VSS VDD_1V8
Xq_reg reset clk data q VSS VDD_1V8 DFRRQHDLLX0
.ENDS

.SUBCKT dff_async_rst_537 data clk reset q VSS VDD_1V8
Xq_reg reset clk data q VSS VDD_1V8 DFRRQHDLLX0
.ENDS

.SUBCKT dff_async_rst_536 data clk reset q VSS VDD_1V8
Xq_reg reset clk data q VSS VDD_1V8 DFRRQHDLLX0
.ENDS

.SUBCKT dff_async_rst_535 data clk reset q VSS VDD_1V8
Xq_reg reset clk data q VSS VDD_1V8 DFRRQHDLLX0
.ENDS

.SUBCKT dff_async_rst_534 data clk reset q VSS VDD_1V8
Xq_reg reset clk data q VSS VDD_1V8 DFRRQHDLLX0
.ENDS

.SUBCKT dff_async_rst_533 data clk reset q VSS VDD_1V8
Xq_reg reset clk data q VSS VDD_1V8 DFRRQHDLLX0
.ENDS

.SUBCKT dff_async_rst_532 data clk reset q VSS VDD_1V8
Xq_reg reset clk data q VSS VDD_1V8 DFRRQHDLLX0
.ENDS

.SUBCKT dff_async_rst_531 data clk reset q VSS VDD_1V8
Xq_reg reset clk data q VSS VDD_1V8 DFRRQHDLLX0
.ENDS

.SUBCKT dff_async_rst_530 data clk reset q VSS VDD_1V8
Xq_reg reset clk data q VSS VDD_1V8 DFRRQHDLLX0
.ENDS

.SUBCKT dff_async_rst_529 data clk reset q VSS VDD_1V8
Xq_reg reset clk data q VSS VDD_1V8 DFRRQHDLLX0
.ENDS

.SUBCKT dff_async_rst_528 data clk reset q VSS VDD_1V8
Xq_reg reset clk data q VSS VDD_1V8 DFRRQHDLLX0
.ENDS

.SUBCKT dff_async_rst_527 data clk reset q VSS VDD_1V8
Xq_reg reset clk data q VSS VDD_1V8 DFRRQHDLLX0
.ENDS

.SUBCKT dff_async_rst_526 data clk reset q VSS VDD_1V8
Xq_reg reset clk data q VSS VDD_1V8 DFRRQHDLLX0
.ENDS

.SUBCKT dff_async_rst_525 data clk reset q VSS VDD_1V8
Xq_reg reset clk data q VSS VDD_1V8 DFRRQHDLLX0
.ENDS

.SUBCKT dff_async_rst_524 data clk reset q VSS VDD_1V8
Xq_reg reset clk data q VSS VDD_1V8 DFRRQHDLLX0
.ENDS

.SUBCKT dff_async_rst_523 data clk reset q VSS VDD_1V8
Xq_reg reset clk data q VSS VDD_1V8 DFRRQHDLLX0
.ENDS

.SUBCKT dff_async_rst_522 data clk reset q VSS VDD_1V8
Xq_reg reset clk data q VSS VDD_1V8 DFRRQHDLLX0
.ENDS

.SUBCKT dff_async_rst_521 data clk reset q VSS VDD_1V8
Xq_reg reset clk data q VSS VDD_1V8 DFRRQHDLLX0
.ENDS

.SUBCKT dff_async_rst_520 data clk reset q VSS VDD_1V8
Xq_reg reset clk data q VSS VDD_1V8 DFRRQHDLLX0
.ENDS

.SUBCKT dff_async_rst_519 data clk reset q VSS VDD_1V8
Xq_reg reset clk data q VSS VDD_1V8 DFRRQHDLLX0
.ENDS

.SUBCKT dff_async_rst_518 data clk reset q VSS VDD_1V8
Xq_reg reset clk data q VSS VDD_1V8 DFRRQHDLLX0
.ENDS

.SUBCKT dff_async_rst_517 data clk reset q VSS VDD_1V8
Xq_reg reset clk data q VSS VDD_1V8 DFRRQHDLLX0
.ENDS

.SUBCKT dff_async_rst_516 data clk reset q VSS VDD_1V8
Xq_reg reset clk data q VSS VDD_1V8 DFRRQHDLLX0
.ENDS

.SUBCKT dff_async_rst_515 data clk reset q VSS VDD_1V8
Xq_reg reset clk data q VSS VDD_1V8 DFRRQHDLLX0
.ENDS

.SUBCKT dff_async_rst_514 data clk reset q VSS VDD_1V8
Xq_reg reset clk data q VSS VDD_1V8 DFRRQHDLLX0
.ENDS

.SUBCKT dff_async_rst_513 data clk reset q VSS VDD_1V8
Xq_reg reset clk data q VSS VDD_1V8 DFRRQHDLLX0
.ENDS

.SUBCKT dff_async_rst_512 data clk reset q VSS VDD_1V8
Xq_reg reset clk data q VSS VDD_1V8 DFRRQHDLLX0
.ENDS

.SUBCKT dff_async_rst_511 data clk reset q VSS VDD_1V8
Xq_reg reset clk data q VSS VDD_1V8 DFRRQHDLLX0
.ENDS

.SUBCKT dff_async_rst_510 data clk reset q VSS VDD_1V8
Xq_reg reset clk data q VSS VDD_1V8 DFRRQHDLLX0
.ENDS

.SUBCKT dff_async_rst_509 data clk reset q VSS VDD_1V8
Xq_reg reset clk data q VSS VDD_1V8 DFRRQHDLLX0
.ENDS

.SUBCKT dff_async_rst_508 data clk reset q VSS VDD_1V8
Xq_reg reset clk data q VSS VDD_1V8 DFRRQHDLLX0
.ENDS

.SUBCKT dff_async_rst_507 data clk reset q VSS VDD_1V8
Xq_reg reset clk data q VSS VDD_1V8 DFRRQHDLLX0
.ENDS

.SUBCKT dff_async_rst_506 data clk reset q VSS VDD_1V8
Xq_reg reset clk data q VSS VDD_1V8 DFRRQHDLLX0
.ENDS

.SUBCKT dff_async_rst_505 data clk reset q VSS VDD_1V8
Xq_reg reset clk data q VSS VDD_1V8 DFRRQHDLLX0
.ENDS

.SUBCKT dff_async_rst_504 data clk reset q VSS VDD_1V8
Xq_reg reset clk data q VSS VDD_1V8 DFRRQHDLLX0
.ENDS

.SUBCKT dff_async_rst_503 data clk reset q VSS VDD_1V8
Xq_reg reset clk data q VSS VDD_1V8 DFRRQHDLLX0
.ENDS

.SUBCKT dff_async_rst_502 data clk reset q VSS VDD_1V8
Xq_reg reset clk data q VSS VDD_1V8 DFRRQHDLLX0
.ENDS

.SUBCKT dff_async_rst_501 data clk reset q VSS VDD_1V8
Xq_reg reset clk data q VSS VDD_1V8 DFRRQHDLLX0
.ENDS

.SUBCKT dff_async_rst_500 data clk reset q VSS VDD_1V8
Xq_reg reset clk data q VSS VDD_1V8 DFRRQHDLLX0
.ENDS

.SUBCKT dff_async_rst_499 data clk reset q VSS VDD_1V8
Xq_reg reset clk data q VSS VDD_1V8 DFRRQHDLLX0
.ENDS

.SUBCKT dff_async_rst_498 data clk reset q VSS VDD_1V8
Xq_reg reset clk data q VSS VDD_1V8 DFRRQHDLLX0
.ENDS

.SUBCKT dff_async_rst_497 data clk reset q VSS VDD_1V8
Xq_reg reset clk data q VSS VDD_1V8 DFRRQHDLLX0
.ENDS

.SUBCKT dff_async_rst_496 data clk reset q VSS VDD_1V8
Xq_reg reset clk data q VSS VDD_1V8 DFRRQHDLLX0
.ENDS

.SUBCKT dff_async_rst_495 data clk reset q VSS VDD_1V8
Xq_reg reset clk data q VSS VDD_1V8 DFRRQHDLLX0
.ENDS

.SUBCKT dff_async_rst_494 data clk reset q VSS VDD_1V8
Xq_reg reset clk data q VSS VDD_1V8 DFRRQHDLLX0
.ENDS

.SUBCKT dff_async_rst_493 data clk reset q VSS VDD_1V8
Xq_reg reset clk data q VSS VDD_1V8 DFRRQHDLLX0
.ENDS

.SUBCKT dff_async_rst_492 data clk reset q VSS VDD_1V8
Xq_reg reset clk data q VSS VDD_1V8 DFRRQHDLLX0
.ENDS

.SUBCKT dff_async_rst_491 data clk reset q VSS VDD_1V8
Xq_reg reset clk data q VSS VDD_1V8 DFRRQHDLLX0
.ENDS

.SUBCKT dff_async_rst_490 data clk reset q VSS VDD_1V8
Xq_reg reset clk data q VSS VDD_1V8 DFRRQHDLLX0
.ENDS

.SUBCKT dff_async_rst_489 data clk reset q VSS VDD_1V8
Xq_reg reset clk data q VSS VDD_1V8 DFRRQHDLLX0
.ENDS

.SUBCKT dff_async_rst_488 data clk reset q VSS VDD_1V8
Xq_reg reset clk data q VSS VDD_1V8 DFRRQHDLLX0
.ENDS

.SUBCKT dff_async_rst_487 data clk reset q VSS VDD_1V8
Xq_reg reset clk data q VSS VDD_1V8 DFRRQHDLLX0
.ENDS

.SUBCKT dff_async_rst_486 data clk reset q VSS VDD_1V8
Xq_reg reset clk data q VSS VDD_1V8 DFRRQHDLLX0
.ENDS

.SUBCKT dff_async_rst_483 data clk reset q VSS VDD_1V8
Xq_reg reset clk data q VSS VDD_1V8 DFRRQHDLLX0
.ENDS

.SUBCKT dff_async_rst_482 data clk reset q VSS VDD_1V8
Xq_reg reset clk data q VSS VDD_1V8 DFRRQHDLLX0
.ENDS

.SUBCKT dff_async_rst_481 data clk reset q VSS VDD_1V8
Xq_reg reset clk data q VSS VDD_1V8 DFRRQHDLLX0
.ENDS

.SUBCKT dff_async_rst_478 data clk reset q VSS VDD_1V8
Xq_reg reset clk data q VSS VDD_1V8 DFRRQHDLLX0
.ENDS

.SUBCKT dff_async_rst_477 data clk reset q VSS VDD_1V8
Xq_reg reset clk data q VSS VDD_1V8 DFRRQHDLLX0
.ENDS

.SUBCKT dff_async_rst_476 data clk reset q VSS VDD_1V8
Xq_reg reset clk data q VSS VDD_1V8 DFRRQHDLLX0
.ENDS

.SUBCKT dff_async_rst_475 data clk reset q VSS VDD_1V8
Xq_reg reset clk data q VSS VDD_1V8 DFRRQHDLLX0
.ENDS

.SUBCKT dff_async_rst_474 data clk reset q VSS VDD_1V8
Xq_reg reset clk data q VSS VDD_1V8 DFRRQHDLLX0
.ENDS

.SUBCKT dff_async_rst_473 data clk reset q VSS VDD_1V8
Xq_reg reset clk data q VSS VDD_1V8 DFRRQHDLLX0
.ENDS

.SUBCKT dff_async_rst_472 data clk reset q VSS VDD_1V8
Xq_reg reset clk data q VSS VDD_1V8 DFRRQHDLLX0
.ENDS

.SUBCKT dff_async_rst_471 data clk reset q VSS VDD_1V8
Xq_reg reset clk data q VSS VDD_1V8 DFRRQHDLLX0
.ENDS

.SUBCKT dff_async_rst_470 data clk reset q VSS VDD_1V8
Xq_reg reset clk data q VSS VDD_1V8 DFRRQHDLLX0
.ENDS

.SUBCKT dff_async_rst_469 data clk reset q VSS VDD_1V8
Xq_reg reset clk data q VSS VDD_1V8 DFRRQHDLLX0
.ENDS

.SUBCKT dff_async_rst_468 data clk reset q VSS VDD_1V8
Xq_reg reset clk data q VSS VDD_1V8 DFRRQHDLLX0
.ENDS

.SUBCKT dff_async_rst_467 data clk reset q VSS VDD_1V8
Xq_reg reset clk data q VSS VDD_1V8 DFRRQHDLLX0
.ENDS

.SUBCKT dff_async_rst_466 data clk reset q VSS VDD_1V8
Xq_reg reset clk data q VSS VDD_1V8 DFRRQHDLLX0
.ENDS

.SUBCKT dff_async_rst_465 data clk reset q VSS VDD_1V8
Xq_reg reset clk data q VSS VDD_1V8 DFRRQHDLLX0
.ENDS

.SUBCKT dff_async_rst_464 data clk reset q VSS VDD_1V8
Xq_reg reset clk data q VSS VDD_1V8 DFRRQHDLLX0
.ENDS

.SUBCKT dff_async_rst_463 data clk reset q VSS VDD_1V8
Xq_reg reset clk data q VSS VDD_1V8 DFRRQHDLLX0
.ENDS

.SUBCKT dff_async_rst_462 data clk reset q VSS VDD_1V8
Xq_reg reset clk data q VSS VDD_1V8 DFRRQHDLLX0
.ENDS

.SUBCKT dff_async_rst_461 data clk reset q VSS VDD_1V8
Xq_reg reset clk data q VSS VDD_1V8 DFRRQHDLLX0
.ENDS

.SUBCKT dff_async_rst_460 data clk reset q VSS VDD_1V8
Xq_reg reset clk data q VSS VDD_1V8 DFRRQHDLLX0
.ENDS

.SUBCKT dff_async_rst_459 data clk reset q VSS VDD_1V8
Xq_reg reset clk data q VSS VDD_1V8 DFRRQHDLLX0
.ENDS

.SUBCKT dff_async_rst_458 data clk reset q VSS VDD_1V8
Xq_reg reset clk data q VSS VDD_1V8 DFRRQHDLLX0
.ENDS

.SUBCKT dff_async_rst_457 data clk reset q VSS VDD_1V8
Xq_reg reset clk data q VSS VDD_1V8 DFRRQHDLLX0
.ENDS

.SUBCKT dff_async_rst_456 data clk reset q VSS VDD_1V8
Xq_reg reset clk data q VSS VDD_1V8 DFRRQHDLLX0
.ENDS

.SUBCKT dff_async_rst_455 data clk reset q VSS VDD_1V8
Xq_reg reset clk data q VSS VDD_1V8 DFRRQHDLLX0
.ENDS

.SUBCKT dff_async_rst_454 data clk reset q VSS VDD_1V8
Xq_reg reset clk data q VSS VDD_1V8 DFRRQHDLLX0
.ENDS

.SUBCKT dff_async_rst_453 data clk reset q VSS VDD_1V8
Xq_reg reset clk data q VSS VDD_1V8 DFRRQHDLLX0
.ENDS

.SUBCKT dff_async_rst_452 data clk reset q VSS VDD_1V8
Xq_reg reset clk data q VSS VDD_1V8 DFRRQHDLLX0
.ENDS

.SUBCKT dff_async_rst_451 data clk reset q VSS VDD_1V8
Xq_reg reset clk data q VSS VDD_1V8 DFRRQHDLLX0
.ENDS

.SUBCKT dff_async_rst_450 data clk reset q VSS VDD_1V8
Xq_reg reset clk data q VSS VDD_1V8 DFRRQHDLLX0
.ENDS

.SUBCKT dff_async_rst_449 data clk reset q VSS VDD_1V8
Xq_reg reset clk data q VSS VDD_1V8 DFRRQHDLLX0
.ENDS

.SUBCKT dff_async_rst_448 data clk reset q VSS VDD_1V8
Xq_reg reset clk data q VSS VDD_1V8 DFRRQHDLLX0
.ENDS

.SUBCKT dff_async_rst_447 data clk reset q VSS VDD_1V8
Xq_reg reset clk data q VSS VDD_1V8 DFRRQHDLLX0
.ENDS

.SUBCKT dff_async_rst_446 data clk reset q VSS VDD_1V8
Xq_reg reset clk data q VSS VDD_1V8 DFRRQHDLLX0
.ENDS

.SUBCKT dff_async_rst_445 data clk reset q VSS VDD_1V8
Xq_reg reset clk data q VSS VDD_1V8 DFRRQHDLLX0
.ENDS

.SUBCKT dff_async_rst_444 data clk reset q VSS VDD_1V8
Xq_reg reset clk data q VSS VDD_1V8 DFRRQHDLLX0
.ENDS

.SUBCKT dff_async_rst_443 data clk reset q VSS VDD_1V8
Xq_reg reset clk data q VSS VDD_1V8 DFRRQHDLLX0
.ENDS

.SUBCKT dff_async_rst_442 data clk reset q VSS VDD_1V8
Xq_reg reset clk data q VSS VDD_1V8 DFRRQHDLLX0
.ENDS

.SUBCKT dff_async_rst_441 data clk reset q VSS VDD_1V8
Xq_reg reset clk data q VSS VDD_1V8 DFRRQHDLLX0
.ENDS

.SUBCKT dff_async_rst_440 data clk reset q VSS VDD_1V8
Xq_reg reset clk data q VSS VDD_1V8 DFRRQHDLLX0
.ENDS

.SUBCKT dff_async_rst_439 data clk reset q VSS VDD_1V8
Xq_reg reset clk data q VSS VDD_1V8 DFRRQHDLLX0
.ENDS

.SUBCKT dff_async_rst_438 data clk reset q VSS VDD_1V8
Xq_reg reset clk data q VSS VDD_1V8 DFRRQHDLLX0
.ENDS

.SUBCKT dff_async_rst_437 data clk reset q VSS VDD_1V8
Xq_reg reset clk data q VSS VDD_1V8 DFRRQHDLLX0
.ENDS

.SUBCKT dff_async_rst_436 data clk reset q VSS VDD_1V8
Xq_reg reset clk data q VSS VDD_1V8 DFRRQHDLLX0
.ENDS

.SUBCKT dff_async_rst_435 data clk reset q VSS VDD_1V8
Xq_reg reset clk data q VSS VDD_1V8 DFRRQHDLLX0
.ENDS

.SUBCKT dff_async_rst_434 data clk reset q VSS VDD_1V8
Xq_reg reset clk data q VSS VDD_1V8 DFRRQHDLLX0
.ENDS

.SUBCKT dff_async_rst_433 data clk reset q VSS VDD_1V8
Xq_reg reset clk data q VSS VDD_1V8 DFRRQHDLLX0
.ENDS

.SUBCKT dff_async_rst_432 data clk reset q VSS VDD_1V8
Xq_reg reset clk data q VSS VDD_1V8 DFRRQHDLLX0
.ENDS

.SUBCKT dff_async_rst_431 data clk reset q VSS VDD_1V8
Xq_reg reset clk data q VSS VDD_1V8 DFRRQHDLLX0
.ENDS

.SUBCKT dff_async_rst_430 data clk reset q VSS VDD_1V8
Xq_reg reset clk data q VSS VDD_1V8 DFRRQHDLLX0
.ENDS

.SUBCKT dff_async_rst_429 data clk reset q VSS VDD_1V8
Xq_reg reset clk data q VSS VDD_1V8 DFRRQHDLLX0
.ENDS

.SUBCKT dff_async_rst_428 data clk reset q VSS VDD_1V8
Xq_reg reset clk data q VSS VDD_1V8 DFRRQHDLLX0
.ENDS

.SUBCKT dff_async_rst_427 data clk reset q VSS VDD_1V8
Xq_reg reset clk data q VSS VDD_1V8 DFRRQHDLLX0
.ENDS

.SUBCKT dff_async_rst_426 data clk reset q VSS VDD_1V8
Xq_reg reset clk data q VSS VDD_1V8 DFRRQHDLLX0
.ENDS

.SUBCKT dff_async_rst_425 data clk reset q VSS VDD_1V8
Xq_reg reset clk data q VSS VDD_1V8 DFRRQHDLLX0
.ENDS

.SUBCKT dff_async_rst_424 data clk reset q VSS VDD_1V8
Xq_reg reset clk data q VSS VDD_1V8 DFRRQHDLLX0
.ENDS

.SUBCKT dff_async_rst_423 data clk reset q VSS VDD_1V8
Xq_reg reset clk data q VSS VDD_1V8 DFRRQHDLLX0
.ENDS

.SUBCKT dff_async_rst_422 data clk reset q VSS VDD_1V8
Xq_reg reset clk data q VSS VDD_1V8 DFRRQHDLLX0
.ENDS

.SUBCKT dff_async_rst_421 data clk reset q VSS VDD_1V8
Xq_reg reset clk data q VSS VDD_1V8 DFRRQHDLLX0
.ENDS

.SUBCKT dff_async_rst_418 data clk reset q VSS VDD_1V8
Xq_reg reset clk data q VSS VDD_1V8 DFRRQHDLLX0
.ENDS

.SUBCKT dff_async_rst_417 data clk reset q VSS VDD_1V8
Xq_reg reset clk data q VSS VDD_1V8 DFRRQHDLLX0
.ENDS

.SUBCKT dff_async_rst_416 data clk reset q VSS VDD_1V8
Xq_reg reset clk data q VSS VDD_1V8 DFRRQHDLLX0
.ENDS

.SUBCKT dff_async_rst_413 data clk reset q VSS VDD_1V8
Xq_reg reset clk data q VSS VDD_1V8 DFRRQHDLLX0
.ENDS

.SUBCKT dff_async_rst_412 data clk reset q VSS VDD_1V8
Xq_reg reset clk data q VSS VDD_1V8 DFRRQHDLLX0
.ENDS

.SUBCKT dff_async_rst_411 data clk reset q VSS VDD_1V8
Xq_reg reset clk data q VSS VDD_1V8 DFRRQHDLLX0
.ENDS

.SUBCKT dff_async_rst_410 data clk reset q VSS VDD_1V8
Xq_reg reset clk data q VSS VDD_1V8 DFRRQHDLLX0
.ENDS

.SUBCKT dff_async_rst_409 data clk reset q VSS VDD_1V8
Xq_reg reset clk data q VSS VDD_1V8 DFRRQHDLLX0
.ENDS

.SUBCKT dff_async_rst_408 data clk reset q VSS VDD_1V8
Xq_reg reset clk data q VSS VDD_1V8 DFRRQHDLLX0
.ENDS

.SUBCKT dff_async_rst_407 data clk reset q VSS VDD_1V8
Xq_reg reset clk data q VSS VDD_1V8 DFRRQHDLLX0
.ENDS

.SUBCKT dff_async_rst_406 data clk reset q VSS VDD_1V8
Xq_reg reset clk data q VSS VDD_1V8 DFRRQHDLLX0
.ENDS

.SUBCKT dff_async_rst_405 data clk reset q VSS VDD_1V8
Xq_reg reset clk data q VSS VDD_1V8 DFRRQHDLLX0
.ENDS

.SUBCKT dff_async_rst_404 data clk reset q VSS VDD_1V8
Xq_reg reset clk data q VSS VDD_1V8 DFRRQHDLLX0
.ENDS

.SUBCKT dff_async_rst_403 data clk reset q VSS VDD_1V8
Xq_reg reset clk data q VSS VDD_1V8 DFRRQHDLLX0
.ENDS

.SUBCKT dff_async_rst_402 data clk reset q VSS VDD_1V8
Xq_reg reset clk data q VSS VDD_1V8 DFRRQHDLLX0
.ENDS

.SUBCKT dff_async_rst_401 data clk reset q VSS VDD_1V8
Xq_reg reset clk data q VSS VDD_1V8 DFRRQHDLLX0
.ENDS

.SUBCKT dff_async_rst_400 data clk reset q VSS VDD_1V8
Xq_reg reset clk data q VSS VDD_1V8 DFRRQHDLLX0
.ENDS

.SUBCKT dff_async_rst_399 data clk reset q VSS VDD_1V8
Xq_reg reset clk data q VSS VDD_1V8 DFRRQHDLLX0
.ENDS

.SUBCKT dff_async_rst_398 data clk reset q VSS VDD_1V8
Xq_reg reset clk data q VSS VDD_1V8 DFRRQHDLLX0
.ENDS

.SUBCKT dff_async_rst_397 data clk reset q VSS VDD_1V8
Xq_reg reset clk data q VSS VDD_1V8 DFRRQHDLLX0
.ENDS

.SUBCKT dff_async_rst_396 data clk reset q VSS VDD_1V8
Xq_reg reset clk data q VSS VDD_1V8 DFRRQHDLLX0
.ENDS

.SUBCKT dff_async_rst_395 data clk reset q VSS VDD_1V8
Xq_reg reset clk data q VSS VDD_1V8 DFRRQHDLLX0
.ENDS

.SUBCKT dff_async_rst_394 data clk reset q VSS VDD_1V8
Xq_reg reset clk data q VSS VDD_1V8 DFRRQHDLLX0
.ENDS

.SUBCKT dff_async_rst_393 data clk reset q VSS VDD_1V8
Xq_reg reset clk data q VSS VDD_1V8 DFRRQHDLLX0
.ENDS

.SUBCKT dff_async_rst_392 data clk reset q VSS VDD_1V8
Xq_reg reset clk data q VSS VDD_1V8 DFRRQHDLLX0
.ENDS

.SUBCKT dff_async_rst_391 data clk reset q VSS VDD_1V8
Xq_reg reset clk data q VSS VDD_1V8 DFRRQHDLLX0
.ENDS

.SUBCKT dff_async_rst_390 data clk reset q VSS VDD_1V8
Xq_reg reset clk data q VSS VDD_1V8 DFRRQHDLLX0
.ENDS

.SUBCKT dff_async_rst_389 data clk reset q VSS VDD_1V8
Xq_reg reset clk data q VSS VDD_1V8 DFRRQHDLLX0
.ENDS

.SUBCKT dff_async_rst_388 data clk reset q VSS VDD_1V8
Xq_reg reset clk data q VSS VDD_1V8 DFRRQHDLLX0
.ENDS

.SUBCKT dff_async_rst_387 data clk reset q VSS VDD_1V8
Xq_reg reset clk data q VSS VDD_1V8 DFRRQHDLLX0
.ENDS

.SUBCKT dff_async_rst_386 data clk reset q VSS VDD_1V8
Xq_reg reset clk data q VSS VDD_1V8 DFRRQHDLLX0
.ENDS

.SUBCKT dff_async_rst_385 data clk reset q VSS VDD_1V8
Xq_reg reset clk data q VSS VDD_1V8 DFRRQHDLLX0
.ENDS

.SUBCKT dff_async_rst_384 data clk reset q VSS VDD_1V8
Xq_reg reset clk data q VSS VDD_1V8 DFRRQHDLLX0
.ENDS

.SUBCKT dff_async_rst_383 data clk reset q VSS VDD_1V8
Xq_reg reset clk data q VSS VDD_1V8 DFRRQHDLLX0
.ENDS

.SUBCKT dff_async_rst_382 data clk reset q VSS VDD_1V8
Xq_reg reset clk data q VSS VDD_1V8 DFRRQHDLLX0
.ENDS

.SUBCKT dff_async_rst_381 data clk reset q VSS VDD_1V8
Xq_reg reset clk data q VSS VDD_1V8 DFRRQHDLLX0
.ENDS

.SUBCKT dff_async_rst_380 data clk reset q VSS VDD_1V8
Xq_reg reset clk data q VSS VDD_1V8 DFRRQHDLLX0
.ENDS

.SUBCKT dff_async_rst_379 data clk reset q VSS VDD_1V8
Xq_reg reset clk data q VSS VDD_1V8 DFRRQHDLLX0
.ENDS

.SUBCKT dff_async_rst_378 data clk reset q VSS VDD_1V8
Xq_reg reset clk data q VSS VDD_1V8 DFRRQHDLLX0
.ENDS

.SUBCKT dff_async_rst_377 data clk reset q VSS VDD_1V8
Xq_reg reset clk data q VSS VDD_1V8 DFRRQHDLLX0
.ENDS

.SUBCKT dff_async_rst_376 data clk reset q VSS VDD_1V8
Xq_reg reset clk data q VSS VDD_1V8 DFRRQHDLLX0
.ENDS

.SUBCKT dff_async_rst_375 data clk reset q VSS VDD_1V8
Xq_reg reset clk data q VSS VDD_1V8 DFRRQHDLLX0
.ENDS

.SUBCKT dff_async_rst_374 data clk reset q VSS VDD_1V8
Xq_reg reset clk data q VSS VDD_1V8 DFRRQHDLLX0
.ENDS

.SUBCKT dff_async_rst_373 data clk reset q VSS VDD_1V8
Xq_reg reset clk data q VSS VDD_1V8 DFRRQHDLLX0
.ENDS

.SUBCKT dff_async_rst_372 data clk reset q VSS VDD_1V8
Xq_reg reset clk data q VSS VDD_1V8 DFRRQHDLLX0
.ENDS

.SUBCKT dff_async_rst_371 data clk reset q VSS VDD_1V8
Xq_reg reset clk data q VSS VDD_1V8 DFRRQHDLLX0
.ENDS

.SUBCKT dff_async_rst_370 data clk reset q VSS VDD_1V8
Xq_reg reset clk data q VSS VDD_1V8 DFRRQHDLLX0
.ENDS

.SUBCKT dff_async_rst_369 data clk reset q VSS VDD_1V8
Xq_reg reset clk data q VSS VDD_1V8 DFRRQHDLLX0
.ENDS

.SUBCKT dff_async_rst_368 data clk reset q VSS VDD_1V8
Xq_reg reset clk data q VSS VDD_1V8 DFRRQHDLLX0
.ENDS

.SUBCKT dff_async_rst_367 data clk reset q VSS VDD_1V8
Xq_reg reset clk data q VSS VDD_1V8 DFRRQHDLLX0
.ENDS

.SUBCKT dff_async_rst_366 data clk reset q VSS VDD_1V8
Xq_reg reset clk data q VSS VDD_1V8 DFRRQHDLLX0
.ENDS

.SUBCKT dff_async_rst_365 data clk reset q VSS VDD_1V8
Xq_reg reset clk data q VSS VDD_1V8 DFRRQHDLLX0
.ENDS

.SUBCKT dff_async_rst_364 data clk reset q VSS VDD_1V8
Xq_reg reset clk data q VSS VDD_1V8 DFRRQHDLLX0
.ENDS

.SUBCKT dff_async_rst_363 data clk reset q VSS VDD_1V8
Xq_reg reset clk data q VSS VDD_1V8 DFRRQHDLLX0
.ENDS

.SUBCKT dff_async_rst_362 data clk reset q VSS VDD_1V8
Xq_reg reset clk data q VSS VDD_1V8 DFRRQHDLLX0
.ENDS

.SUBCKT dff_async_rst_361 data clk reset q VSS VDD_1V8
Xq_reg reset clk data q VSS VDD_1V8 DFRRQHDLLX0
.ENDS

.SUBCKT dff_async_rst_360 data clk reset q VSS VDD_1V8
Xq_reg reset clk data q VSS VDD_1V8 DFRRQHDLLX0
.ENDS

.SUBCKT dff_async_rst_359 data clk reset q VSS VDD_1V8
Xq_reg reset clk data q VSS VDD_1V8 DFRRQHDLLX0
.ENDS

.SUBCKT dff_async_rst_358 data clk reset q VSS VDD_1V8
Xq_reg reset clk data q VSS VDD_1V8 DFRRQHDLLX0
.ENDS

.SUBCKT dff_async_rst_357 data clk reset q VSS VDD_1V8
Xq_reg reset clk data q VSS VDD_1V8 DFRRQHDLLX0
.ENDS

.SUBCKT dff_async_rst_356 data clk reset q VSS VDD_1V8
Xq_reg reset clk data q VSS VDD_1V8 DFRRQHDLLX0
.ENDS

.SUBCKT dff_async_rst_355 data clk reset q VSS VDD_1V8
Xq_reg reset clk data q VSS VDD_1V8 DFRRQHDLLX0
.ENDS

.SUBCKT dff_async_rst_354 data clk reset q VSS VDD_1V8
Xq_reg reset clk data q VSS VDD_1V8 DFRRQHDLLX0
.ENDS

.SUBCKT dff_async_rst_353 data clk reset q VSS VDD_1V8
Xq_reg reset clk data q VSS VDD_1V8 DFRRQHDLLX0
.ENDS

.SUBCKT dff_async_rst_352 data clk reset q VSS VDD_1V8
Xq_reg reset clk data q VSS VDD_1V8 DFRRQHDLLX0
.ENDS

.SUBCKT dff_async_rst_351 data clk reset q VSS VDD_1V8
Xq_reg reset clk data q VSS VDD_1V8 DFRRQHDLLX0
.ENDS

.SUBCKT dff_async_rst_350 data clk reset q VSS VDD_1V8
Xq_reg reset clk data q VSS VDD_1V8 DFRRQHDLLX0
.ENDS

.SUBCKT dff_async_rst_345 data clk reset q VSS VDD_1V8
Xq_reg reset clk data q VSS VDD_1V8 DFRRQHDLLX0
.ENDS

.SUBCKT dff_async_rst_344 data clk reset q VSS VDD_1V8
Xq_reg reset clk data q VSS VDD_1V8 DFRRQHDLLX0
.ENDS

.SUBCKT dff_async_rst_343 data clk reset q VSS VDD_1V8
Xq_reg reset clk data q VSS VDD_1V8 DFRRQHDLLX0
.ENDS

.SUBCKT dff_async_rst_342 data clk reset q VSS VDD_1V8
Xq_reg reset clk data q VSS VDD_1V8 DFRRQHDLLX0
.ENDS

.SUBCKT dff_async_rst_341 data clk reset q VSS VDD_1V8
Xq_reg reset clk data q VSS VDD_1V8 DFRRQHDLLX0
.ENDS

.SUBCKT dff_async_rst_340 data clk reset q VSS VDD_1V8
Xq_reg reset clk data q VSS VDD_1V8 DFRRQHDLLX0
.ENDS

.SUBCKT dff_async_rst_339 data clk reset q VSS VDD_1V8
Xq_reg reset clk data q VSS VDD_1V8 DFRRQHDLLX0
.ENDS

.SUBCKT dff_async_rst_338 data clk reset q VSS VDD_1V8
Xq_reg reset clk data q VSS VDD_1V8 DFRRQHDLLX0
.ENDS

.SUBCKT dff_async_rst_337 data clk reset q VSS VDD_1V8
Xq_reg reset clk data q VSS VDD_1V8 DFRRQHDLLX0
.ENDS

.SUBCKT dff_async_rst_336 data clk reset q VSS VDD_1V8
Xq_reg reset clk data q VSS VDD_1V8 DFRRQHDLLX0
.ENDS

.SUBCKT dff_async_rst_335 data clk reset q VSS VDD_1V8
Xq_reg reset clk data q VSS VDD_1V8 DFRRQHDLLX0
.ENDS

.SUBCKT dff_async_rst_334 data clk reset q VSS VDD_1V8
Xq_reg reset clk data q VSS VDD_1V8 DFRRQHDLLX0
.ENDS

.SUBCKT dff_async_rst_333 data clk reset q VSS VDD_1V8
Xq_reg reset clk data q VSS VDD_1V8 DFRRQHDLLX0
.ENDS

.SUBCKT dff_async_rst_332 data clk reset q VSS VDD_1V8
Xq_reg reset clk data q VSS VDD_1V8 DFRRQHDLLX0
.ENDS

.SUBCKT dff_async_rst_331 data clk reset q VSS VDD_1V8
Xq_reg reset clk data q VSS VDD_1V8 DFRRQHDLLX0
.ENDS

.SUBCKT dff_async_rst_330 data clk reset q VSS VDD_1V8
Xq_reg reset clk data q VSS VDD_1V8 DFRRQHDLLX0
.ENDS

.SUBCKT dff_async_rst_329 data clk reset q VSS VDD_1V8
Xq_reg reset clk data q VSS VDD_1V8 DFRRQHDLLX0
.ENDS

.SUBCKT dff_async_rst_328 data clk reset q VSS VDD_1V8
Xq_reg reset clk data q VSS VDD_1V8 DFRRQHDLLX0
.ENDS

.SUBCKT dff_async_rst_327 data clk reset q VSS VDD_1V8
Xq_reg reset clk data q VSS VDD_1V8 DFRRQHDLLX0
.ENDS

.SUBCKT dff_async_rst_326 data clk reset q VSS VDD_1V8
Xq_reg reset clk data q VSS VDD_1V8 DFRRQHDLLX0
.ENDS

.SUBCKT dff_async_rst_325 data clk reset q VSS VDD_1V8
Xq_reg reset clk data q VSS VDD_1V8 DFRRQHDLLX0
.ENDS

.SUBCKT dff_async_rst_324 data clk reset q VSS VDD_1V8
Xq_reg reset clk data q VSS VDD_1V8 DFRRQHDLLX0
.ENDS

.SUBCKT dff_async_rst_323 data clk reset q VSS VDD_1V8
Xq_reg reset clk data q VSS VDD_1V8 DFRRQHDLLX0
.ENDS

.SUBCKT dff_async_rst_322 data clk reset q VSS VDD_1V8
Xq_reg reset clk data q VSS VDD_1V8 DFRRQHDLLX0
.ENDS

.SUBCKT dff_async_rst_321 data clk reset q VSS VDD_1V8
Xq_reg reset clk data q VSS VDD_1V8 DFRRQHDLLX0
.ENDS

.SUBCKT dff_async_rst_320 data clk reset q VSS VDD_1V8
Xq_reg reset clk data q VSS VDD_1V8 DFRRQHDLLX0
.ENDS

.SUBCKT dff_async_rst_319 data clk reset q VSS VDD_1V8
Xq_reg reset clk data q VSS VDD_1V8 DFRRQHDLLX0
.ENDS

.SUBCKT dff_async_rst_318 data clk reset q VSS VDD_1V8
Xq_reg reset clk data q VSS VDD_1V8 DFRRQHDLLX0
.ENDS

.SUBCKT dff_async_rst_317 data clk reset q VSS VDD_1V8
Xq_reg reset clk data q VSS VDD_1V8 DFRRQHDLLX0
.ENDS

.SUBCKT dff_async_rst_316 data clk reset q VSS VDD_1V8
Xq_reg reset clk data q VSS VDD_1V8 DFRRQHDLLX0
.ENDS

.SUBCKT dff_async_rst_315 data clk reset q VSS VDD_1V8
Xq_reg reset clk data q VSS VDD_1V8 DFRRQHDLLX0
.ENDS

.SUBCKT dff_async_rst_314 data clk reset q VSS VDD_1V8
Xq_reg reset clk data q VSS VDD_1V8 DFRRQHDLLX0
.ENDS

.SUBCKT dff_async_rst_313 data clk reset q VSS VDD_1V8
Xq_reg reset clk data q VSS VDD_1V8 DFRRQHDLLX0
.ENDS

.SUBCKT dff_async_rst_312 data clk reset q VSS VDD_1V8
Xq_reg reset clk data q VSS VDD_1V8 DFRRQHDLLX0
.ENDS

.SUBCKT dff_async_rst_311 data clk reset q VSS VDD_1V8
Xq_reg reset clk data q VSS VDD_1V8 DFRRQHDLLX0
.ENDS

.SUBCKT dff_async_rst_310 data clk reset q VSS VDD_1V8
Xq_reg reset clk data q VSS VDD_1V8 DFRRQHDLLX0
.ENDS

.SUBCKT dff_async_rst_309 data clk reset q VSS VDD_1V8
Xq_reg reset clk data q VSS VDD_1V8 DFRRQHDLLX0
.ENDS

.SUBCKT dff_async_rst_308 data clk reset q VSS VDD_1V8
Xq_reg reset clk data q VSS VDD_1V8 DFRRQHDLLX0
.ENDS

.SUBCKT dff_async_rst_307 data clk reset q VSS VDD_1V8
Xq_reg reset clk data q VSS VDD_1V8 DFRRQHDLLX0
.ENDS

.SUBCKT dff_async_rst_306 data clk reset q VSS VDD_1V8
Xq_reg reset clk data q VSS VDD_1V8 DFRRQHDLLX0
.ENDS

.SUBCKT dff_async_rst_305 data clk reset q VSS VDD_1V8
Xq_reg reset clk data q VSS VDD_1V8 DFRRQHDLLX0
.ENDS

.SUBCKT dff_async_rst_304 data clk reset q VSS VDD_1V8
Xq_reg reset clk data q VSS VDD_1V8 DFRRQHDLLX0
.ENDS

.SUBCKT dff_async_rst_303 data clk reset q VSS VDD_1V8
Xq_reg reset clk data q VSS VDD_1V8 DFRRQHDLLX0
.ENDS

.SUBCKT dff_async_rst_302 data clk reset q VSS VDD_1V8
Xq_reg reset clk data q VSS VDD_1V8 DFRRQHDLLX0
.ENDS

.SUBCKT dff_async_rst_301 data clk reset q VSS VDD_1V8
Xq_reg reset clk data q VSS VDD_1V8 DFRRQHDLLX0
.ENDS

.SUBCKT dff_async_rst_300 data clk reset q VSS VDD_1V8
Xq_reg reset clk data q VSS VDD_1V8 DFRRQHDLLX0
.ENDS

.SUBCKT dff_async_rst_299 data clk reset q VSS VDD_1V8
Xq_reg reset clk data q VSS VDD_1V8 DFRRQHDLLX0
.ENDS

.SUBCKT dff_async_rst_298 data clk reset q VSS VDD_1V8
Xq_reg reset clk data q VSS VDD_1V8 DFRRQHDLLX0
.ENDS

.SUBCKT dff_async_rst_297 data clk reset q VSS VDD_1V8
Xq_reg reset clk data q VSS VDD_1V8 DFRRQHDLLX0
.ENDS

.SUBCKT dff_async_rst_296 data clk reset q VSS VDD_1V8
Xq_reg reset clk data q VSS VDD_1V8 DFRRQHDLLX0
.ENDS

.SUBCKT dff_async_rst_295 data clk reset q VSS VDD_1V8
Xq_reg reset clk data q VSS VDD_1V8 DFRRQHDLLX0
.ENDS

.SUBCKT dff_async_rst_294 data clk reset q VSS VDD_1V8
Xq_reg reset clk data q VSS VDD_1V8 DFRRQHDLLX0
.ENDS

.SUBCKT dff_async_rst_293 data clk reset q VSS VDD_1V8
Xq_reg reset clk data q VSS VDD_1V8 DFRRQHDLLX0
.ENDS

.SUBCKT dff_async_rst_292 data clk reset q VSS VDD_1V8
Xq_reg reset clk data q VSS VDD_1V8 DFRRQHDLLX0
.ENDS

.SUBCKT dff_async_rst_291 data clk reset q VSS VDD_1V8
Xq_reg reset clk data q VSS VDD_1V8 DFRRQHDLLX0
.ENDS

.SUBCKT dff_async_rst_290 data clk reset q VSS VDD_1V8
Xq_reg reset clk data q VSS VDD_1V8 DFRRQHDLLX0
.ENDS

.SUBCKT dff_async_rst_289 data clk reset q VSS VDD_1V8
Xq_reg reset clk data q VSS VDD_1V8 DFRRQHDLLX0
.ENDS

.SUBCKT dff_async_rst_288 data clk reset q VSS VDD_1V8
Xq_reg reset clk data q VSS VDD_1V8 DFRRQHDLLX0
.ENDS

.SUBCKT dff_async_rst_287 data clk reset q VSS VDD_1V8
Xq_reg reset clk data q VSS VDD_1V8 DFRRQHDLLX0
.ENDS

.SUBCKT dff_async_rst_286 data clk reset q VSS VDD_1V8
Xq_reg reset clk data q VSS VDD_1V8 DFRRQHDLLX0
.ENDS

.SUBCKT dff_async_rst_285 data clk reset q VSS VDD_1V8
Xq_reg reset clk data q VSS VDD_1V8 DFRRQHDLLX0
.ENDS

.SUBCKT dff_async_rst_280 data clk reset q VSS VDD_1V8
Xq_reg reset clk data q VSS VDD_1V8 DFRRQHDLLX0
.ENDS

.SUBCKT dff_async_rst_279 data clk reset q VSS VDD_1V8
Xq_reg reset clk data q VSS VDD_1V8 DFRRQHDLLX0
.ENDS

.SUBCKT dff_async_rst_278 data clk reset q VSS VDD_1V8
Xq_reg reset clk data q VSS VDD_1V8 DFRRQHDLLX0
.ENDS

.SUBCKT dff_async_rst_277 data clk reset q VSS VDD_1V8
Xq_reg reset clk data q VSS VDD_1V8 DFRRQHDLLX0
.ENDS

.SUBCKT dff_async_rst_276 data clk reset q VSS VDD_1V8
Xq_reg reset clk data q VSS VDD_1V8 DFRRQHDLLX0
.ENDS

.SUBCKT dff_async_rst_275 data clk reset q VSS VDD_1V8
Xq_reg reset clk data q VSS VDD_1V8 DFRRQHDLLX0
.ENDS

.SUBCKT dff_async_rst_274 data clk reset q VSS VDD_1V8
Xq_reg reset clk data q VSS VDD_1V8 DFRRQHDLLX0
.ENDS

.SUBCKT dff_async_rst_273 data clk reset q VSS VDD_1V8
Xq_reg reset clk data q VSS VDD_1V8 DFRRQHDLLX0
.ENDS

.SUBCKT dff_async_rst_272 data clk reset q VSS VDD_1V8
Xq_reg reset clk data q VSS VDD_1V8 DFRRQHDLLX0
.ENDS

.SUBCKT dff_async_rst_271 data clk reset q VSS VDD_1V8
Xq_reg reset clk data q VSS VDD_1V8 DFRRQHDLLX0
.ENDS

.SUBCKT dff_async_rst_270 data clk reset q VSS VDD_1V8
Xq_reg reset clk data q VSS VDD_1V8 DFRRQHDLLX0
.ENDS

.SUBCKT dff_async_rst_269 data clk reset q VSS VDD_1V8
Xq_reg reset clk data q VSS VDD_1V8 DFRRQHDLLX0
.ENDS

.SUBCKT dff_async_rst_268 data clk reset q VSS VDD_1V8
Xq_reg reset clk data q VSS VDD_1V8 DFRRQHDLLX0
.ENDS

.SUBCKT dff_async_rst_267 data clk reset q VSS VDD_1V8
Xq_reg reset clk data q VSS VDD_1V8 DFRRQHDLLX0
.ENDS

.SUBCKT dff_async_rst_266 data clk reset q VSS VDD_1V8
Xq_reg reset clk data q VSS VDD_1V8 DFRRQHDLLX0
.ENDS

.SUBCKT dff_async_rst_265 data clk reset q VSS VDD_1V8
Xq_reg reset clk data q VSS VDD_1V8 DFRRQHDLLX0
.ENDS

.SUBCKT dff_async_rst_264 data clk reset q VSS VDD_1V8
Xq_reg reset clk data q VSS VDD_1V8 DFRRQHDLLX0
.ENDS

.SUBCKT dff_async_rst_263 data clk reset q VSS VDD_1V8
Xq_reg reset clk data q VSS VDD_1V8 DFRRQHDLLX0
.ENDS

.SUBCKT dff_async_rst_262 data clk reset q VSS VDD_1V8
Xq_reg reset clk data q VSS VDD_1V8 DFRRQHDLLX0
.ENDS

.SUBCKT dff_async_rst_261 data clk reset q VSS VDD_1V8
Xq_reg reset clk data q VSS VDD_1V8 DFRRQHDLLX0
.ENDS

.SUBCKT dff_async_rst_260 data clk reset q VSS VDD_1V8
Xq_reg reset clk data q VSS VDD_1V8 DFRRQHDLLX0
.ENDS

.SUBCKT dff_async_rst_259 data clk reset q VSS VDD_1V8
Xq_reg reset clk data q VSS VDD_1V8 DFRRQHDLLX0
.ENDS

.SUBCKT dff_async_rst_258 data clk reset q VSS VDD_1V8
Xq_reg reset clk data q VSS VDD_1V8 DFRRQHDLLX0
.ENDS

.SUBCKT dff_async_rst_257 data clk reset q VSS VDD_1V8
Xq_reg reset clk data q VSS VDD_1V8 DFRRQHDLLX0
.ENDS

.SUBCKT dff_async_rst_256 data clk reset q VSS VDD_1V8
Xq_reg reset clk data q VSS VDD_1V8 DFRRQHDLLX0
.ENDS

.SUBCKT dff_async_rst_255 data clk reset q VSS VDD_1V8
Xq_reg reset clk data q VSS VDD_1V8 DFRRQHDLLX0
.ENDS

.SUBCKT dff_async_rst_254 data clk reset q VSS VDD_1V8
Xq_reg reset clk data q VSS VDD_1V8 DFRRQHDLLX0
.ENDS

.SUBCKT dff_async_rst_253 data clk reset q VSS VDD_1V8
Xq_reg reset clk data q VSS VDD_1V8 DFRRQHDLLX0
.ENDS

.SUBCKT dff_async_rst_252 data clk reset q VSS VDD_1V8
Xq_reg reset clk data q VSS VDD_1V8 DFRRQHDLLX0
.ENDS

.SUBCKT dff_async_rst_251 data clk reset q VSS VDD_1V8
Xq_reg reset clk data q VSS VDD_1V8 DFRRQHDLLX0
.ENDS

.SUBCKT dff_async_rst_250 data clk reset q VSS VDD_1V8
Xq_reg reset clk data q VSS VDD_1V8 DFRRQHDLLX0
.ENDS

.SUBCKT dff_async_rst_249 data clk reset q VSS VDD_1V8
Xq_reg reset clk data q VSS VDD_1V8 DFRRQHDLLX0
.ENDS

.SUBCKT dff_async_rst_248 data clk reset q VSS VDD_1V8
Xq_reg reset clk data q VSS VDD_1V8 DFRRQHDLLX0
.ENDS

.SUBCKT dff_async_rst_247 data clk reset q VSS VDD_1V8
Xq_reg reset clk data q VSS VDD_1V8 DFRRQHDLLX0
.ENDS

.SUBCKT dff_async_rst_246 data clk reset q VSS VDD_1V8
Xq_reg reset clk data q VSS VDD_1V8 DFRRQHDLLX0
.ENDS

.SUBCKT dff_async_rst_245 data clk reset q VSS VDD_1V8
Xq_reg reset clk data q VSS VDD_1V8 DFRRQHDLLX0
.ENDS

.SUBCKT dff_async_rst_244 data clk reset q VSS VDD_1V8
Xq_reg reset clk data q VSS VDD_1V8 DFRRQHDLLX0
.ENDS

.SUBCKT dff_async_rst_243 data clk reset q VSS VDD_1V8
Xq_reg reset clk data q VSS VDD_1V8 DFRRQHDLLX0
.ENDS

.SUBCKT dff_async_rst_242 data clk reset q VSS VDD_1V8
Xq_reg reset clk data q VSS VDD_1V8 DFRRQHDLLX0
.ENDS

.SUBCKT dff_async_rst_241 data clk reset q VSS VDD_1V8
Xq_reg reset clk data q VSS VDD_1V8 DFRRQHDLLX0
.ENDS

.SUBCKT dff_async_rst_240 data clk reset q VSS VDD_1V8
Xq_reg reset clk data q VSS VDD_1V8 DFRRQHDLLX0
.ENDS

.SUBCKT dff_async_rst_239 data clk reset q VSS VDD_1V8
Xq_reg reset clk data q VSS VDD_1V8 DFRRQHDLLX0
.ENDS

.SUBCKT dff_async_rst_238 data clk reset q VSS VDD_1V8
Xq_reg reset clk data q VSS VDD_1V8 DFRRQHDLLX0
.ENDS

.SUBCKT dff_async_rst_237 data clk reset q VSS VDD_1V8
Xq_reg reset clk data q VSS VDD_1V8 DFRRQHDLLX0
.ENDS

.SUBCKT dff_async_rst_236 data clk reset q VSS VDD_1V8
Xq_reg reset clk data q VSS VDD_1V8 DFRRQHDLLX0
.ENDS

.SUBCKT dff_async_rst_235 data clk reset q VSS VDD_1V8
Xq_reg reset clk data q VSS VDD_1V8 DFRRQHDLLX0
.ENDS

.SUBCKT dff_async_rst_234 data clk reset q VSS VDD_1V8
Xq_reg reset clk data q VSS VDD_1V8 DFRRQHDLLX0
.ENDS

.SUBCKT dff_async_rst_233 data clk reset q VSS VDD_1V8
Xq_reg reset clk data q VSS VDD_1V8 DFRRQHDLLX0
.ENDS

.SUBCKT dff_async_rst_232 data clk reset q VSS VDD_1V8
Xq_reg reset clk data q VSS VDD_1V8 DFRRQHDLLX0
.ENDS

.SUBCKT dff_async_rst_231 data clk reset q VSS VDD_1V8
Xq_reg reset clk data q VSS VDD_1V8 DFRRQHDLLX0
.ENDS

.SUBCKT dff_async_rst_230 data clk reset q VSS VDD_1V8
Xq_reg reset clk data q VSS VDD_1V8 DFRRQHDLLX0
.ENDS

.SUBCKT dff_async_rst_229 data clk reset q VSS VDD_1V8
Xq_reg reset clk data q VSS VDD_1V8 DFRRQHDLLX0
.ENDS

.SUBCKT dff_async_rst_228 data clk reset q VSS VDD_1V8
Xq_reg reset clk data q VSS VDD_1V8 DFRRQHDLLX0
.ENDS

.SUBCKT dff_async_rst_227 data clk reset q VSS VDD_1V8
Xq_reg reset clk data q VSS VDD_1V8 DFRRQHDLLX0
.ENDS

.SUBCKT dff_async_rst_226 data clk reset q VSS VDD_1V8
Xq_reg reset clk data q VSS VDD_1V8 DFRRQHDLLX0
.ENDS

.SUBCKT dff_async_rst_225 data clk reset q VSS VDD_1V8
Xq_reg reset clk data q VSS VDD_1V8 DFRRQHDLLX0
.ENDS

.SUBCKT dff_async_rst_224 data clk reset q VSS VDD_1V8
Xq_reg reset clk data q VSS VDD_1V8 DFRRQHDLLX0
.ENDS

.SUBCKT dff_async_rst_223 data clk reset q VSS VDD_1V8
Xq_reg reset clk data q VSS VDD_1V8 DFRRQHDLLX0
.ENDS

.SUBCKT dff_async_rst_222 data clk reset q VSS VDD_1V8
Xq_reg reset clk data q VSS VDD_1V8 DFRRQHDLLX0
.ENDS

.SUBCKT dff_async_rst_221 data clk reset q VSS VDD_1V8
Xq_reg reset clk data q VSS VDD_1V8 DFRRQHDLLX0
.ENDS

.SUBCKT dff_async_rst_220 data clk reset q VSS VDD_1V8
Xq_reg reset clk data q VSS VDD_1V8 DFRRQHDLLX0
.ENDS

.SUBCKT dff_async_rst_219 data clk reset q VSS VDD_1V8
Xq_reg reset clk data q VSS VDD_1V8 DFRRQHDLLX0
.ENDS

.SUBCKT dff_async_rst_218 data clk reset q VSS VDD_1V8
Xq_reg reset clk data q VSS VDD_1V8 DFRRQHDLLX0
.ENDS

.SUBCKT dff_async_rst_217 data clk reset q VSS VDD_1V8
Xq_reg reset clk data q VSS VDD_1V8 DFRRQHDLLX0
.ENDS

.SUBCKT dff_async_rst_215 data clk reset q VSS VDD_1V8
Xq_reg reset clk data q VSS VDD_1V8 DFRRQHDLLX0
.ENDS

.SUBCKT dff_async_rst_214 data clk reset q VSS VDD_1V8
Xq_reg reset clk data q VSS VDD_1V8 DFRRQHDLLX0
.ENDS

.SUBCKT dff_async_rst_213 data clk reset q VSS VDD_1V8
Xq_reg reset clk data q VSS VDD_1V8 DFRRQHDLLX0
.ENDS

.SUBCKT dff_async_rst_212 data clk reset q VSS VDD_1V8
Xq_reg reset clk data q VSS VDD_1V8 DFRRQHDLLX0
.ENDS

.SUBCKT dff_async_rst_211 data clk reset q VSS VDD_1V8
Xq_reg reset clk data q VSS VDD_1V8 DFRRQHDLLX0
.ENDS

.SUBCKT dff_async_rst_210 data clk reset q VSS VDD_1V8
Xq_reg reset clk data q VSS VDD_1V8 DFRRQHDLLX0
.ENDS

.SUBCKT dff_async_rst_209 data clk reset q VSS VDD_1V8
Xq_reg reset clk data q VSS VDD_1V8 DFRRQHDLLX0
.ENDS

.SUBCKT dff_async_rst_208 data clk reset q VSS VDD_1V8
Xq_reg reset clk data q VSS VDD_1V8 DFRRQHDLLX0
.ENDS

.SUBCKT dff_async_rst_207 data clk reset q VSS VDD_1V8
Xq_reg reset clk data q VSS VDD_1V8 DFRRQHDLLX0
.ENDS

.SUBCKT dff_async_rst_206 data clk reset q VSS VDD_1V8
Xq_reg reset clk data q VSS VDD_1V8 DFRRQHDLLX0
.ENDS

.SUBCKT dff_async_rst_205 data clk reset q VSS VDD_1V8
Xq_reg reset clk data q VSS VDD_1V8 DFRRQHDLLX0
.ENDS

.SUBCKT dff_async_rst_204 data clk reset q VSS VDD_1V8
Xq_reg reset clk data q VSS VDD_1V8 DFRRQHDLLX0
.ENDS

.SUBCKT dff_async_rst_203 data clk reset q VSS VDD_1V8
Xq_reg reset clk data q VSS VDD_1V8 DFRRQHDLLX0
.ENDS

.SUBCKT dff_async_rst_202 data clk reset q VSS VDD_1V8
Xq_reg reset clk data q VSS VDD_1V8 DFRRQHDLLX0
.ENDS

.SUBCKT dff_async_rst_201 data clk reset q VSS VDD_1V8
Xq_reg reset clk data q VSS VDD_1V8 DFRRQHDLLX0
.ENDS

.SUBCKT dff_async_rst_200 data clk reset q VSS VDD_1V8
Xq_reg reset clk data q VSS VDD_1V8 DFRRQHDLLX0
.ENDS

.SUBCKT dff_async_rst_199 data clk reset q VSS VDD_1V8
Xq_reg reset clk data q VSS VDD_1V8 DFRRQHDLLX0
.ENDS

.SUBCKT dff_async_rst_198 data clk reset q VSS VDD_1V8
Xq_reg reset clk data q VSS VDD_1V8 DFRRQHDLLX0
.ENDS

.SUBCKT dff_async_rst_197 data clk reset q VSS VDD_1V8
Xq_reg reset clk data q VSS VDD_1V8 DFRRQHDLLX0
.ENDS

.SUBCKT dff_async_rst_196 data clk reset q VSS VDD_1V8
Xq_reg reset clk data q VSS VDD_1V8 DFRRQHDLLX0
.ENDS

.SUBCKT dff_async_rst_195 data clk reset q VSS VDD_1V8
Xq_reg reset clk data q VSS VDD_1V8 DFRRQHDLLX0
.ENDS

.SUBCKT dff_async_rst_194 data clk reset q VSS VDD_1V8
Xq_reg reset clk data q VSS VDD_1V8 DFRRQHDLLX0
.ENDS

.SUBCKT dff_async_rst_193 data clk reset q VSS VDD_1V8
Xq_reg reset clk data q VSS VDD_1V8 DFRRQHDLLX0
.ENDS

.SUBCKT dff_async_rst_192 data clk reset q VSS VDD_1V8
Xq_reg reset clk data q VSS VDD_1V8 DFRRQHDLLX0
.ENDS

.SUBCKT dff_async_rst_191 data clk reset q VSS VDD_1V8
Xq_reg reset clk data q VSS VDD_1V8 DFRRQHDLLX0
.ENDS

.SUBCKT dff_async_rst_190 data clk reset q VSS VDD_1V8
Xq_reg reset clk data q VSS VDD_1V8 DFRRQHDLLX0
.ENDS

.SUBCKT dff_async_rst_189 data clk reset q VSS VDD_1V8
Xq_reg reset clk data q VSS VDD_1V8 DFRRQHDLLX0
.ENDS

.SUBCKT dff_async_rst_188 data clk reset q VSS VDD_1V8
Xq_reg reset clk data q VSS VDD_1V8 DFRRQHDLLX0
.ENDS

.SUBCKT dff_async_rst_187 data clk reset q VSS VDD_1V8
Xq_reg reset clk data q VSS VDD_1V8 DFRRQHDLLX0
.ENDS

.SUBCKT dff_async_rst_186 data clk reset q VSS VDD_1V8
Xq_reg reset clk data q VSS VDD_1V8 DFRRQHDLLX0
.ENDS

.SUBCKT dff_async_rst_185 data clk reset q VSS VDD_1V8
Xq_reg reset clk data q VSS VDD_1V8 DFRRQHDLLX0
.ENDS

.SUBCKT dff_async_rst_184 data clk reset q VSS VDD_1V8
Xq_reg reset clk data q VSS VDD_1V8 DFRRQHDLLX0
.ENDS

.SUBCKT dff_async_rst_183 data clk reset q VSS VDD_1V8
Xq_reg reset clk data q VSS VDD_1V8 DFRRQHDLLX0
.ENDS

.SUBCKT dff_async_rst_182 data clk reset q VSS VDD_1V8
Xq_reg reset clk data q VSS VDD_1V8 DFRRQHDLLX0
.ENDS

.SUBCKT dff_async_rst_181 data clk reset q VSS VDD_1V8
Xq_reg reset clk data q VSS VDD_1V8 DFRRQHDLLX0
.ENDS

.SUBCKT dff_async_rst_180 data clk reset q VSS VDD_1V8
Xq_reg reset clk data q VSS VDD_1V8 DFRRQHDLLX0
.ENDS

.SUBCKT dff_async_rst_179 data clk reset q VSS VDD_1V8
Xq_reg reset clk data q VSS VDD_1V8 DFRRQHDLLX0
.ENDS

.SUBCKT dff_async_rst_178 data clk reset q VSS VDD_1V8
Xq_reg reset clk data q VSS VDD_1V8 DFRRQHDLLX0
.ENDS

.SUBCKT dff_async_rst_177 data clk reset q VSS VDD_1V8
Xq_reg reset clk data q VSS VDD_1V8 DFRRQHDLLX0
.ENDS

.SUBCKT dff_async_rst_176 data clk reset q VSS VDD_1V8
Xq_reg reset clk data q VSS VDD_1V8 DFRRQHDLLX0
.ENDS

.SUBCKT dff_async_rst_175 data clk reset q VSS VDD_1V8
Xq_reg reset clk data q VSS VDD_1V8 DFRRQHDLLX0
.ENDS

.SUBCKT dff_async_rst_174 data clk reset q VSS VDD_1V8
Xq_reg reset clk data q VSS VDD_1V8 DFRRQHDLLX0
.ENDS

.SUBCKT dff_async_rst_173 data clk reset q VSS VDD_1V8
Xq_reg reset clk data q VSS VDD_1V8 DFRRQHDLLX0
.ENDS

.SUBCKT dff_async_rst_172 data clk reset q VSS VDD_1V8
Xq_reg reset clk data q VSS VDD_1V8 DFRRQHDLLX0
.ENDS

.SUBCKT dff_async_rst_171 data clk reset q VSS VDD_1V8
Xq_reg reset clk data q VSS VDD_1V8 DFRRQHDLLX0
.ENDS

.SUBCKT dff_async_rst_170 data clk reset q VSS VDD_1V8
Xq_reg reset clk data q VSS VDD_1V8 DFRRQHDLLX0
.ENDS

.SUBCKT dff_async_rst_169 data clk reset q VSS VDD_1V8
Xq_reg reset clk data q VSS VDD_1V8 DFRRQHDLLX0
.ENDS

.SUBCKT dff_async_rst_168 data clk reset q VSS VDD_1V8
Xq_reg reset clk data q VSS VDD_1V8 DFRRQHDLLX0
.ENDS

.SUBCKT dff_async_rst_167 data clk reset q VSS VDD_1V8
Xq_reg reset clk data q VSS VDD_1V8 DFRRQHDLLX0
.ENDS

.SUBCKT dff_async_rst_166 data clk reset q VSS VDD_1V8
Xq_reg reset clk data q VSS VDD_1V8 DFRRQHDLLX0
.ENDS

.SUBCKT dff_async_rst_165 data clk reset q VSS VDD_1V8
Xq_reg reset clk data q VSS VDD_1V8 DFRRQHDLLX0
.ENDS

.SUBCKT dff_async_rst_164 data clk reset q VSS VDD_1V8
Xq_reg reset clk data q VSS VDD_1V8 DFRRQHDLLX0
.ENDS

.SUBCKT dff_async_rst_163 data clk reset q VSS VDD_1V8
Xq_reg reset clk data q VSS VDD_1V8 DFRRQHDLLX0
.ENDS

.SUBCKT dff_async_rst_162 data clk reset q VSS VDD_1V8
Xq_reg reset clk data q VSS VDD_1V8 DFRRQHDLLX0
.ENDS

.SUBCKT dff_async_rst_161 data clk reset q VSS VDD_1V8
Xq_reg reset clk data q VSS VDD_1V8 DFRRQHDLLX0
.ENDS

.SUBCKT dff_async_rst_160 data clk reset q VSS VDD_1V8
Xq_reg reset clk data q VSS VDD_1V8 DFRRQHDLLX0
.ENDS

.SUBCKT dff_async_rst_159 data clk reset q VSS VDD_1V8
Xq_reg reset clk data q VSS VDD_1V8 DFRRQHDLLX0
.ENDS

.SUBCKT dff_async_rst_158 data clk reset q VSS VDD_1V8
Xq_reg reset clk data q VSS VDD_1V8 DFRRQHDLLX0
.ENDS

.SUBCKT dff_async_rst_157 data clk reset q VSS VDD_1V8
Xq_reg reset clk data q VSS VDD_1V8 DFRRQHDLLX0
.ENDS

.SUBCKT dff_async_rst_156 data clk reset q VSS VDD_1V8
Xq_reg reset clk data q VSS VDD_1V8 DFRRQHDLLX0
.ENDS

.SUBCKT dff_async_rst_155 data clk reset q VSS VDD_1V8
Xq_reg reset clk data q VSS VDD_1V8 DFRRQHDLLX0
.ENDS

.SUBCKT dff_async_rst_154 data clk reset q VSS VDD_1V8
Xq_reg reset clk data q VSS VDD_1V8 DFRRQHDLLX0
.ENDS

.SUBCKT dff_async_rst_153 data clk reset q VSS VDD_1V8
Xq_reg reset clk data q VSS VDD_1V8 DFRRQHDLLX0
.ENDS

.SUBCKT dff_async_rst_152 data clk reset q VSS VDD_1V8
Xq_reg reset clk data q VSS VDD_1V8 DFRRQHDLLX0
.ENDS

.SUBCKT dff_async_rst_150 data clk reset q VSS VDD_1V8
Xq_reg reset clk data q VSS VDD_1V8 DFRRQHDLLX0
.ENDS

.SUBCKT dff_async_rst_149 data clk reset q VSS VDD_1V8
Xq_reg reset clk data q VSS VDD_1V8 DFRRQHDLLX0
.ENDS

.SUBCKT dff_async_rst_148 data clk reset q VSS VDD_1V8
Xq_reg reset clk data q VSS VDD_1V8 DFRRQHDLLX0
.ENDS

.SUBCKT dff_async_rst_147 data clk reset q VSS VDD_1V8
Xq_reg reset clk data q VSS VDD_1V8 DFRRQHDLLX0
.ENDS

.SUBCKT dff_async_rst_146 data clk reset q VSS VDD_1V8
Xq_reg reset clk data q VSS VDD_1V8 DFRRQHDLLX0
.ENDS

.SUBCKT dff_async_rst_145 data clk reset q VSS VDD_1V8
Xq_reg reset clk data q VSS VDD_1V8 DFRRQHDLLX0
.ENDS

.SUBCKT dff_async_rst_144 data clk reset q VSS VDD_1V8
Xq_reg reset clk data q VSS VDD_1V8 DFRRQHDLLX0
.ENDS

.SUBCKT dff_async_rst_143 data clk reset q VSS VDD_1V8
Xq_reg reset clk data q VSS VDD_1V8 DFRRQHDLLX0
.ENDS

.SUBCKT dff_async_rst_142 data clk reset q VSS VDD_1V8
Xq_reg reset clk data q VSS VDD_1V8 DFRRQHDLLX0
.ENDS

.SUBCKT dff_async_rst_141 data clk reset q VSS VDD_1V8
Xq_reg reset clk data q VSS VDD_1V8 DFRRQHDLLX0
.ENDS

.SUBCKT dff_async_rst_140 data clk reset q VSS VDD_1V8
Xq_reg reset clk data q VSS VDD_1V8 DFRRQHDLLX0
.ENDS

.SUBCKT dff_async_rst_139 data clk reset q VSS VDD_1V8
Xq_reg reset clk data q VSS VDD_1V8 DFRRQHDLLX0
.ENDS

.SUBCKT dff_async_rst_138 data clk reset q VSS VDD_1V8
Xq_reg reset clk data q VSS VDD_1V8 DFRRQHDLLX0
.ENDS

.SUBCKT dff_async_rst_137 data clk reset q VSS VDD_1V8
Xq_reg reset clk data q VSS VDD_1V8 DFRRQHDLLX0
.ENDS

.SUBCKT dff_async_rst_136 data clk reset q VSS VDD_1V8
Xq_reg reset clk data q VSS VDD_1V8 DFRRQHDLLX0
.ENDS

.SUBCKT dff_async_rst_135 data clk reset q VSS VDD_1V8
Xq_reg reset clk data q VSS VDD_1V8 DFRRQHDLLX0
.ENDS

.SUBCKT dff_async_rst_134 data clk reset q VSS VDD_1V8
Xq_reg reset clk data q VSS VDD_1V8 DFRRQHDLLX0
.ENDS

.SUBCKT dff_async_rst_133 data clk reset q VSS VDD_1V8
Xq_reg reset clk data q VSS VDD_1V8 DFRRQHDLLX0
.ENDS

.SUBCKT dff_async_rst_132 data clk reset q VSS VDD_1V8
Xq_reg reset clk data q VSS VDD_1V8 DFRRQHDLLX0
.ENDS

.SUBCKT dff_async_rst_131 data clk reset q VSS VDD_1V8
Xq_reg reset clk data q VSS VDD_1V8 DFRRQHDLLX0
.ENDS

.SUBCKT dff_async_rst_130 data clk reset q VSS VDD_1V8
Xq_reg reset clk data q VSS VDD_1V8 DFRRQHDLLX0
.ENDS

.SUBCKT dff_async_rst_129 data clk reset q VSS VDD_1V8
Xq_reg reset clk data q VSS VDD_1V8 DFRRQHDLLX0
.ENDS

.SUBCKT dff_async_rst_128 data clk reset q VSS VDD_1V8
Xq_reg reset clk data q VSS VDD_1V8 DFRRQHDLLX0
.ENDS

.SUBCKT dff_async_rst_127 data clk reset q VSS VDD_1V8
Xq_reg reset clk data q VSS VDD_1V8 DFRRQHDLLX0
.ENDS

.SUBCKT dff_async_rst_126 data clk reset q VSS VDD_1V8
Xq_reg reset clk data q VSS VDD_1V8 DFRRQHDLLX0
.ENDS

.SUBCKT dff_async_rst_125 data clk reset q VSS VDD_1V8
Xq_reg reset clk data q VSS VDD_1V8 DFRRQHDLLX0
.ENDS

.SUBCKT dff_async_rst_124 data clk reset q VSS VDD_1V8
Xq_reg reset clk data q VSS VDD_1V8 DFRRQHDLLX0
.ENDS

.SUBCKT dff_async_rst_123 data clk reset q VSS VDD_1V8
Xq_reg reset clk data q VSS VDD_1V8 DFRRQHDLLX0
.ENDS

.SUBCKT dff_async_rst_122 data clk reset q VSS VDD_1V8
Xq_reg reset clk data q VSS VDD_1V8 DFRRQHDLLX0
.ENDS

.SUBCKT dff_async_rst_121 data clk reset q VSS VDD_1V8
Xq_reg reset clk data q VSS VDD_1V8 DFRRQHDLLX0
.ENDS

.SUBCKT dff_async_rst_120 data clk reset q VSS VDD_1V8
Xq_reg reset clk data q VSS VDD_1V8 DFRRQHDLLX0
.ENDS

.SUBCKT dff_async_rst_119 data clk reset q VSS VDD_1V8
Xq_reg reset clk data q VSS VDD_1V8 DFRRQHDLLX0
.ENDS

.SUBCKT dff_async_rst_118 data clk reset q VSS VDD_1V8
Xq_reg reset clk data q VSS VDD_1V8 DFRRQHDLLX0
.ENDS

.SUBCKT dff_async_rst_117 data clk reset q VSS VDD_1V8
Xq_reg reset clk data q VSS VDD_1V8 DFRRQHDLLX0
.ENDS

.SUBCKT dff_async_rst_116 data clk reset q VSS VDD_1V8
Xq_reg reset clk data q VSS VDD_1V8 DFRRQHDLLX0
.ENDS

.SUBCKT dff_async_rst_115 data clk reset q VSS VDD_1V8
Xq_reg reset clk data q VSS VDD_1V8 DFRRQHDLLX0
.ENDS

.SUBCKT dff_async_rst_114 data clk reset q VSS VDD_1V8
Xq_reg reset clk data q VSS VDD_1V8 DFRRQHDLLX0
.ENDS

.SUBCKT dff_async_rst_113 data clk reset q VSS VDD_1V8
Xq_reg reset clk data q VSS VDD_1V8 DFRRQHDLLX0
.ENDS

.SUBCKT dff_async_rst_112 data clk reset q VSS VDD_1V8
Xq_reg reset clk data q VSS VDD_1V8 DFRRQHDLLX0
.ENDS

.SUBCKT dff_async_rst_111 data clk reset q VSS VDD_1V8
Xq_reg reset clk data q VSS VDD_1V8 DFRRQHDLLX0
.ENDS

.SUBCKT dff_async_rst_110 data clk reset q VSS VDD_1V8
Xq_reg reset clk data q VSS VDD_1V8 DFRRQHDLLX0
.ENDS

.SUBCKT dff_async_rst_109 data clk reset q VSS VDD_1V8
Xq_reg reset clk data q VSS VDD_1V8 DFRRQHDLLX0
.ENDS

.SUBCKT dff_async_rst_108 data clk reset q VSS VDD_1V8
Xq_reg reset clk data q VSS VDD_1V8 DFRRQHDLLX0
.ENDS

.SUBCKT dff_async_rst_107 data clk reset q VSS VDD_1V8
Xq_reg reset clk data q VSS VDD_1V8 DFRRQHDLLX0
.ENDS

.SUBCKT dff_async_rst_106 data clk reset q VSS VDD_1V8
Xq_reg reset clk data q VSS VDD_1V8 DFRRQHDLLX0
.ENDS

.SUBCKT dff_async_rst_105 data clk reset q VSS VDD_1V8
Xq_reg reset clk data q VSS VDD_1V8 DFRRQHDLLX0
.ENDS

.SUBCKT dff_async_rst_104 data clk reset q VSS VDD_1V8
Xq_reg reset clk data q VSS VDD_1V8 DFRRQHDLLX0
.ENDS

.SUBCKT dff_async_rst_103 data clk reset q VSS VDD_1V8
Xq_reg reset clk data q VSS VDD_1V8 DFRRQHDLLX0
.ENDS

.SUBCKT dff_async_rst_102 data clk reset q VSS VDD_1V8
Xq_reg reset clk data q VSS VDD_1V8 DFRRQHDLLX0
.ENDS

.SUBCKT dff_async_rst_101 data clk reset q VSS VDD_1V8
Xq_reg reset clk data q VSS VDD_1V8 DFRRQHDLLX0
.ENDS

.SUBCKT dff_async_rst_100 data clk reset q VSS VDD_1V8
Xq_reg reset clk data q VSS VDD_1V8 DFRRQHDLLX0
.ENDS

.SUBCKT dff_async_rst_99 data clk reset q VSS VDD_1V8
Xq_reg reset clk data q VSS VDD_1V8 DFRRQHDLLX0
.ENDS

.SUBCKT dff_async_rst_98 data clk reset q VSS VDD_1V8
Xq_reg reset clk data q VSS VDD_1V8 DFRRQHDLLX0
.ENDS

.SUBCKT dff_async_rst_97 data clk reset q VSS VDD_1V8
Xq_reg reset clk data q VSS VDD_1V8 DFRRQHDLLX0
.ENDS

.SUBCKT dff_async_rst_96 data clk reset q VSS VDD_1V8
Xq_reg reset clk data q VSS VDD_1V8 DFRRQHDLLX0
.ENDS

.SUBCKT dff_async_rst_95 data clk reset q VSS VDD_1V8
Xq_reg reset clk data q VSS VDD_1V8 DFRRQHDLLX0
.ENDS

.SUBCKT dff_async_rst_94 data clk reset q VSS VDD_1V8
Xq_reg reset clk data q VSS VDD_1V8 DFRRQHDLLX0
.ENDS

.SUBCKT dff_async_rst_93 data clk reset q VSS VDD_1V8
Xq_reg reset clk data q VSS VDD_1V8 DFRRQHDLLX0
.ENDS

.SUBCKT dff_async_rst_92 data clk reset q VSS VDD_1V8
Xq_reg reset clk data q VSS VDD_1V8 DFRRQHDLLX0
.ENDS

.SUBCKT dff_async_rst_91 data clk reset q VSS VDD_1V8
Xq_reg reset clk data q VSS VDD_1V8 DFRRQHDLLX0
.ENDS

.SUBCKT dff_async_rst_90 data clk reset q VSS VDD_1V8
Xq_reg reset clk data q VSS VDD_1V8 DFRRQHDLLX0
.ENDS

.SUBCKT dff_async_rst_89 data clk reset q VSS VDD_1V8
Xq_reg reset clk data q VSS VDD_1V8 DFRRQHDLLX0
.ENDS

.SUBCKT dff_async_rst_88 data clk reset q VSS VDD_1V8
Xq_reg reset clk data q VSS VDD_1V8 DFRRQHDLLX0
.ENDS

.SUBCKT dff_async_rst_87 data clk reset q VSS VDD_1V8
Xq_reg reset clk data q VSS VDD_1V8 DFRRQHDLLX0
.ENDS

.SUBCKT dff_async_rst_85 data clk reset q VSS VDD_1V8
Xq_reg reset clk data q VSS VDD_1V8 DFRRQHDLLX0
.ENDS

.SUBCKT dff_async_rst_84 data clk reset q VSS VDD_1V8
Xq_reg reset clk data q VSS VDD_1V8 DFRRQHDLLX0
.ENDS

.SUBCKT dff_async_rst_83 data clk reset q VSS VDD_1V8
Xq_reg reset clk data q VSS VDD_1V8 DFRRQHDLLX0
.ENDS

.SUBCKT dff_async_rst_82 data clk reset q VSS VDD_1V8
Xq_reg reset clk data q VSS VDD_1V8 DFRRQHDLLX0
.ENDS

.SUBCKT dff_async_rst_81 data clk reset q VSS VDD_1V8
Xq_reg reset clk data q VSS VDD_1V8 DFRRQHDLLX0
.ENDS

.SUBCKT dff_async_rst_80 data clk reset q VSS VDD_1V8
Xq_reg reset clk data q VSS VDD_1V8 DFRRQHDLLX0
.ENDS

.SUBCKT dff_async_rst_79 data clk reset q VSS VDD_1V8
Xq_reg reset clk data q VSS VDD_1V8 DFRRQHDLLX0
.ENDS

.SUBCKT dff_async_rst_78 data clk reset q VSS VDD_1V8
Xq_reg reset clk data q VSS VDD_1V8 DFRRQHDLLX0
.ENDS

.SUBCKT dff_async_rst_77 data clk reset q VSS VDD_1V8
Xq_reg reset clk data q VSS VDD_1V8 DFRRQHDLLX0
.ENDS

.SUBCKT dff_async_rst_76 data clk reset q VSS VDD_1V8
Xq_reg reset clk data q VSS VDD_1V8 DFRRQHDLLX0
.ENDS

.SUBCKT dff_async_rst_75 data clk reset q VSS VDD_1V8
Xq_reg reset clk data q VSS VDD_1V8 DFRRQHDLLX0
.ENDS

.SUBCKT dff_async_rst_74 data clk reset q VSS VDD_1V8
Xq_reg reset clk data q VSS VDD_1V8 DFRRQHDLLX0
.ENDS

.SUBCKT dff_async_rst_73 data clk reset q VSS VDD_1V8
Xq_reg reset clk data q VSS VDD_1V8 DFRRQHDLLX0
.ENDS

.SUBCKT dff_async_rst_72 data clk reset q VSS VDD_1V8
Xq_reg reset clk data q VSS VDD_1V8 DFRRQHDLLX0
.ENDS

.SUBCKT dff_async_rst_71 data clk reset q VSS VDD_1V8
Xq_reg reset clk data q VSS VDD_1V8 DFRRQHDLLX0
.ENDS

.SUBCKT dff_async_rst_70 data clk reset q VSS VDD_1V8
Xq_reg reset clk data q VSS VDD_1V8 DFRRQHDLLX0
.ENDS

.SUBCKT dff_async_rst_69 data clk reset q VSS VDD_1V8
Xq_reg reset clk data q VSS VDD_1V8 DFRRQHDLLX0
.ENDS

.SUBCKT dff_async_rst_68 data clk reset q VSS VDD_1V8
Xq_reg reset clk data q VSS VDD_1V8 DFRRQHDLLX0
.ENDS

.SUBCKT dff_async_rst_67 data clk reset q VSS VDD_1V8
Xq_reg reset clk data q VSS VDD_1V8 DFRRQHDLLX0
.ENDS

.SUBCKT dff_async_rst_66 data clk reset q VSS VDD_1V8
Xq_reg reset clk data q VSS VDD_1V8 DFRRQHDLLX0
.ENDS

.SUBCKT dff_async_rst_65 data clk reset q VSS VDD_1V8
Xq_reg reset clk data q VSS VDD_1V8 DFRRQHDLLX0
.ENDS

.SUBCKT dff_async_rst_64 data clk reset q VSS VDD_1V8
Xq_reg reset clk data q VSS VDD_1V8 DFRRQHDLLX0
.ENDS

.SUBCKT dff_async_rst_63 data clk reset q VSS VDD_1V8
Xq_reg reset clk data q VSS VDD_1V8 DFRRQHDLLX0
.ENDS

.SUBCKT dff_async_rst_62 data clk reset q VSS VDD_1V8
Xq_reg reset clk data q VSS VDD_1V8 DFRRQHDLLX0
.ENDS

.SUBCKT dff_async_rst_61 data clk reset q VSS VDD_1V8
Xq_reg reset clk data q VSS VDD_1V8 DFRRQHDLLX0
.ENDS

.SUBCKT dff_async_rst_60 data clk reset q VSS VDD_1V8
Xq_reg reset clk data q VSS VDD_1V8 DFRRQHDLLX0
.ENDS

.SUBCKT dff_async_rst_59 data clk reset q VSS VDD_1V8
Xq_reg reset clk data q VSS VDD_1V8 DFRRQHDLLX0
.ENDS

.SUBCKT dff_async_rst_58 data clk reset q VSS VDD_1V8
Xq_reg reset clk data q VSS VDD_1V8 DFRRQHDLLX0
.ENDS

.SUBCKT dff_async_rst_57 data clk reset q VSS VDD_1V8
Xq_reg reset clk data q VSS VDD_1V8 DFRRQHDLLX0
.ENDS

.SUBCKT dff_async_rst_56 data clk reset q VSS VDD_1V8
Xq_reg reset clk data q VSS VDD_1V8 DFRRQHDLLX0
.ENDS

.SUBCKT dff_async_rst_55 data clk reset q VSS VDD_1V8
Xq_reg reset clk data q VSS VDD_1V8 DFRRQHDLLX0
.ENDS

.SUBCKT dff_async_rst_54 data clk reset q VSS VDD_1V8
Xq_reg reset clk data q VSS VDD_1V8 DFRRQHDLLX0
.ENDS

.SUBCKT dff_async_rst_53 data clk reset q VSS VDD_1V8
Xq_reg reset clk data q VSS VDD_1V8 DFRRQHDLLX0
.ENDS

.SUBCKT dff_async_rst_52 data clk reset q VSS VDD_1V8
Xq_reg reset clk data q VSS VDD_1V8 DFRRQHDLLX0
.ENDS

.SUBCKT dff_async_rst_51 data clk reset q VSS VDD_1V8
Xq_reg reset clk data q VSS VDD_1V8 DFRRQHDLLX0
.ENDS

.SUBCKT dff_async_rst_50 data clk reset q VSS VDD_1V8
Xq_reg reset clk data q VSS VDD_1V8 DFRRQHDLLX0
.ENDS

.SUBCKT dff_async_rst_49 data clk reset q VSS VDD_1V8
Xq_reg reset clk data q VSS VDD_1V8 DFRRQHDLLX0
.ENDS

.SUBCKT dff_async_rst_48 data clk reset q VSS VDD_1V8
Xq_reg reset clk data q VSS VDD_1V8 DFRRQHDLLX0
.ENDS

.SUBCKT dff_async_rst_47 data clk reset q VSS VDD_1V8
Xq_reg reset clk data q VSS VDD_1V8 DFRRQHDLLX0
.ENDS

.SUBCKT dff_async_rst_46 data clk reset q VSS VDD_1V8
Xq_reg reset clk data q VSS VDD_1V8 DFRRQHDLLX0
.ENDS

.SUBCKT dff_async_rst_45 data clk reset q VSS VDD_1V8
Xq_reg reset clk data q VSS VDD_1V8 DFRRQHDLLX0
.ENDS

.SUBCKT dff_async_rst_44 data clk reset q VSS VDD_1V8
Xq_reg reset clk data q VSS VDD_1V8 DFRRQHDLLX0
.ENDS

.SUBCKT dff_async_rst_43 data clk reset q VSS VDD_1V8
Xq_reg reset clk data q VSS VDD_1V8 DFRRQHDLLX0
.ENDS

.SUBCKT dff_async_rst_42 data clk reset q VSS VDD_1V8
Xq_reg reset clk data q VSS VDD_1V8 DFRRQHDLLX0
.ENDS

.SUBCKT dff_async_rst_41 data clk reset q VSS VDD_1V8
Xq_reg reset clk data q VSS VDD_1V8 DFRRQHDLLX0
.ENDS

.SUBCKT dff_async_rst_40 data clk reset q VSS VDD_1V8
Xq_reg reset clk data q VSS VDD_1V8 DFRRQHDLLX0
.ENDS

.SUBCKT dff_async_rst_39 data clk reset q VSS VDD_1V8
Xq_reg reset clk data q VSS VDD_1V8 DFRRQHDLLX0
.ENDS

.SUBCKT dff_async_rst_38 data clk reset q VSS VDD_1V8
Xq_reg reset clk data q VSS VDD_1V8 DFRRQHDLLX0
.ENDS

.SUBCKT dff_async_rst_37 data clk reset q VSS VDD_1V8
Xq_reg reset clk data q VSS VDD_1V8 DFRRQHDLLX0
.ENDS

.SUBCKT dff_async_rst_36 data clk reset q VSS VDD_1V8
Xq_reg reset clk data q VSS VDD_1V8 DFRRQHDLLX0
.ENDS

.SUBCKT dff_async_rst_35 data clk reset q VSS VDD_1V8
Xq_reg reset clk data q VSS VDD_1V8 DFRRQHDLLX0
.ENDS

.SUBCKT dff_async_rst_34 data clk reset q VSS VDD_1V8
Xq_reg reset clk data q VSS VDD_1V8 DFRRQHDLLX0
.ENDS

.SUBCKT dff_async_rst_33 data clk reset q VSS VDD_1V8
Xq_reg reset clk data q VSS VDD_1V8 DFRRQHDLLX0
.ENDS

.SUBCKT dff_async_rst_32 data clk reset q VSS VDD_1V8
Xq_reg reset clk data q VSS VDD_1V8 DFRRQHDLLX0
.ENDS

.SUBCKT dff_async_rst_31 data clk reset q VSS VDD_1V8
Xq_reg reset clk data q VSS VDD_1V8 DFRRQHDLLX0
.ENDS

.SUBCKT dff_async_rst_30 data clk reset q VSS VDD_1V8
Xq_reg reset clk data q VSS VDD_1V8 DFRRQHDLLX0
.ENDS

.SUBCKT dff_async_rst_29 data clk reset q VSS VDD_1V8
Xq_reg reset clk data q VSS VDD_1V8 DFRRQHDLLX0
.ENDS

.SUBCKT dff_async_rst_28 data clk reset q VSS VDD_1V8
Xq_reg reset clk data q VSS VDD_1V8 DFRRQHDLLX0
.ENDS

.SUBCKT dff_async_rst_27 data clk reset q VSS VDD_1V8
Xq_reg reset clk data q VSS VDD_1V8 DFRRQHDLLX0
.ENDS

.SUBCKT dff_async_rst_26 data clk reset q VSS VDD_1V8
Xq_reg reset clk data q VSS VDD_1V8 DFRRQHDLLX0
.ENDS

.SUBCKT dff_async_rst_25 data clk reset q VSS VDD_1V8
Xq_reg reset clk data q VSS VDD_1V8 DFRRQHDLLX0
.ENDS

.SUBCKT dff_async_rst_24 data clk reset q VSS VDD_1V8
Xq_reg reset clk data q VSS VDD_1V8 DFRRQHDLLX0
.ENDS

.SUBCKT dff_async_rst_23 data clk reset q VSS VDD_1V8
Xq_reg reset clk data q VSS VDD_1V8 DFRRQHDLLX0
.ENDS

.SUBCKT dff_async_rst_22 data clk reset q VSS VDD_1V8
Xq_reg reset clk data q VSS VDD_1V8 DFRRQHDLLX0
.ENDS

.SUBCKT Timer clock reset_BAR count[31] count[30] count[29] count[28] count[27] count[26]
+ count[25] count[24] count[23] count[22] count[21] count[20] count[19] count[18]
+ count[17] count[16] count[15] count[14] count[13] count[12] count[11] count[10]
+ count[9] count[8] count[7] count[6] count[5] count[4] count[3] count[2] count[1]
+ count[0] VSS VDD_1V8
XINHDLLX4_G4B1I1 VSS VDD_1V8 clk_timer_G4B2I1 clk_timer_G4B1I1 INHDLLX4
XINHDLLX2_G4B2I1 clk_timer_G4B1I1 VSS VDD_1V8 clock INHDLLX2
XU47 n1 VSS n45 n2 VDD_1V8 N31 AN21HDLLX0
XU46 VSS n45 n1 n2 VDD_1V8 NO2HDLLX0
XU45 n1 VSS VDD_1V8 count[30] INHDLLX0
XU44 VSS n3 count[29] VDD_1V8 n2 NA2HDLLX0
XU43 VSS n3 n4 n5 VDD_1V8 NO2HDLLX0
XU42 VSS n6 count[27] VDD_1V8 n5 NA2HDLLX0
XU41 VSS n6 n7 n8 VDD_1V8 NO2HDLLX0
XU40 VSS n9 count[25] VDD_1V8 n8 NA2HDLLX0
XU39 VSS n9 n10 n11 VDD_1V8 NO2HDLLX0
XU38 VSS n12 count[23] VDD_1V8 n11 NA2HDLLX0
XU37 VSS n12 n13 n14 VDD_1V8 NO2HDLLX0
XU36 VSS n15 count[21] VDD_1V8 n14 NA2HDLLX0
XU35 VSS n15 n16 n17 VDD_1V8 NO2HDLLX0
XU34 VSS n18 count[19] VDD_1V8 n17 NA2HDLLX0
XU33 VSS n18 n19 n20 VDD_1V8 NO2HDLLX0
XU32 VSS n21 count[17] VDD_1V8 n20 NA2HDLLX0
XU31 VSS n21 n22 n23 VDD_1V8 NO2HDLLX0
XU30 VSS n24 count[15] VDD_1V8 n23 NA2HDLLX0
XU29 VSS n24 n25 n26 VDD_1V8 NO2HDLLX0
XU28 VSS n27 count[13] VDD_1V8 n26 NA2HDLLX0
XU27 VSS n27 n28 n29 VDD_1V8 NO2HDLLX0
XU26 VSS n30 count[11] VDD_1V8 n29 NA2HDLLX0
XU25 VSS n30 n31 n32 VDD_1V8 NO2HDLLX0
XU24 VSS n33 count[9] VDD_1V8 n32 NA2HDLLX0
XU23 VSS n33 n34 n35 VDD_1V8 NO2HDLLX0
XU22 VSS n36 count[7] VDD_1V8 n35 NA2HDLLX0
XU21 VSS n36 n37 n38 VDD_1V8 NO2HDLLX0
XU20 VSS n39 count[5] VDD_1V8 n38 NA2HDLLX0
XU19 VSS n39 n40 n41 VDD_1V8 NO2HDLLX0
XU18 VSS n42 count[3] VDD_1V8 n41 NA2HDLLX0
XU17 n43 count[0] VSS VDD_1V8 n42 count[1] NO3I2HDLLX0
XU16 n43 VSS VDD_1V8 count[2] INHDLLX0
XU15 n40 VSS VDD_1V8 count[4] INHDLLX0
XU14 n37 VSS VDD_1V8 count[6] INHDLLX0
XU13 n34 VSS VDD_1V8 count[8] INHDLLX0
XU12 n31 VSS VDD_1V8 count[10] INHDLLX0
XU11 n28 VSS VDD_1V8 count[12] INHDLLX0
XU10 n25 VSS VDD_1V8 count[14] INHDLLX0
XU9 n22 VSS VDD_1V8 count[16] INHDLLX0
XU8 n19 VSS VDD_1V8 count[18] INHDLLX0
XU7 n16 VSS VDD_1V8 count[20] INHDLLX0
XU6 n13 VSS VDD_1V8 count[22] INHDLLX0
XU5 n10 VSS VDD_1V8 count[24] INHDLLX0
XU4 n7 VSS VDD_1V8 count[26] INHDLLX0
XU3 n4 VSS VDD_1V8 count[28] INHDLLX0
Xcount_reg_0_ reset_BAR clk_timer_G4B2I1 N1 count[0] VSS VDD_1V8 DFRRQHDLLX0
Xcount_reg_1_ reset_BAR clk_timer_G4B2I1 N2 count[1] VSS VDD_1V8 DFRRQHDLLX0
Xcount_reg_2_ reset_BAR clk_timer_G4B2I1 N3 count[2] VSS VDD_1V8 DFRRQHDLLX0
Xcount_reg_3_ reset_BAR clk_timer_G4B2I1 N4 count[3] VSS VDD_1V8 DFRRQHDLLX0
Xcount_reg_4_ reset_BAR clk_timer_G4B2I1 N5 count[4] VSS VDD_1V8 DFRRQHDLLX0
Xcount_reg_5_ reset_BAR clk_timer_G4B2I1 N6 count[5] VSS VDD_1V8 DFRRQHDLLX0
Xcount_reg_6_ reset_BAR clk_timer_G4B2I1 N7 count[6] VSS VDD_1V8 DFRRQHDLLX0
Xcount_reg_7_ reset_BAR clk_timer_G4B2I1 N8 count[7] VSS VDD_1V8 DFRRQHDLLX0
Xcount_reg_8_ reset_BAR clk_timer_G4B2I1 N9 count[8] VSS VDD_1V8 DFRRQHDLLX0
Xcount_reg_9_ reset_BAR clk_timer_G4B2I1 N10 count[9] VSS VDD_1V8 DFRRQHDLLX0
Xcount_reg_10_ reset_BAR clk_timer_G4B2I1 N11 count[10] VSS VDD_1V8 DFRRQHDLLX0
Xcount_reg_11_ reset_BAR clk_timer_G4B2I1 N12 count[11] VSS VDD_1V8 DFRRQHDLLX0
Xcount_reg_12_ reset_BAR clk_timer_G4B2I1 N13 count[12] VSS VDD_1V8 DFRRQHDLLX0
Xcount_reg_13_ reset_BAR clk_timer_G4B2I1 N14 count[13] VSS VDD_1V8 DFRRQHDLLX0
Xcount_reg_14_ reset_BAR clk_timer_G4B2I1 N15 count[14] VSS VDD_1V8 DFRRQHDLLX0
Xcount_reg_15_ reset_BAR clk_timer_G4B2I1 N16 count[15] VSS VDD_1V8 DFRRQHDLLX0
Xcount_reg_16_ reset_BAR clk_timer_G4B2I1 N17 count[16] VSS VDD_1V8 DFRRQHDLLX0
Xcount_reg_17_ reset_BAR clk_timer_G4B2I1 N18 count[17] VSS VDD_1V8 DFRRQHDLLX0
Xcount_reg_18_ reset_BAR clk_timer_G4B2I1 N19 count[18] VSS VDD_1V8 DFRRQHDLLX0
Xcount_reg_19_ reset_BAR clk_timer_G4B2I1 N20 count[19] VSS VDD_1V8 DFRRQHDLLX0
Xcount_reg_20_ reset_BAR clk_timer_G4B2I1 N21 count[20] VSS VDD_1V8 DFRRQHDLLX0
Xcount_reg_21_ reset_BAR clk_timer_G4B2I1 N22 count[21] VSS VDD_1V8 DFRRQHDLLX0
Xcount_reg_22_ reset_BAR clk_timer_G4B2I1 N23 count[22] VSS VDD_1V8 DFRRQHDLLX0
Xcount_reg_23_ reset_BAR clk_timer_G4B2I1 N24 count[23] VSS VDD_1V8 DFRRQHDLLX0
Xcount_reg_24_ reset_BAR clk_timer_G4B2I1 N25 count[24] VSS VDD_1V8 DFRRQHDLLX0
Xcount_reg_25_ reset_BAR clk_timer_G4B2I1 N26 count[25] VSS VDD_1V8 DFRRQHDLLX0
Xcount_reg_26_ reset_BAR clk_timer_G4B2I1 N27 count[26] VSS VDD_1V8 DFRRQHDLLX0
Xcount_reg_27_ reset_BAR clk_timer_G4B2I1 N28 count[27] VSS VDD_1V8 DFRRQHDLLX0
Xcount_reg_28_ reset_BAR clk_timer_G4B2I1 N29 count[28] VSS VDD_1V8 DFRRQHDLLX0
Xcount_reg_29_ reset_BAR clk_timer_G4B2I1 N30 count[29] VSS VDD_1V8 DFRRQHDLLX0
Xcount_reg_30_ reset_BAR clk_timer_G4B2I1 N31 count[30] VSS VDD_1V8 DFRRQHDLLX0
Xcount_reg_31_ reset_BAR clk_timer_G4B2I1 N32 count[31] VSS VDD_1V8 DFRRQHDLLX0
XU79 VSS VDD_1V8 N32 count[31] n45 EO2HDLLX0
XU78 VSS VDD_1V8 N2 N1 count[1] count[0] MU2IHDLLX0
XU77 N1 VSS VDD_1V8 count[0] INHDLLX0
XU76 n43 VSS n42 n44 VDD_1V8 N3 AN21HDLLX0
XU75 VSS count[0] count[1] VDD_1V8 n44 NA2HDLLX0
XU74 n42 VDD_1V8 count[3] VSS n41 N4 OA21HDLLX0
XU73 n40 VSS n39 n41 VDD_1V8 N5 AN21HDLLX0
XU72 n39 VDD_1V8 count[5] VSS n38 N6 OA21HDLLX0
XU71 n37 VSS n36 n38 VDD_1V8 N7 AN21HDLLX0
XU70 n36 VDD_1V8 count[7] VSS n35 N8 OA21HDLLX0
XU69 n34 VSS n33 n35 VDD_1V8 N9 AN21HDLLX0
XU68 n33 VDD_1V8 count[9] VSS n32 N10 OA21HDLLX0
XU67 n31 VSS n30 n32 VDD_1V8 N11 AN21HDLLX0
XU66 n30 VDD_1V8 count[11] VSS n29 N12 OA21HDLLX0
XU65 n28 VSS n27 n29 VDD_1V8 N13 AN21HDLLX0
XU64 n27 VDD_1V8 count[13] VSS n26 N14 OA21HDLLX0
XU63 n25 VSS n24 n26 VDD_1V8 N15 AN21HDLLX0
XU62 n24 VDD_1V8 count[15] VSS n23 N16 OA21HDLLX0
XU61 n22 VSS n21 n23 VDD_1V8 N17 AN21HDLLX0
XU60 n21 VDD_1V8 count[17] VSS n20 N18 OA21HDLLX0
XU59 n19 VSS n18 n20 VDD_1V8 N19 AN21HDLLX0
XU58 n18 VDD_1V8 count[19] VSS n17 N20 OA21HDLLX0
XU57 n16 VSS n15 n17 VDD_1V8 N21 AN21HDLLX0
XU56 n15 VDD_1V8 count[21] VSS n14 N22 OA21HDLLX0
XU55 n13 VSS n12 n14 VDD_1V8 N23 AN21HDLLX0
XU54 n12 VDD_1V8 count[23] VSS n11 N24 OA21HDLLX0
XU53 n10 VSS n9 n11 VDD_1V8 N25 AN21HDLLX0
XU52 n9 VDD_1V8 count[25] VSS n8 N26 OA21HDLLX0
XU51 n7 VSS n6 n8 VDD_1V8 N27 AN21HDLLX0
XU50 n6 VDD_1V8 count[27] VSS n5 N28 OA21HDLLX0
XU49 n4 VSS n3 n5 VDD_1V8 N29 AN21HDLLX0
XU48 n3 VDD_1V8 count[29] VSS n2 N30 OA21HDLLX0
.ENDS

.SUBCKT dff_async_rst_1363 data clk reset q VSS VDD_1V8
Xq_reg reset clk data q VSS VDD_1V8 DFRRQHDLLX0
.ENDS

.SUBCKT dff_async_rst_1362 data clk reset q VSS VDD_1V8
Xq_reg reset clk data q VSS VDD_1V8 DFRRQHDLLX0
.ENDS

.SUBCKT dff_async_rst_1361 data clk reset q VSS VDD_1V8
Xq_reg reset clk data q VSS VDD_1V8 DFRRQHDLLX0
.ENDS

.SUBCKT dff_async_rst_1360 data clk reset q VSS VDD_1V8
Xq_reg reset clk data q VSS VDD_1V8 DFRRQHDLLX0
.ENDS

.SUBCKT dff_async_rst_1359 data clk reset q VSS VDD_1V8
Xq_reg reset clk data q VSS VDD_1V8 DFRRQHDLLX0
.ENDS

.SUBCKT dff_async_rst_1358 data clk reset q VSS VDD_1V8
Xq_reg reset clk data q VSS VDD_1V8 DFRRQHDLLX0
.ENDS

.SUBCKT dff_async_rst_1357 data clk reset q VSS VDD_1V8
Xq_reg reset clk data q VSS VDD_1V8 DFRRQHDLLX0
.ENDS

.SUBCKT dff_async_rst_1356 data clk reset q VSS VDD_1V8
Xq_reg reset clk data q VSS VDD_1V8 DFRRQHDLLX0
.ENDS

.SUBCKT dff_async_rst_1355 data clk reset q VSS VDD_1V8
Xq_reg reset clk data q VSS VDD_1V8 DFRRQHDLLX0
.ENDS

.SUBCKT dff_async_rst_1354 data clk reset q VSS VDD_1V8
Xq_reg reset clk data q VSS VDD_1V8 DFRRQHDLLX0
.ENDS

.SUBCKT dff_async_rst_1353 data clk reset q VSS VDD_1V8
Xq_reg reset clk data q VSS VDD_1V8 DFRRQHDLLX0
.ENDS

.SUBCKT dff_async_rst_1352 data clk reset q VSS VDD_1V8
Xq_reg reset clk data q VSS VDD_1V8 DFRRQHDLLX0
.ENDS

.SUBCKT dff_async_rst_1351 data clk reset q VSS VDD_1V8
Xq_reg reset clk data q VSS VDD_1V8 DFRRQHDLLX0
.ENDS

.SUBCKT dff_async_rst_1350 data clk reset q VSS VDD_1V8
Xq_reg reset clk data q VSS VDD_1V8 DFRRQHDLLX0
.ENDS

.SUBCKT dff_async_rst_1349 data clk reset q VSS VDD_1V8
Xq_reg reset clk data q VSS VDD_1V8 DFRRQHDLLX0
.ENDS

.SUBCKT dff_async_rst_1348 data clk reset q VSS VDD_1V8
Xq_reg reset clk data q VSS VDD_1V8 DFRRQHDLLX0
.ENDS

.SUBCKT dff_async_rst_1347 data clk reset q VSS VDD_1V8
Xq_reg reset clk data q VSS VDD_1V8 DFRRQHDLLX0
.ENDS

.SUBCKT dff_async_rst_1346 data clk reset q VSS VDD_1V8
Xq_reg reset clk data q VSS VDD_1V8 DFRRQHDLLX0
.ENDS

.SUBCKT dff_async_rst_1345 data clk reset q VSS VDD_1V8
Xq_reg reset clk data q VSS VDD_1V8 DFRRQHDLLX0
.ENDS

.SUBCKT dff_async_rst_1344 data clk reset q VSS VDD_1V8
Xq_reg reset clk data q VSS VDD_1V8 DFRRQHDLLX0
.ENDS

.SUBCKT dff_async_rst_1343 data clk reset q VSS VDD_1V8
Xq_reg reset clk data q VSS VDD_1V8 DFRRQHDLLX0
.ENDS

.SUBCKT dff_async_rst_1342 data clk reset q VSS VDD_1V8
Xq_reg reset clk data q VSS VDD_1V8 DFRRQHDLLX0
.ENDS

.SUBCKT dff_async_rst_1341 data clk reset q VSS VDD_1V8
Xq_reg reset clk data q VSS VDD_1V8 DFRRQHDLLX0
.ENDS

.SUBCKT dff_async_rst_1340 data clk reset q VSS VDD_1V8
Xq_reg reset clk data q VSS VDD_1V8 DFRRQHDLLX0
.ENDS

.SUBCKT dff_async_rst_1339 data clk reset q VSS VDD_1V8
Xq_reg reset clk data q VSS VDD_1V8 DFRRQHDLLX0
.ENDS

.SUBCKT dff_async_rst_1338 data clk reset q VSS VDD_1V8
Xq_reg reset clk data q VSS VDD_1V8 DFRRQHDLLX0
.ENDS

.SUBCKT dff_async_rst_1337 data clk reset q VSS VDD_1V8
Xq_reg reset clk data q VSS VDD_1V8 DFRRQHDLLX0
.ENDS

.SUBCKT dff_async_rst_1336 data clk reset q VSS VDD_1V8
Xq_reg reset clk data q VSS VDD_1V8 DFRRQHDLLX0
.ENDS

.SUBCKT dff_async_rst_1335 data clk reset q VSS VDD_1V8
Xq_reg reset clk data q VSS VDD_1V8 DFRRQHDLLX0
.ENDS

.SUBCKT dff_async_rst_1334 data clk reset q VSS VDD_1V8
Xq_reg reset clk data q VSS VDD_1V8 DFRRQHDLLX0
.ENDS

.SUBCKT dff_async_rst_1333 data clk reset q VSS VDD_1V8
Xq_reg reset clk data q VSS VDD_1V8 DFRRQHDLLX0
.ENDS

.SUBCKT dff_async_rst_1332 data clk reset q VSS VDD_1V8
Xq_reg reset clk data q VSS VDD_1V8 DFRRQHDLLX0
.ENDS

.SUBCKT DH_top_riscv_soc_PD_CORE cts_0 cts_0_2 VSS VDD_1V8
XBUHDLLX2_G2B3I1 VSS VDD_1V8 cts_0_2 clk_G2B3I1 BUHDLLX8
XBUHDLLX1_G2B5I1 clk_G2B3I1 VSS VDD_1V8 clk_G2B2I1 BUHDLLX3
XBUHDLLX1_G2B7I1 clk_G2B2I1 VSS VDD_1V8 cts_0 BUHDLLX2
.ENDS

.SUBCKT pad_ring clk_pad clk reset_pad reset MISO_pad MISO RX_UART_pad RX_UART maip_pad
+ maip MOSI_pad MOSI SCLK_pad SCLK SCS_pad SCS TX_UART_pad TX_UART gpio_pad[7] gpio_pad[6]
+ gpio_pad[5] gpio_pad[4] gpio_pad[3] gpio_pad[2] gpio_pad[1] gpio_pad[0] Reg_GPIO_en[7]
+ Reg_GPIO_en[6] Reg_GPIO_en[5] Reg_GPIO_en[4] Reg_GPIO_en[3] Reg_GPIO_en[2] Reg_GPIO_en[1]
+ Reg_GPIO_en[0] Reg_GPIO_int[7] Reg_GPIO_int[6] Reg_GPIO_int[5] Reg_GPIO_int[4]
+ Reg_GPIO_int[3] Reg_GPIO_int[2] Reg_GPIO_int[1] Reg_GPIO_int[0] Reg_GPIO_out[7]
+ Reg_GPIO_out[6] Reg_GPIO_out[5] Reg_GPIO_out[4] Reg_GPIO_out[3] Reg_GPIO_out[2]
+ Reg_GPIO_out[1] Reg_GPIO_out[0] VDD_1V8_PADS VDD_3V3_PADS VSS
Xpad_bit_7__inout_pad_inst gpio_pad[7] VSS SYNOPSYS_UNCONNECTED_46 Reg_GPIO_int[7]
+ Reg_GPIO_out[7] Reg_GPIO_en[7] VDD_3V3_PADS VDD_1V8_PADS VSS VDD_3V3_PADS VSS BBC2SF
Xpad_bit_6__inout_pad_inst gpio_pad[6] VSS SYNOPSYS_UNCONNECTED_47 Reg_GPIO_int[6]
+ Reg_GPIO_out[6] Reg_GPIO_en[6] VDD_3V3_PADS VDD_1V8_PADS VSS VDD_3V3_PADS VSS BBC2SF
Xpad_bit_5__inout_pad_inst gpio_pad[5] VSS SYNOPSYS_UNCONNECTED_48 Reg_GPIO_int[5]
+ Reg_GPIO_out[5] Reg_GPIO_en[5] VDD_3V3_PADS VDD_1V8_PADS VSS VDD_3V3_PADS VSS BBC2SF
Xpad_bit_4__inout_pad_inst gpio_pad[4] VSS SYNOPSYS_UNCONNECTED_49 Reg_GPIO_int[4]
+ Reg_GPIO_out[4] Reg_GPIO_en[4] VDD_3V3_PADS VDD_1V8_PADS VSS VDD_3V3_PADS VSS BBC2SF
Xpad_bit_3__inout_pad_inst gpio_pad[3] VSS SYNOPSYS_UNCONNECTED_50 Reg_GPIO_int[3]
+ Reg_GPIO_out[3] Reg_GPIO_en[3] VDD_3V3_PADS VDD_1V8_PADS VSS VDD_3V3_PADS VSS BBC2SF
Xpad_bit_2__inout_pad_inst gpio_pad[2] VSS SYNOPSYS_UNCONNECTED_51 Reg_GPIO_int[2]
+ Reg_GPIO_out[2] Reg_GPIO_en[2] VDD_3V3_PADS VDD_1V8_PADS VSS VDD_3V3_PADS VSS BBC2SF
Xpad_bit_1__inout_pad_inst gpio_pad[1] VSS SYNOPSYS_UNCONNECTED_52 Reg_GPIO_int[1]
+ Reg_GPIO_out[1] Reg_GPIO_en[1] VDD_3V3_PADS VDD_1V8_PADS VSS VDD_3V3_PADS VSS BBC2SF
Xpad_bit_0__inout_pad_inst gpio_pad[0] VSS SYNOPSYS_UNCONNECTED_53 Reg_GPIO_int[0]
+ Reg_GPIO_out[0] Reg_GPIO_en[0] VDD_3V3_PADS VDD_1V8_PADS VSS VDD_3V3_PADS VSS BBC2SF
XTX_UART_pad_inst TX_UART_pad TX_UART VSS VDD_3V3_PADS VDD_1V8_PADS VSS VSS VDD_3V3_PADS BT2SF
XSCS_pad_inst SCS_pad SCS VSS VDD_3V3_PADS VDD_1V8_PADS VSS VSS VDD_3V3_PADS BT2SF
XSCLK_pad_inst SCLK_pad SCLK VSS VDD_3V3_PADS VDD_1V8_PADS VSS VSS VDD_3V3_PADS BT2SF
XMOSI_pad_inst MOSI_pad MOSI VSS VDD_3V3_PADS VDD_1V8_PADS VSS VSS VDD_3V3_PADS BT2SF
Xmaip_pad_inst maip_pad SYNOPSYS_UNCONNECTED_54 maip VSS VDD_3V3_PADS VSS VDD_3V3_PADS
+ VSS VDD_1V8_PADS ICF
XRX_UART_pad_inst RX_UART_pad SYNOPSYS_UNCONNECTED_55 RX_UART VSS VDD_3V3_PADS VSS
+ VDD_3V3_PADS VSS VDD_1V8_PADS ICF
XMISO_pad_inst MISO_pad SYNOPSYS_UNCONNECTED_56 MISO VSS VDD_3V3_PADS VSS VDD_3V3_PADS
+ VSS VDD_1V8_PADS ICF
Xreset_pad_inst reset_pad SYNOPSYS_UNCONNECTED_57 reset VSS VDD_3V3_PADS VSS VDD_3V3_PADS
+ VSS VDD_1V8_PADS ICF
Xclk_pad_inst clk_pad SYNOPSYS_UNCONNECTED_58 clk VSS VDD_3V3_PADS VSS VDD_3V3_PADS
+ VSS VDD_1V8_PADS ICF
.ENDS

.SUBCKT prll_d_rega_bits8_7 clk reset D_in[7] D_in[6] D_in[5] D_in[4] D_in[3] D_in[2]
+ D_in[1] D_in[0] D_out[7] D_out[6] D_out[5] D_out[4] D_out[3] D_out[2] D_out[1]
+ D_out[0] VSS VDD_1V8 IN0 IN1 IN2 IN3 IN4 IN5 IN6
Xbit__7__prll_regstr_ D_in[7] clk IN5 D_out[7] VSS VDD_1V8 dff_async_rsta_56
Xbit__6__prll_regstr_ D_in[6] clk IN0 D_out[6] VSS VDD_1V8 dff_async_rsta_57
Xbit__5__prll_regstr_ D_in[5] clk IN6 D_out[5] VSS VDD_1V8 dff_async_rsta_58
Xbit__4__prll_regstr_ D_in[4] clk IN3 D_out[4] VSS VDD_1V8 dff_async_rsta_59
Xbit__3__prll_regstr_ D_in[3] clk IN2 D_out[3] VSS VDD_1V8 dff_async_rsta_60
Xbit__2__prll_regstr_ D_in[2] clk IN4 D_out[2] VSS VDD_1V8 dff_async_rsta_61
Xbit__1__prll_regstr_ D_in[1] clk IN1 D_out[1] VSS VDD_1V8 dff_async_rsta_62
Xbit__0__prll_regstr_ D_in[0] clk reset D_out[0] VSS VDD_1V8 dff_async_rsta_63
.ENDS

.SUBCKT prll_d_rega_bits8_6 clk reset D_in[7] D_in[6] D_in[5] D_in[4] D_in[3] D_in[2]
+ D_in[1] D_in[0] D_out[7] D_out[6] D_out[5] D_out[4] D_out[3] D_out[2] D_out[1]
+ D_out[0] VSS VDD_1V8
Xbit__7__prll_regstr_ D_in[7] clk reset D_out[7] VSS VDD_1V8 dff_async_rsta_48
Xbit__6__prll_regstr_ D_in[6] clk reset D_out[6] VSS VDD_1V8 dff_async_rsta_49
Xbit__5__prll_regstr_ D_in[5] clk reset D_out[5] VSS VDD_1V8 dff_async_rsta_50
Xbit__4__prll_regstr_ D_in[4] clk reset D_out[4] VSS VDD_1V8 dff_async_rsta_51
Xbit__3__prll_regstr_ D_in[3] clk reset D_out[3] VSS VDD_1V8 dff_async_rsta_52
Xbit__2__prll_regstr_ D_in[2] clk reset D_out[2] VSS VDD_1V8 dff_async_rsta_53
Xbit__1__prll_regstr_ D_in[1] clk reset D_out[1] VSS VDD_1V8 dff_async_rsta_54
Xbit__0__prll_regstr_ D_in[0] clk reset D_out[0] VSS VDD_1V8 dff_async_rsta_55
.ENDS

.SUBCKT prll_d_rega_bits8_5 clk reset D_in[7] D_in[6] D_in[5] D_in[4] D_in[3] D_in[2]
+ D_in[1] D_in[0] D_out[7] D_out[6] D_out[5] D_out[4] D_out[3] D_out[2] D_out[1]
+ D_out[0] VSS VDD_1V8
Xbit__7__prll_regstr_ D_in[7] clk reset D_out[7] VSS VDD_1V8 dff_async_rsta_40
Xbit__6__prll_regstr_ D_in[6] clk reset D_out[6] VSS VDD_1V8 dff_async_rsta_41
Xbit__5__prll_regstr_ D_in[5] clk reset D_out[5] VSS VDD_1V8 dff_async_rsta_42
Xbit__4__prll_regstr_ D_in[4] clk reset D_out[4] VSS VDD_1V8 dff_async_rsta_43
Xbit__3__prll_regstr_ D_in[3] clk reset D_out[3] VSS VDD_1V8 dff_async_rsta_44
Xbit__2__prll_regstr_ D_in[2] clk reset D_out[2] VSS VDD_1V8 dff_async_rsta_45
Xbit__1__prll_regstr_ D_in[1] clk reset D_out[1] VSS VDD_1V8 dff_async_rsta_46
Xbit__0__prll_regstr_ D_in[0] clk reset D_out[0] VSS VDD_1V8 dff_async_rsta_47
.ENDS

.SUBCKT prll_d_rega_bits8_4 clk reset D_in[7] D_in[6] D_in[5] D_in[4] D_in[3] D_in[2]
+ D_in[1] D_in[0] D_out[7] D_out[6] D_out[5] D_out[4] D_out[3] D_out[2] D_out[1]
+ D_out[0] VSS VDD_1V8
Xbit__7__prll_regstr_ D_in[7] clk reset D_out[7] VSS VDD_1V8 dff_async_rsta_32
Xbit__6__prll_regstr_ D_in[6] clk reset D_out[6] VSS VDD_1V8 dff_async_rsta_33
Xbit__5__prll_regstr_ D_in[5] clk reset D_out[5] VSS VDD_1V8 dff_async_rsta_34
Xbit__4__prll_regstr_ D_in[4] clk reset D_out[4] VSS VDD_1V8 dff_async_rsta_35
Xbit__3__prll_regstr_ D_in[3] clk reset D_out[3] VSS VDD_1V8 dff_async_rsta_36
Xbit__2__prll_regstr_ D_in[2] clk reset D_out[2] VSS VDD_1V8 dff_async_rsta_37
Xbit__1__prll_regstr_ D_in[1] clk reset D_out[1] VSS VDD_1V8 dff_async_rsta_38
Xbit__0__prll_regstr_ D_in[0] clk reset D_out[0] VSS VDD_1V8 dff_async_rsta_39
.ENDS

.SUBCKT prll_d_rega_bits8_3 clk reset D_in[7] D_in[6] D_in[5] D_in[4] D_in[3] D_in[2]
+ D_in[1] D_in[0] D_out[7] D_out[6] D_out[5] D_out[4] D_out[3] D_out[2] D_out[1]
+ D_out[0] VSS VDD_1V8 IN0
Xbit__7__prll_regstr_ D_in[7] clk reset D_out[7] VSS VDD_1V8 dff_async_rsta_24
Xbit__6__prll_regstr_ D_in[6] clk reset D_out[6] VSS VDD_1V8 dff_async_rsta_25
Xbit__5__prll_regstr_ D_in[5] clk reset D_out[5] VSS VDD_1V8 dff_async_rsta_26
Xbit__4__prll_regstr_ D_in[4] clk reset D_out[4] VSS VDD_1V8 dff_async_rsta_27
Xbit__3__prll_regstr_ D_in[3] clk reset D_out[3] VSS VDD_1V8 dff_async_rsta_28
Xbit__2__prll_regstr_ D_in[2] clk reset D_out[2] VSS VDD_1V8 dff_async_rsta_29
Xbit__1__prll_regstr_ D_in[1] IN0 reset D_out[1] VSS VDD_1V8 dff_async_rsta_30
Xbit__0__prll_regstr_ D_in[0] clk reset D_out[0] VSS VDD_1V8 dff_async_rsta_31
.ENDS

.SUBCKT prll_d_rega_bits8_2 clk reset D_in[7] D_in[6] D_in[5] D_in[4] D_in[3] D_in[2]
+ D_in[1] D_in[0] D_out[7] D_out[6] D_out[5] D_out[4] D_out[3] D_out[2] D_out[1]
+ D_out[0] VSS VDD_1V8
Xbit__7__prll_regstr_ D_in[7] clk reset D_out[7] VSS VDD_1V8 dff_async_rsta_16
Xbit__6__prll_regstr_ D_in[6] clk reset D_out[6] VSS VDD_1V8 dff_async_rsta_17
Xbit__5__prll_regstr_ D_in[5] clk reset D_out[5] VSS VDD_1V8 dff_async_rsta_18
Xbit__4__prll_regstr_ D_in[4] clk reset D_out[4] VSS VDD_1V8 dff_async_rsta_19
Xbit__3__prll_regstr_ D_in[3] clk reset D_out[3] VSS VDD_1V8 dff_async_rsta_20
Xbit__2__prll_regstr_ D_in[2] clk reset D_out[2] VSS VDD_1V8 dff_async_rsta_21
Xbit__1__prll_regstr_ D_in[1] clk reset D_out[1] VSS VDD_1V8 dff_async_rsta_22
Xbit__0__prll_regstr_ D_in[0] clk reset D_out[0] VSS VDD_1V8 dff_async_rsta_23
.ENDS

.SUBCKT prll_d_rega_bits8_1 clk reset D_in[7] D_in[6] D_in[5] D_in[4] D_in[3] D_in[2]
+ D_in[1] D_in[0] D_out[7] D_out[6] D_out[5] D_out[4] D_out[3] D_out[2] D_out[1]
+ D_out[0] VSS VDD_1V8
Xbit__7__prll_regstr_ D_in[7] clk reset D_out[7] VSS VDD_1V8 dff_async_rsta_8
Xbit__6__prll_regstr_ D_in[6] clk reset D_out[6] VSS VDD_1V8 dff_async_rsta_9
Xbit__5__prll_regstr_ D_in[5] clk reset D_out[5] VSS VDD_1V8 dff_async_rsta_10
Xbit__4__prll_regstr_ D_in[4] clk reset D_out[4] VSS VDD_1V8 dff_async_rsta_11
Xbit__3__prll_regstr_ D_in[3] clk reset D_out[3] VSS VDD_1V8 dff_async_rsta_12
Xbit__2__prll_regstr_ D_in[2] clk reset D_out[2] VSS VDD_1V8 dff_async_rsta_13
Xbit__1__prll_regstr_ D_in[1] clk reset D_out[1] VSS VDD_1V8 dff_async_rsta_14
Xbit__0__prll_regstr_ D_in[0] clk reset D_out[0] VSS VDD_1V8 dff_async_rsta_15
.ENDS

.SUBCKT prll_d_rega_bits8_0 clk reset D_in[7] D_in[6] D_in[5] D_in[4] D_in[3] D_in[2]
+ D_in[1] D_in[0] D_out[7] D_out[6] D_out[5] D_out[4] D_out[3] D_out[2] D_out[1]
+ D_out[0] VSS VDD_1V8 IN0 IN1 IN2 IN3 IN4
Xbit__7__prll_regstr_ D_in[7] clk reset D_out[7] VSS VDD_1V8 dff_async_rsta_0
Xbit__6__prll_regstr_ D_in[6] IN2 IN4 D_out[6] VSS VDD_1V8 dff_async_rsta_1
Xbit__5__prll_regstr_ D_in[5] IN0 IN3 D_out[5] VSS VDD_1V8 dff_async_rsta_2
Xbit__4__prll_regstr_ D_in[4] IN1 reset D_out[4] VSS VDD_1V8 dff_async_rsta_3
Xbit__3__prll_regstr_ D_in[3] clk reset D_out[3] VSS VDD_1V8 dff_async_rsta_4
Xbit__2__prll_regstr_ D_in[2] clk reset D_out[2] VSS VDD_1V8 dff_async_rsta_5
Xbit__1__prll_regstr_ D_in[1] clk reset D_out[1] VSS VDD_1V8 dff_async_rsta_6
Xbit__0__prll_regstr_ D_in[0] clk reset D_out[0] VSS VDD_1V8 dff_async_rsta_7
.ENDS

.SUBCKT prll_d_reg_ena_bits8_7 clk reset enable D_in[7] D_in[6] D_in[5] D_in[4] D_in[3]
+ D_in[2] D_in[1] D_in[0] D_out[7] D_out[6] D_out[5] D_out[4] D_out[3] D_out[2]
+ D_out[1] D_out[0] VSS VDD_1V8
Xbit__7__prll_regstr_ D_in[7] clk enable reset D_out[7] VSS VDD_1V8 dff_async_rst_ena_56
Xbit__6__prll_regstr_ D_in[6] clk enable reset D_out[6] VSS VDD_1V8 dff_async_rst_ena_57
Xbit__5__prll_regstr_ D_in[5] clk enable reset D_out[5] VSS VDD_1V8 dff_async_rst_ena_58
Xbit__4__prll_regstr_ D_in[4] clk enable reset D_out[4] VSS VDD_1V8 dff_async_rst_ena_59
Xbit__3__prll_regstr_ D_in[3] clk enable reset D_out[3] VSS VDD_1V8 dff_async_rst_ena_60
Xbit__2__prll_regstr_ D_in[2] clk enable reset D_out[2] VSS VDD_1V8 dff_async_rst_ena_61
Xbit__1__prll_regstr_ D_in[1] clk enable reset D_out[1] VSS VDD_1V8 dff_async_rst_ena_62
Xbit__0__prll_regstr_ D_in[0] clk enable reset D_out[0] VSS VDD_1V8 dff_async_rst_ena_63
.ENDS

.SUBCKT prll_d_reg_ena_bits8_6 clk reset enable D_in[7] D_in[6] D_in[5] D_in[4] D_in[3]
+ D_in[2] D_in[1] D_in[0] D_out[7] D_out[6] D_out[5] D_out[4] D_out[3] D_out[2]
+ D_out[1] D_out[0] VSS VDD_1V8
Xbit__7__prll_regstr_ D_in[7] clk enable reset D_out[7] VSS VDD_1V8 dff_async_rst_ena_48
Xbit__6__prll_regstr_ D_in[6] clk enable reset D_out[6] VSS VDD_1V8 dff_async_rst_ena_49
Xbit__5__prll_regstr_ D_in[5] clk enable reset D_out[5] VSS VDD_1V8 dff_async_rst_ena_50
Xbit__4__prll_regstr_ D_in[4] clk enable reset D_out[4] VSS VDD_1V8 dff_async_rst_ena_51
Xbit__3__prll_regstr_ D_in[3] clk enable reset D_out[3] VSS VDD_1V8 dff_async_rst_ena_52
Xbit__2__prll_regstr_ D_in[2] clk enable reset D_out[2] VSS VDD_1V8 dff_async_rst_ena_53
Xbit__1__prll_regstr_ D_in[1] clk enable reset D_out[1] VSS VDD_1V8 dff_async_rst_ena_54
Xbit__0__prll_regstr_ D_in[0] clk enable reset D_out[0] VSS VDD_1V8 dff_async_rst_ena_55
.ENDS

.SUBCKT prll_d_reg_ena_bits8_5 clk reset enable D_in[7] D_in[6] D_in[5] D_in[4] D_in[3]
+ D_in[2] D_in[1] D_in[0] D_out[7] D_out[6] D_out[5] D_out[4] D_out[3] D_out[2]
+ D_out[1] D_out[0] VSS VDD_1V8
Xbit__7__prll_regstr_ D_in[7] clk enable reset D_out[7] VSS VDD_1V8 dff_async_rst_ena_40
Xbit__6__prll_regstr_ D_in[6] clk enable reset D_out[6] VSS VDD_1V8 dff_async_rst_ena_41
Xbit__5__prll_regstr_ D_in[5] clk enable reset D_out[5] VSS VDD_1V8 dff_async_rst_ena_42
Xbit__4__prll_regstr_ D_in[4] clk enable reset D_out[4] VSS VDD_1V8 dff_async_rst_ena_43
Xbit__3__prll_regstr_ D_in[3] clk enable reset D_out[3] VSS VDD_1V8 dff_async_rst_ena_44
Xbit__2__prll_regstr_ D_in[2] clk enable reset D_out[2] VSS VDD_1V8 dff_async_rst_ena_45
Xbit__1__prll_regstr_ D_in[1] clk enable reset D_out[1] VSS VDD_1V8 dff_async_rst_ena_46
Xbit__0__prll_regstr_ D_in[0] clk enable reset D_out[0] VSS VDD_1V8 dff_async_rst_ena_47
.ENDS

.SUBCKT prll_d_reg_ena_bits8_4 clk reset enable D_in[7] D_in[6] D_in[5] D_in[4] D_in[3]
+ D_in[2] D_in[1] D_in[0] D_out[7] D_out[6] D_out[5] D_out[4] D_out[3] D_out[2]
+ D_out[1] D_out[0] VSS VDD_1V8
Xbit__7__prll_regstr_ D_in[7] clk enable reset D_out[7] VSS VDD_1V8 dff_async_rst_ena_32
Xbit__6__prll_regstr_ D_in[6] clk enable reset D_out[6] VSS VDD_1V8 dff_async_rst_ena_33
Xbit__5__prll_regstr_ D_in[5] clk enable reset D_out[5] VSS VDD_1V8 dff_async_rst_ena_34
Xbit__4__prll_regstr_ D_in[4] clk enable reset D_out[4] VSS VDD_1V8 dff_async_rst_ena_35
Xbit__3__prll_regstr_ D_in[3] clk enable reset D_out[3] VSS VDD_1V8 dff_async_rst_ena_36
Xbit__2__prll_regstr_ D_in[2] clk enable reset D_out[2] VSS VDD_1V8 dff_async_rst_ena_37
Xbit__1__prll_regstr_ D_in[1] clk enable reset D_out[1] VSS VDD_1V8 dff_async_rst_ena_38
Xbit__0__prll_regstr_ D_in[0] clk enable reset D_out[0] VSS VDD_1V8 dff_async_rst_ena_39
.ENDS

.SUBCKT prll_d_reg_ena_bits8_3 clk reset enable D_in[7] D_in[6] D_in[5] D_in[4] D_in[3]
+ D_in[2] D_in[1] D_in[0] D_out[7] D_out[6] D_out[5] D_out[4] D_out[3] D_out[2]
+ D_out[1] D_out[0] VSS VDD_1V8
Xbit__7__prll_regstr_ D_in[7] clk enable reset D_out[7] VSS VDD_1V8 dff_async_rst_ena_24
Xbit__6__prll_regstr_ D_in[6] clk enable reset D_out[6] VSS VDD_1V8 dff_async_rst_ena_25
Xbit__5__prll_regstr_ D_in[5] clk enable reset D_out[5] VSS VDD_1V8 dff_async_rst_ena_26
Xbit__4__prll_regstr_ D_in[4] clk enable reset D_out[4] VSS VDD_1V8 dff_async_rst_ena_27
Xbit__3__prll_regstr_ D_in[3] clk enable reset D_out[3] VSS VDD_1V8 dff_async_rst_ena_28
Xbit__2__prll_regstr_ D_in[2] clk enable reset D_out[2] VSS VDD_1V8 dff_async_rst_ena_29
Xbit__1__prll_regstr_ D_in[1] clk enable reset D_out[1] VSS VDD_1V8 dff_async_rst_ena_30
Xbit__0__prll_regstr_ D_in[0] clk enable reset D_out[0] VSS VDD_1V8 dff_async_rst_ena_31
.ENDS

.SUBCKT prll_d_reg_ena_bits8_2 clk reset enable D_in[7] D_in[6] D_in[5] D_in[4] D_in[3]
+ D_in[2] D_in[1] D_in[0] D_out[7] D_out[6] D_out[5] D_out[4] D_out[3] D_out[2]
+ D_out[1] D_out[0] VSS VDD_1V8
Xbit__7__prll_regstr_ D_in[7] clk enable reset D_out[7] VSS VDD_1V8 dff_async_rst_ena_16
Xbit__6__prll_regstr_ D_in[6] clk enable reset D_out[6] VSS VDD_1V8 dff_async_rst_ena_17
Xbit__5__prll_regstr_ D_in[5] clk enable reset D_out[5] VSS VDD_1V8 dff_async_rst_ena_18
Xbit__4__prll_regstr_ D_in[4] clk enable reset D_out[4] VSS VDD_1V8 dff_async_rst_ena_19
Xbit__3__prll_regstr_ D_in[3] clk enable reset D_out[3] VSS VDD_1V8 dff_async_rst_ena_20
Xbit__2__prll_regstr_ D_in[2] clk enable reset D_out[2] VSS VDD_1V8 dff_async_rst_ena_21
Xbit__1__prll_regstr_ D_in[1] clk enable reset D_out[1] VSS VDD_1V8 dff_async_rst_ena_22
Xbit__0__prll_regstr_ D_in[0] clk enable reset D_out[0] VSS VDD_1V8 dff_async_rst_ena_23
.ENDS

.SUBCKT prll_d_reg_ena_bits8_1 clk reset enable D_in[7] D_in[6] D_in[5] D_in[4] D_in[3]
+ D_in[2] D_in[1] D_in[0] D_out[7] D_out[6] D_out[5] D_out[4] D_out[3] D_out[2]
+ D_out[1] D_out[0] VSS VDD_1V8
Xbit__7__prll_regstr_ D_in[7] clk enable reset D_out[7] VSS VDD_1V8 dff_async_rst_ena_8
Xbit__6__prll_regstr_ D_in[6] clk enable reset D_out[6] VSS VDD_1V8 dff_async_rst_ena_9
Xbit__5__prll_regstr_ D_in[5] clk enable reset D_out[5] VSS VDD_1V8 dff_async_rst_ena_10
Xbit__4__prll_regstr_ D_in[4] clk enable reset D_out[4] VSS VDD_1V8 dff_async_rst_ena_11
Xbit__3__prll_regstr_ D_in[3] clk enable reset D_out[3] VSS VDD_1V8 dff_async_rst_ena_12
Xbit__2__prll_regstr_ D_in[2] clk enable reset D_out[2] VSS VDD_1V8 dff_async_rst_ena_13
Xbit__1__prll_regstr_ D_in[1] clk enable reset D_out[1] VSS VDD_1V8 dff_async_rst_ena_14
Xbit__0__prll_regstr_ D_in[0] clk enable reset D_out[0] VSS VDD_1V8 dff_async_rst_ena_15
.ENDS

.SUBCKT prll_d_reg_ena_bits8_0 clk reset enable D_in[7] D_in[6] D_in[5] D_in[4] D_in[3]
+ D_in[2] D_in[1] D_in[0] D_out[7] D_out[6] D_out[5] D_out[4] D_out[3] D_out[2]
+ D_out[1] D_out[0] VSS VDD_1V8 IN0 IN1 IN2 IN3 IN4 IN5 IN6
Xbit__7__prll_regstr_ D_in[7] clk enable IN4 D_out[7] VSS VDD_1V8 dff_async_rst_ena_0
Xbit__6__prll_regstr_ D_in[6] clk enable reset D_out[6] VSS VDD_1V8 dff_async_rst_ena_1
Xbit__5__prll_regstr_ D_in[5] clk enable IN6 D_out[5] VSS VDD_1V8 dff_async_rst_ena_2
Xbit__4__prll_regstr_ D_in[4] clk enable IN1 D_out[4] VSS VDD_1V8 dff_async_rst_ena_3
Xbit__3__prll_regstr_ D_in[3] clk enable IN5 D_out[3] VSS VDD_1V8 dff_async_rst_ena_4
Xbit__2__prll_regstr_ D_in[2] clk enable IN0 D_out[2] VSS VDD_1V8 dff_async_rst_ena_5
Xbit__1__prll_regstr_ D_in[1] clk enable IN2 D_out[1] VSS VDD_1V8 dff_async_rst_ena_6
Xbit__0__prll_regstr_ D_in[0] clk enable IN3 D_out[0] VSS VDD_1V8 dff_async_rst_ena_7
.ENDS

.SUBCKT top_spi CLK reset pndgn D_pop[64] D_pop[63] D_pop[62] D_pop[61] D_pop[60]
+ D_pop[59] D_pop[58] D_pop[57] D_pop[56] D_pop[55] D_pop[54] D_pop[53] D_pop[52]
+ D_pop[51] D_pop[50] D_pop[49] D_pop[48] D_pop[47] D_pop[46] D_pop[45] D_pop[44]
+ D_pop[43] D_pop[42] D_pop[41] D_pop[40] D_pop[39] D_pop[38] D_pop[37] D_pop[36]
+ D_pop[35] D_pop[34] D_pop[33] D_pop[32] D_pop[31] D_pop[30] D_pop[29] D_pop[28]
+ D_pop[27] D_pop[26] D_pop[25] D_pop[24] D_pop[23] D_pop[22] D_pop[21] D_pop[20]
+ D_pop[19] D_pop[18] D_pop[17] D_pop[16] D_pop[15] D_pop[14] D_pop[13] D_pop[12]
+ D_pop[11] D_pop[10] D_pop[9] D_pop[8] D_pop[7] D_pop[6] D_pop[5] D_pop[4] D_pop[3]
+ D_pop[2] D_pop[1] D_pop[0] MISO pop D_push[64] D_push[63] D_push[62] D_push[61]
+ D_push[60] D_push[59] D_push[58] D_push[57] D_push[56] D_push[55] D_push[54] D_push[53]
+ D_push[52] D_push[51] D_push[50] D_push[49] D_push[48] D_push[47] D_push[46] D_push[45]
+ D_push[44] D_push[43] D_push[42] D_push[41] D_push[40] D_push[39] D_push[38] D_push[37]
+ D_push[36] D_push[35] D_push[34] D_push[33] D_push[32] D_push[31] D_push[30] D_push[29]
+ D_push[28] D_push[27] D_push[26] D_push[25] D_push[24] D_push[23] D_push[22] D_push[21]
+ D_push[20] D_push[19] D_push[18] D_push[17] D_push[16] D_push[15] D_push[14] D_push[13]
+ D_push[12] D_push[11] D_push[10] D_push[9] D_push[8] D_push[7] D_push[6] D_push[5]
+ D_push[4] D_push[3] D_push[2] D_push[1] D_push[0] push MOSI SCLK SCS VSS VDD_1V8
Xspi1 CTS_2_G3B4I5 n240 MISO VSS tspi_data_config[14] tspi_data_config[13] tspi_data_config[12]
+ tspi_data_config[11] VSS VSS VSS VSS VSS VSS VSS VSS VSS VSS tspi_data_config[0]
+ tspi_config_en VSS VSS tspi_data_tx[61] VSS VSS tspi_data_tx[58] tspi_data_tx[57]
+ tspi_data_tx[56] tspi_data_tx[55] tspi_data_tx[54] tspi_data_tx[53] tspi_data_tx[52]
+ tspi_data_tx[51] tspi_data_tx[50] tspi_data_tx[49] tspi_data_tx[48] tspi_data_tx[47]
+ tspi_data_tx[46] tspi_data_tx[45] tspi_data_tx[44] tspi_data_tx[43] tspi_data_tx[42]
+ tspi_data_tx[41] tspi_data_tx[40] tspi_data_tx[39] tspi_data_tx[38] tspi_data_tx[37]
+ tspi_data_tx[36] tspi_data_tx[35] tspi_data_tx[34] tspi_data_tx[33] tspi_data_tx[32]
+ tspi_data_tx[31] tspi_data_tx[30] tspi_data_tx[29] tspi_data_tx[28] tspi_data_tx[27]
+ tspi_data_tx[26] tspi_data_tx[25] tspi_data_tx[24] tspi_data_tx[23] tspi_data_tx[22]
+ tspi_data_tx[21] tspi_data_tx[20] tspi_data_tx[19] tspi_data_tx[18] tspi_data_tx[17]
+ tspi_data_tx[16] tspi_data_tx[15] tspi_data_tx[14] tspi_data_tx[13] tspi_data_tx[12]
+ tspi_data_tx[11] tspi_data_tx[10] tspi_data_tx[9] tspi_data_tx[8] tspi_data_tx[7]
+ tspi_data_tx[6] tspi_data_tx[5] tspi_data_tx[4] tspi_data_tx[3] tspi_data_tx[2]
+ tspi_data_tx[1] tspi_data_tx[0] tspi_send_data data_read[31] data_read[30] data_read[29]
+ data_read[28] data_read[27] data_read[26] data_read[25] data_read[24] data_read[23]
+ data_read[22] data_read[21] data_read[20] data_read[19] data_read[18] data_read[17]
+ data_read[16] data_read[15] data_read[14] data_read[13] data_read[12] data_read[11]
+ data_read[10] data_read[9] data_read[8] data_read[7] data_read[6] data_read[5]
+ data_read[4] data_read[3] data_read[2] data_read[1] data_read[0] MOSI SCS SCLK
+ end_send VSS VDD_1V8 MOSI n244 n196 n168 n164 n95 n66 n1 CTS_2_G3B4I6 CTS_2_G3B4I4
+ CTS_2_G3B4I2 CTS_2_G3B4I1 spi
XU49 VSS n120 n109 VDD_1V8 n647 NA2HDLLX0
XU244 n105 VSS VDD_1V8 n90 n89 n91 NO3HDLLX1
XU74 VSS n247 n10 n112 VDD_1V8 NO2HDLLX1
Xdata_pop_reg_9_ n195 CTS_2_G3B4I7 n548 data_pop[9] VSS VDD_1V8 DFRRQHDLLX0
Xdata_pop_reg_8_ n195 CTS_2_G3B4I7 n549 data_pop[8] VSS VDD_1V8 DFRRQHDLLX0
Xdata_pop_reg_7_ n237 CTS_2_G3B4I3 n550 data_pop[7] VSS VDD_1V8 DFRRQHDLLX0
Xdata_pop_reg_6_ n195 CTS_2_G3B4I7 n551 data_pop[6] VSS VDD_1V8 DFRRQHDLLX0
Xdata_pop_reg_5_ n237 CTS_2_G3B4I7 n552 data_pop[5] VSS VDD_1V8 DFRRQHDLLX0
Xdata_pop_reg_4_ n195 CTS_2_G3B4I7 n553 data_pop[4] VSS VDD_1V8 DFRRQHDLLX0
Xdata_pop_reg_3_ n237 CTS_2_G3B4I7 n554 data_pop[3] VSS VDD_1V8 DFRRQHDLLX0
Xdata_pop_reg_2_ n195 CTS_2_G3B4I7 n555 data_pop[2] VSS VDD_1V8 DFRRQHDLLX0
Xdata_pop_reg_1_ n195 CTS_2_G3B4I7 n556 data_pop[1] VSS VDD_1V8 DFRRQHDLLX0
Xdata_pop_reg_0_ n195 CTS_2_G3B4I7 n557 data_pop[0] VSS VDD_1V8 DFRRQHDLLX0
Xstate_reg_1_ n185 CTS_2_G3B4I3 n644 state_1_ VSS VDD_1V8 DFRRQHDLLX0
Xt_word_reg_0_ n196 CTS_2_G3B4I1 n431 t_word[0] VSS VDD_1V8 DFRRQHDLLX0
Xt_word_reg_31_ n196 CTS_2_G3B4I1 n400 t_word[31] VSS VDD_1V8 DFRRQHDLLX0
Xtspi_data_tx_reg_24_ n188 CTS_2_G3B4I2 n608 tspi_data_tx[24] VSS VDD_1V8 DFRRQHDLLX0
Xdata_reg_0_ n188 CTS_2_G3B4I2 n646 data[0] VSS VDD_1V8 DFRRQHDLLX0
Xtspi_data_tx_reg_25_ n188 CTS_2_G3B4I2 n609 tspi_data_tx[25] VSS VDD_1V8 DFRRQHDLLX0
Xtspi_data_tx_reg_26_ n188 CTS_2_G3B4I2 n610 tspi_data_tx[26] VSS VDD_1V8 DFRRQHDLLX0
Xtspi_data_tx_reg_27_ n188 CTS_2_G3B4I2 n611 tspi_data_tx[27] VSS VDD_1V8 DFRRQHDLLX0
Xtspi_data_tx_reg_28_ n188 CTS_2_G3B4I2 n612 tspi_data_tx[28] VSS VDD_1V8 DFRRQHDLLX0
Xtspi_data_tx_reg_29_ n188 CTS_2_G3B4I2 n613 tspi_data_tx[29] VSS VDD_1V8 DFRRQHDLLX0
Xtspi_data_tx_reg_30_ n188 CTS_2_G3B4I2 n614 tspi_data_tx[30] VSS VDD_1V8 DFRRQHDLLX0
Xtspi_data_tx_reg_31_ n95 CTS_2_G3B4I2 n615 tspi_data_tx[31] VSS VDD_1V8 DFRRQHDLLX0
Xindex_reg_2_ n185 CTS_2_G3B4I3 n442 index[2] VSS VDD_1V8 DFRRQHDLLX0
Xindex_reg_0_ n185 CTS_2_G3B4I3 n444 index[0] VSS VDD_1V8 DFRRQHDLLX0
Xdata_reg_31_ n195 CTS_2_G3B4I7 n445 data[31] VSS VDD_1V8 DFRRQHDLLX0
Xdata_reg_30_ n188 CTS_2_G3B4I2 n446 data[30] VSS VDD_1V8 DFRRQHDLLX0
Xdata_reg_29_ n195 CTS_2_G3B4I7 n447 data[29] VSS VDD_1V8 DFRRQHDLLX0
Xdata_reg_28_ n188 CTS_2_G3B4I2 n448 data[28] VSS VDD_1V8 DFRRQHDLLX0
Xdata_reg_27_ n188 CTS_2_G3B4I7 n449 data[27] VSS VDD_1V8 DFRRQHDLLX0
Xdata_reg_26_ n188 CTS_2_G3B4I7 n450 data[26] VSS VDD_1V8 DFRRQHDLLX0
Xdata_reg_25_ n195 CTS_2_G3B4I7 n451 data[25] VSS VDD_1V8 DFRRQHDLLX0
Xdata_reg_24_ n188 CTS_2_G3B4I7 n452 data[24] VSS VDD_1V8 DFRRQHDLLX0
Xdata_reg_23_ n188 CTS_2_G3B4I7 n453 data[23] VSS VDD_1V8 DFRRQHDLLX0
Xdata_reg_22_ n188 CTS_2_G3B4I2 n454 data[22] VSS VDD_1V8 DFRRQHDLLX0
Xdata_reg_21_ n195 CTS_2_G3B4I7 n455 data[21] VSS VDD_1V8 DFRRQHDLLX0
Xdata_reg_20_ n188 CTS_2_G3B4I2 n456 data[20] VSS VDD_1V8 DFRRQHDLLX0
Xdata_reg_19_ n188 CTS_2_G3B4I2 n457 data[19] VSS VDD_1V8 DFRRQHDLLX0
Xdata_reg_18_ n188 CTS_2_G3B4I2 n458 data[18] VSS VDD_1V8 DFRRQHDLLX0
Xdata_reg_17_ n188 CTS_2_G3B4I2 n459 data[17] VSS VDD_1V8 DFRRQHDLLX0
Xdata_reg_16_ n195 CTS_2_G3B4I7 n460 data[16] VSS VDD_1V8 DFRRQHDLLX0
Xdata_reg_15_ n188 CTS_2_G3B4I2 n461 data[15] VSS VDD_1V8 DFRRQHDLLX0
Xdata_reg_14_ n188 CTS_2_G3B4I2 n462 data[14] VSS VDD_1V8 DFRRQHDLLX0
Xdata_reg_13_ n188 CTS_2_G3B4I2 n463 data[13] VSS VDD_1V8 DFRRQHDLLX0
Xdata_reg_12_ n188 CTS_2_G3B4I2 n464 data[12] VSS VDD_1V8 DFRRQHDLLX0
Xdata_reg_11_ n188 CTS_2_G3B4I2 n465 data[11] VSS VDD_1V8 DFRRQHDLLX0
Xdata_reg_10_ n195 CTS_2_G3B4I7 n466 data[10] VSS VDD_1V8 DFRRQHDLLX0
Xdata_reg_9_ n188 CTS_2_G3B4I2 n467 data[9] VSS VDD_1V8 DFRRQHDLLX0
Xdata_reg_8_ n188 CTS_2_G3B4I2 n468 data[8] VSS VDD_1V8 DFRRQHDLLX0
Xdata_reg_7_ n237 CTS_2_G3B4I3 n469 data[7] VSS VDD_1V8 DFRRQHDLLX0
Xdata_reg_6_ n237 CTS_2_G3B4I7 n470 data[6] VSS VDD_1V8 DFRRQHDLLX0
Xdata_reg_5_ n237 CTS_2_G3B4I7 n471 data[5] VSS VDD_1V8 DFRRQHDLLX0
Xdata_reg_4_ n195 CTS_2_G3B4I7 n472 data[4] VSS VDD_1V8 DFRRQHDLLX0
Xdata_reg_3_ n237 CTS_2_G3B4I3 n473 data[3] VSS VDD_1V8 DFRRQHDLLX0
Xdata_reg_2_ n188 CTS_2_G3B4I2 n474 data[2] VSS VDD_1V8 DFRRQHDLLX0
Xdata_reg_1_ n195 CTS_2_G3B4I7 n475 data[1] VSS VDD_1V8 DFRRQHDLLX0
Xtspi_data_tx_reg_56_ n66 CTS_2_G3B4I2 n596 tspi_data_tx[56] VSS VDD_1V8 DFRRQHDLLX0
Xtspi_data_tx_reg_61_ n95 CTS_2_G3B4I3 n599 tspi_data_tx[61] VSS VDD_1V8 DFRRQHDLLX0
Xdata_pop_reg_64_ n195 CTS_2_G3B4I7 n439 data_pop_64 VSS VDD_1V8 DFRRQHDLLX0
Xdata_pop_reg_63_ n195 CTS_2_G3B4I7 n440 data_pop_63 VSS VDD_1V8 DFRRQHDLLX0
Xdata_pop_reg_62_ n195 CTS_2_G3B4I7 n441 data_pop_62 VSS VDD_1V8 DFRRQHDLLX0
Xdata_pop_reg_59_ n237 CTS_2_G3B4I3 n476 data_pop_59 VSS VDD_1V8 DFRRQHDLLX0
Xdata_pop_reg_58_ n237 CTS_2_G3B4I3 n477 data_pop_58 VSS VDD_1V8 DFRRQHDLLX0
Xdata_pop_reg_57_ n237 CTS_2_G3B4I3 n478 data_pop_57 VSS VDD_1V8 DFRRQHDLLX0
Xdata_pop_reg_54_ n195 CTS_2_G3B4I7 n503 data_pop[54] VSS VDD_1V8 DFRRQHDLLX0
Xdata_pop_reg_53_ n237 CTS_2_G3B4I3 n504 data_pop[53] VSS VDD_1V8 DFRRQHDLLX0
Xdata_pop_reg_52_ n195 CTS_2_G3B4I7 n505 data_pop[52] VSS VDD_1V8 DFRRQHDLLX0
Xdata_pop_reg_51_ n195 CTS_2_G3B4I7 n506 data_pop[51] VSS VDD_1V8 DFRRQHDLLX0
Xdata_pop_reg_50_ n237 CTS_2_G3B4I7 n507 data_pop[50] VSS VDD_1V8 DFRRQHDLLX0
Xdata_pop_reg_49_ n237 CTS_2_G3B4I7 n508 data_pop[49] VSS VDD_1V8 DFRRQHDLLX0
Xdata_pop_reg_48_ n237 CTS_2_G3B4I3 n509 data_pop[48] VSS VDD_1V8 DFRRQHDLLX0
Xdata_pop_reg_47_ n237 CTS_2_G3B4I3 n510 data_pop[47] VSS VDD_1V8 DFRRQHDLLX0
Xdata_pop_reg_46_ n195 CTS_2_G3B4I7 n511 data_pop[46] VSS VDD_1V8 DFRRQHDLLX0
Xdata_pop_reg_45_ n237 CTS_2_G3B4I3 n512 data_pop[45] VSS VDD_1V8 DFRRQHDLLX0
Xdata_pop_reg_44_ n237 CTS_2_G3B4I3 n513 data_pop[44] VSS VDD_1V8 DFRRQHDLLX0
Xdata_pop_reg_43_ n237 CTS_2_G3B4I3 n514 data_pop[43] VSS VDD_1V8 DFRRQHDLLX0
Xdata_pop_reg_42_ n237 CTS_2_G3B4I3 n515 data_pop[42] VSS VDD_1V8 DFRRQHDLLX0
Xdata_pop_reg_41_ n237 CTS_2_G3B4I3 n516 data_pop[41] VSS VDD_1V8 DFRRQHDLLX0
Xdata_pop_reg_40_ n237 CTS_2_G3B4I3 n517 data_pop[40] VSS VDD_1V8 DFRRQHDLLX0
Xdata_pop_reg_39_ n237 CTS_2_G3B4I3 n518 data_pop[39] VSS VDD_1V8 DFRRQHDLLX0
Xdata_pop_reg_38_ n237 CTS_2_G3B4I3 n519 data_pop[38] VSS VDD_1V8 DFRRQHDLLX0
Xdata_pop_reg_37_ n237 CTS_2_G3B4I3 n520 data_pop[37] VSS VDD_1V8 DFRRQHDLLX0
Xdata_pop_reg_36_ n195 CTS_2_G3B4I7 n521 data_pop[36] VSS VDD_1V8 DFRRQHDLLX0
Xdata_pop_reg_35_ n195 CTS_2_G3B4I7 n522 data_pop[35] VSS VDD_1V8 DFRRQHDLLX0
Xdata_pop_reg_34_ n195 CTS_2_G3B4I7 n523 data_pop[34] VSS VDD_1V8 DFRRQHDLLX0
Xdata_pop_reg_33_ n195 CTS_2_G3B4I7 n524 data_pop[33] VSS VDD_1V8 DFRRQHDLLX0
Xdata_pop_reg_32_ n195 CTS_2_G3B4I7 n525 data_pop[32] VSS VDD_1V8 DFRRQHDLLX0
Xdata_pop_reg_31_ n195 CTS_2_G3B4I7 n526 data_pop[31] VSS VDD_1V8 DFRRQHDLLX0
Xdata_pop_reg_30_ n195 CTS_2_G3B4I7 n527 data_pop[30] VSS VDD_1V8 DFRRQHDLLX0
Xdata_pop_reg_29_ n195 CTS_2_G3B4I7 n528 data_pop[29] VSS VDD_1V8 DFRRQHDLLX0
Xdata_pop_reg_28_ n195 CTS_2_G3B4I7 n529 data_pop[28] VSS VDD_1V8 DFRRQHDLLX0
Xdata_pop_reg_27_ n195 CTS_2_G3B4I7 n530 data_pop[27] VSS VDD_1V8 DFRRQHDLLX0
Xdata_pop_reg_26_ n195 CTS_2_G3B4I7 n531 data_pop[26] VSS VDD_1V8 DFRRQHDLLX0
Xdata_pop_reg_25_ n195 CTS_2_G3B4I7 n532 data_pop[25] VSS VDD_1V8 DFRRQHDLLX0
Xdata_pop_reg_24_ n195 CTS_2_G3B4I7 n533 data_pop[24] VSS VDD_1V8 DFRRQHDLLX0
Xdata_pop_reg_23_ n195 CTS_2_G3B4I7 n534 data_pop[23] VSS VDD_1V8 DFRRQHDLLX0
Xdata_pop_reg_22_ n195 CTS_2_G3B4I7 n535 data_pop[22] VSS VDD_1V8 DFRRQHDLLX0
Xdata_pop_reg_21_ n195 CTS_2_G3B4I7 n536 data_pop[21] VSS VDD_1V8 DFRRQHDLLX0
Xdata_pop_reg_20_ n195 CTS_2_G3B4I7 n537 data_pop[20] VSS VDD_1V8 DFRRQHDLLX0
Xdata_pop_reg_19_ n195 CTS_2_G3B4I7 n538 data_pop[19] VSS VDD_1V8 DFRRQHDLLX0
Xdata_pop_reg_18_ n195 CTS_2_G3B4I7 n539 data_pop[18] VSS VDD_1V8 DFRRQHDLLX0
Xdata_pop_reg_17_ n195 CTS_2_G3B4I7 n540 data_pop[17] VSS VDD_1V8 DFRRQHDLLX0
Xdata_pop_reg_16_ n195 CTS_2_G3B4I7 n541 data_pop[16] VSS VDD_1V8 DFRRQHDLLX0
Xdata_pop_reg_15_ n195 CTS_2_G3B4I7 n542 data_pop[15] VSS VDD_1V8 DFRRQHDLLX0
Xdata_pop_reg_14_ n195 CTS_2_G3B4I7 n543 data_pop[14] VSS VDD_1V8 DFRRQHDLLX0
Xdata_pop_reg_13_ n195 CTS_2_G3B4I7 n544 data_pop[13] VSS VDD_1V8 DFRRQHDLLX0
Xdata_pop_reg_12_ n195 CTS_2_G3B4I7 n545 data_pop[12] VSS VDD_1V8 DFRRQHDLLX0
Xdata_pop_reg_11_ n195 CTS_2_G3B4I7 n546 data_pop[11] VSS VDD_1V8 DFRRQHDLLX0
Xdata_pop_reg_10_ n195 CTS_2_G3B4I7 n547 data_pop[10] VSS VDD_1V8 DFRRQHDLLX0
Xdata_push_reg_52_ n237 CTS_2_G3B4I7 n347 D_push[52] VSS VDD_1V8 DFRRQHDLLX0
Xdata_push_reg_51_ n185 CTS_2_G3B4I3 n348 D_push[51] VSS VDD_1V8 DFRRQHDLLX0
Xdata_push_reg_50_ n237 CTS_2_G3B4I3 n349 D_push[50] VSS VDD_1V8 DFRRQHDLLX0
Xdata_push_reg_49_ n237 CTS_2_G3B4I3 n350 D_push[49] VSS VDD_1V8 DFRRQHDLLX0
Xdata_push_reg_48_ n237 CTS_2_G3B4I3 n351 D_push[48] VSS VDD_1V8 DFRRQHDLLX0
Xdata_push_reg_47_ n185 CTS_2_G3B4I3 n352 D_push[47] VSS VDD_1V8 DFRRQHDLLX0
Xdata_push_reg_46_ n237 CTS_2_G3B4I7 n353 D_push[46] VSS VDD_1V8 DFRRQHDLLX0
Xdata_push_reg_45_ n185 CTS_2_G3B4I3 n354 D_push[45] VSS VDD_1V8 DFRRQHDLLX0
Xdata_push_reg_44_ n185 CTS_2_G3B4I3 n355 D_push[44] VSS VDD_1V8 DFRRQHDLLX0
Xdata_push_reg_43_ n185 CTS_2_G3B4I3 n356 D_push[43] VSS VDD_1V8 DFRRQHDLLX0
Xdata_push_reg_42_ n185 CTS_2_G3B4I3 n357 D_push[42] VSS VDD_1V8 DFRRQHDLLX0
Xdata_push_reg_41_ n237 CTS_2_G3B4I3 n358 D_push[41] VSS VDD_1V8 DFRRQHDLLX0
Xdata_push_reg_40_ n185 CTS_2_G3B4I3 n359 D_push[40] VSS VDD_1V8 DFRRQHDLLX0
Xdata_push_reg_39_ n185 CTS_2_G3B4I3 n360 D_push[39] VSS VDD_1V8 DFRRQHDLLX0
Xdata_push_reg_38_ n185 CTS_2_G3B4I3 n361 D_push[38] VSS VDD_1V8 DFRRQHDLLX0
Xdata_push_reg_37_ n185 CTS_2_G3B4I3 n362 D_push[37] VSS VDD_1V8 DFRRQHDLLX0
Xdata_push_reg_36_ n237 CTS_2_G3B4I3 n363 D_push[36] VSS VDD_1V8 DFRRQHDLLX0
Xdata_push_reg_35_ n237 CTS_2_G3B4I3 n364 D_push[35] VSS VDD_1V8 DFRRQHDLLX0
Xdata_push_reg_34_ n237 CTS_2_G3B4I3 n365 D_push[34] VSS VDD_1V8 DFRRQHDLLX0
Xdata_push_reg_33_ n237 CTS_2_G3B4I7 n366 D_push[33] VSS VDD_1V8 DFRRQHDLLX0
Xdata_push_reg_32_ n237 CTS_2_G3B4I7 n367 D_push[32] VSS VDD_1V8 DFRRQHDLLX0
Xtspi_data_config_reg_13_ n185 CTS_2_G3B4I3 n436 tspi_data_config[13] VSS VDD_1V8 DFRRQHDLLX0
Xtspi_data_config_reg_12_ n185 CTS_2_G3B4I3 n437 tspi_data_config[12] VSS VDD_1V8 DFRRQHDLLX0
Xtspi_data_tx_reg_16_ n66 CTS_2_G3B4I2 n600 tspi_data_tx[16] VSS VDD_1V8 DFRRQHDLLX0
Xtspi_data_tx_reg_17_ n66 CTS_2_G3B4I2 n601 tspi_data_tx[17] VSS VDD_1V8 DFRRQHDLLX0
Xtspi_data_tx_reg_18_ n188 CTS_2_G3B4I2 n602 tspi_data_tx[18] VSS VDD_1V8 DFRRQHDLLX0
Xtspi_data_tx_reg_19_ n66 CTS_2_G3B4I2 n603 tspi_data_tx[19] VSS VDD_1V8 DFRRQHDLLX0
Xtspi_data_tx_reg_20_ n66 CTS_2_G3B4I2 n604 tspi_data_tx[20] VSS VDD_1V8 DFRRQHDLLX0
Xtspi_data_tx_reg_21_ n66 CTS_2_G3B4I2 n605 tspi_data_tx[21] VSS VDD_1V8 DFRRQHDLLX0
Xtspi_data_tx_reg_22_ n66 CTS_2_G3B4I2 n606 tspi_data_tx[22] VSS VDD_1V8 DFRRQHDLLX0
Xtspi_data_tx_reg_23_ n66 CTS_2_G3B4I2 n607 tspi_data_tx[23] VSS VDD_1V8 DFRRQHDLLX0
Xtspi_data_tx_reg_8_ n66 CTS_2_G3B4I2 n624 tspi_data_tx[8] VSS VDD_1V8 DFRRQHDLLX0
Xtspi_data_tx_reg_9_ n66 CTS_2_G3B4I2 n625 tspi_data_tx[9] VSS VDD_1V8 DFRRQHDLLX0
Xtspi_data_tx_reg_10_ n188 CTS_2_G3B4I2 n626 tspi_data_tx[10] VSS VDD_1V8 DFRRQHDLLX0
Xtspi_data_tx_reg_11_ n188 CTS_2_G3B4I2 n627 tspi_data_tx[11] VSS VDD_1V8 DFRRQHDLLX0
Xtspi_data_tx_reg_12_ n66 CTS_2_G3B4I2 n628 tspi_data_tx[12] VSS VDD_1V8 DFRRQHDLLX0
Xtspi_data_tx_reg_13_ n188 CTS_2_G3B4I2 n629 tspi_data_tx[13] VSS VDD_1V8 DFRRQHDLLX0
Xtspi_data_tx_reg_14_ n66 CTS_2_G3B4I2 n630 tspi_data_tx[14] VSS VDD_1V8 DFRRQHDLLX0
Xtspi_data_tx_reg_15_ n66 CTS_2_G3B4I2 n631 tspi_data_tx[15] VSS VDD_1V8 DFRRQHDLLX0
Xtspi_data_tx_reg_0_ n188 CTS_2_G3B4I2 n632 tspi_data_tx[0] VSS VDD_1V8 DFRRQHDLLX0
Xtspi_data_tx_reg_1_ n188 CTS_2_G3B4I2 n633 tspi_data_tx[1] VSS VDD_1V8 DFRRQHDLLX0
Xtspi_data_tx_reg_2_ n188 CTS_2_G3B4I2 n634 tspi_data_tx[2] VSS VDD_1V8 DFRRQHDLLX0
Xtspi_data_tx_reg_3_ n188 CTS_2_G3B4I2 n635 tspi_data_tx[3] VSS VDD_1V8 DFRRQHDLLX0
Xtspi_data_tx_reg_4_ n188 CTS_2_G3B4I2 n636 tspi_data_tx[4] VSS VDD_1V8 DFRRQHDLLX0
Xtspi_data_tx_reg_5_ n188 CTS_2_G3B4I2 n637 tspi_data_tx[5] VSS VDD_1V8 DFRRQHDLLX0
Xtspi_data_tx_reg_6_ n188 CTS_2_G3B4I2 n638 tspi_data_tx[6] VSS VDD_1V8 DFRRQHDLLX0
Xtspi_data_tx_reg_7_ n66 CTS_2_G3B4I2 n639 tspi_data_tx[7] VSS VDD_1V8 DFRRQHDLLX0
Xaddress_reg_23_ n188 CTS_2_G3B4I2 n479 address[23] VSS VDD_1V8 DFRRQHDLLX0
Xbst_addr_reg_23_ n188 CTS_2_G3B4I2 n558 bst_addr[23] VSS VDD_1V8 DFRRQHDLLX0
Xaddress_reg_22_ n188 CTS_2_G3B4I7 n480 address[22] VSS VDD_1V8 DFRRQHDLLX0
Xbst_addr_reg_22_ n95 CTS_2_G3B4I2 n559 bst_addr[22] VSS VDD_1V8 DFRRQHDLLX0
Xaddress_reg_21_ n237 CTS_2_G3B4I3 n481 address[21] VSS VDD_1V8 DFRRQHDLLX0
Xbst_addr_reg_21_ n95 CTS_2_G3B4I2 n560 bst_addr[21] VSS VDD_1V8 DFRRQHDLLX0
Xaddress_reg_20_ n188 CTS_2_G3B4I7 n482 address[20] VSS VDD_1V8 DFRRQHDLLX0
Xbst_addr_reg_20_ n188 CTS_2_G3B4I2 n561 bst_addr[20] VSS VDD_1V8 DFRRQHDLLX0
Xaddress_reg_19_ n188 CTS_2_G3B4I7 n483 address[19] VSS VDD_1V8 DFRRQHDLLX0
Xbst_addr_reg_19_ n188 CTS_2_G3B4I2 n562 bst_addr[19] VSS VDD_1V8 DFRRQHDLLX0
Xaddress_reg_18_ n188 CTS_2_G3B4I2 n484 address[18] VSS VDD_1V8 DFRRQHDLLX0
Xbst_addr_reg_18_ n95 CTS_2_G3B4I2 n563 bst_addr[18] VSS VDD_1V8 DFRRQHDLLX0
Xaddress_reg_17_ n188 CTS_2_G3B4I2 n485 address[17] VSS VDD_1V8 DFRRQHDLLX0
Xbst_addr_reg_17_ n95 CTS_2_G3B4I4 n564 bst_addr[17] VSS VDD_1V8 DFRRQHDLLX0
Xaddress_reg_16_ n237 CTS_2_G3B4I3 n486 address[16] VSS VDD_1V8 DFRRQHDLLX0
Xbst_addr_reg_16_ n95 CTS_2_G3B4I4 n565 bst_addr[16] VSS VDD_1V8 DFRRQHDLLX0
Xaddress_reg_15_ n95 CTS_2_G3B4I2 n487 address[15] VSS VDD_1V8 DFRRQHDLLX0
Xbst_addr_reg_15_ n95 CTS_2_G3B4I2 n566 bst_addr[15] VSS VDD_1V8 DFRRQHDLLX0
Xaddress_reg_14_ n95 CTS_2_G3B4I2 n488 address[14] VSS VDD_1V8 DFRRQHDLLX0
Xbst_addr_reg_14_ n95 CTS_2_G3B4I2 n567 bst_addr[14] VSS VDD_1V8 DFRRQHDLLX0
Xaddress_reg_13_ n237 CTS_2_G3B4I3 n489 address[13] VSS VDD_1V8 DFRRQHDLLX0
Xbst_addr_reg_13_ n95 CTS_2_G3B4I2 n568 bst_addr[13] VSS VDD_1V8 DFRRQHDLLX0
Xaddress_reg_12_ n237 CTS_2_G3B4I3 n490 address[12] VSS VDD_1V8 DFRRQHDLLX0
Xbst_addr_reg_12_ n95 CTS_2_G3B4I3 n569 bst_addr[12] VSS VDD_1V8 DFRRQHDLLX0
Xaddress_reg_11_ n237 CTS_2_G3B4I3 n491 address[11] VSS VDD_1V8 DFRRQHDLLX0
Xbst_addr_reg_11_ n95 CTS_2_G3B4I3 n570 bst_addr[11] VSS VDD_1V8 DFRRQHDLLX0
Xaddress_reg_10_ n237 CTS_2_G3B4I3 n492 address[10] VSS VDD_1V8 DFRRQHDLLX0
Xbst_addr_reg_10_ n237 CTS_2_G3B4I3 n571 bst_addr[10] VSS VDD_1V8 DFRRQHDLLX0
Xaddress_reg_9_ n237 CTS_2_G3B4I3 n493 address[9] VSS VDD_1V8 DFRRQHDLLX0
Xbst_addr_reg_9_ n95 CTS_2_G3B4I3 n572 bst_addr[9] VSS VDD_1V8 DFRRQHDLLX0
Xaddress_reg_8_ n237 CTS_2_G3B4I3 n494 address[8] VSS VDD_1V8 DFRRQHDLLX0
Xbst_addr_reg_8_ n95 CTS_2_G3B4I3 n573 bst_addr[8] VSS VDD_1V8 DFRRQHDLLX0
Xaddress_reg_7_ n237 CTS_2_G3B4I3 n495 address[7] VSS VDD_1V8 DFRRQHDLLX0
Xbst_addr_reg_7_ n95 CTS_2_G3B4I3 n574 bst_addr[7] VSS VDD_1V8 DFRRQHDLLX0
Xaddress_reg_6_ n237 CTS_2_G3B4I3 n496 address[6] VSS VDD_1V8 DFRRQHDLLX0
Xbst_addr_reg_6_ n237 CTS_2_G3B4I3 n575 bst_addr[6] VSS VDD_1V8 DFRRQHDLLX0
Xaddress_reg_5_ n237 CTS_2_G3B4I3 n497 address[5] VSS VDD_1V8 DFRRQHDLLX0
Xbst_addr_reg_5_ n237 CTS_2_G3B4I3 n576 bst_addr[5] VSS VDD_1V8 DFRRQHDLLX0
Xaddress_reg_4_ n237 CTS_2_G3B4I3 n498 address[4] VSS VDD_1V8 DFRRQHDLLX0
Xbst_addr_reg_4_ n95 CTS_2_G3B4I2 n577 bst_addr[4] VSS VDD_1V8 DFRRQHDLLX0
Xaddress_reg_3_ n237 CTS_2_G3B4I3 n499 address[3] VSS VDD_1V8 DFRRQHDLLX0
Xbst_addr_reg_3_ n95 CTS_2_G3B4I3 n578 bst_addr[3] VSS VDD_1V8 DFRRQHDLLX0
Xaddress_reg_2_ n237 CTS_2_G3B4I2 n500 address[2] VSS VDD_1V8 DFRRQHDLLX0
Xbst_addr_reg_2_ n95 CTS_2_G3B4I2 n579 bst_addr[2] VSS VDD_1V8 DFRRQHDLLX0
Xaddress_reg_1_ n195 CTS_2_G3B4I7 n501 address[1] VSS VDD_1V8 DFRRQHDLLX0
Xaddress_reg_0_ n195 CTS_2_G3B4I7 n502 address[0] VSS VDD_1V8 DFRRQHDLLX0
Xtspi_data_tx_reg_52_ n66 CTS_2_G3B4I2 n592 tspi_data_tx[52] n134 VSS VDD_1V8 DFRRHDLLX0
Xtspi_data_tx_reg_51_ n66 CTS_2_G3B4I2 n591 tspi_data_tx[51] n131 VSS VDD_1V8 DFRRHDLLX0
Xtspi_data_tx_reg_50_ n66 CTS_2_G3B4I4 n590 tspi_data_tx[50] n128 VSS VDD_1V8 DFRRHDLLX0
Xtspi_data_tx_reg_49_ n66 CTS_2_G3B4I4 n589 tspi_data_tx[49] n125 VSS VDD_1V8 DFRRHDLLX0
Xtspi_data_tx_reg_48_ n240 CTS_2_G3B4I4 n588 tspi_data_tx[48] n122 VSS VDD_1V8 DFRRHDLLX0
Xtspi_data_tx_reg_47_ n95 CTS_2_G3B4I4 n587 tspi_data_tx[47] n119 VSS VDD_1V8 DFRRHDLLX0
Xtspi_data_tx_reg_46_ n95 CTS_2_G3B4I4 n586 tspi_data_tx[46] n116 VSS VDD_1V8 DFRRHDLLX0
Xtspi_data_tx_reg_45_ n95 CTS_2_G3B4I4 n585 tspi_data_tx[45] n113 VSS VDD_1V8 DFRRHDLLX0
Xtspi_data_tx_reg_44_ n95 CTS_2_G3B4I4 n584 tspi_data_tx[44] n110 VSS VDD_1V8 DFRRHDLLX0
Xtspi_data_tx_reg_43_ n95 CTS_2_G3B4I4 n583 tspi_data_tx[43] n107 VSS VDD_1V8 DFRRHDLLX0
Xtspi_data_tx_reg_42_ n95 CTS_2_G3B4I3 n582 tspi_data_tx[42] n104 VSS VDD_1V8 DFRRHDLLX0
Xtspi_data_tx_reg_41_ n95 CTS_2_G3B4I4 n581 tspi_data_tx[41] n101 VSS VDD_1V8 DFRRHDLLX0
Xtspi_data_tx_reg_40_ n95 CTS_2_G3B4I4 n580 tspi_data_tx[40] n98 VSS VDD_1V8 DFRRHDLLX0
Xtspi_data_tx_reg_39_ n95 CTS_2_G3B4I4 n623 tspi_data_tx[39] n200 VSS VDD_1V8 DFRRHDLLX0
Xtspi_data_tx_reg_38_ n95 CTS_2_G3B4I4 n622 tspi_data_tx[38] n193 VSS VDD_1V8 DFRRHDLLX0
Xtspi_data_tx_reg_37_ n95 CTS_2_G3B4I4 n621 tspi_data_tx[37] n190 VSS VDD_1V8 DFRRHDLLX0
Xtspi_data_tx_reg_36_ n95 CTS_2_G3B4I4 n620 tspi_data_tx[36] n187 VSS VDD_1V8 DFRRHDLLX0
Xtspi_data_tx_reg_35_ n95 CTS_2_G3B4I4 n619 tspi_data_tx[35] n184 VSS VDD_1V8 DFRRHDLLX0
Xtspi_data_tx_reg_34_ n95 CTS_2_G3B4I4 n618 tspi_data_tx[34] n181 VSS VDD_1V8 DFRRHDLLX0
Xtspi_data_tx_reg_33_ n95 CTS_2_G3B4I4 n617 tspi_data_tx[33] n178 VSS VDD_1V8 DFRRHDLLX0
Xtspi_data_tx_reg_32_ n95 CTS_2_G3B4I4 n616 tspi_data_tx[32] n175 VSS VDD_1V8 DFRRHDLLX0
Xdata_push_reg_7_ n196 CTS_2_G3B4I1 n392 D_push[7] VSS VDD_1V8 DFRRQHDLLX0
Xpush_reg n185 CTS_2_G3B4I3 n339 push VSS VDD_1V8 DFRRQHDLLX0
Xtspi_send_data_reg n1 CTS_2_G3B4I5 n432 tspi_send_data VSS VDD_1V8 DFRRQHDLLX0
Xtspi_config_en_reg n1 CTS_2_G3B4I5 n434 tspi_config_en VSS VDD_1V8 DFRRQHDLLX0
Xdata_push_reg_6_ n196 CTS_2_G3B4I6 n393 D_push[6] VSS VDD_1V8 DFRRQHDLLX0
Xt_word_reg_30_ n196 CTS_2_G3B4I6 n401 t_word[30] VSS VDD_1V8 DFRRQHDLLX0
Xdata_push_reg_5_ n196 CTS_2_G3B4I6 n394 D_push[5] VSS VDD_1V8 DFRRQHDLLX0
Xt_word_reg_29_ n196 CTS_2_G3B4I6 n402 t_word[29] VSS VDD_1V8 DFRRQHDLLX0
Xdata_push_reg_4_ n196 CTS_2_G3B4I6 n395 D_push[4] VSS VDD_1V8 DFRRQHDLLX0
Xt_word_reg_28_ n196 CTS_2_G3B4I6 n403 t_word[28] VSS VDD_1V8 DFRRQHDLLX0
Xdata_push_reg_3_ n196 CTS_2_G3B4I6 n396 D_push[3] VSS VDD_1V8 DFRRQHDLLX0
Xt_word_reg_27_ n196 CTS_2_G3B4I6 n404 t_word[27] VSS VDD_1V8 DFRRQHDLLX0
Xdata_push_reg_2_ n196 CTS_2_G3B4I6 n397 D_push[2] VSS VDD_1V8 DFRRQHDLLX0
Xt_word_reg_26_ n164 CTS_2_G3B4I6 n405 t_word[26] VSS VDD_1V8 DFRRQHDLLX0
Xdata_push_reg_1_ n164 CTS_2_G3B4I6 n398 D_push[1] VSS VDD_1V8 DFRRQHDLLX0
Xt_word_reg_25_ n164 CTS_2_G3B4I6 n406 t_word[25] VSS VDD_1V8 DFRRQHDLLX0
Xdata_push_reg_0_ n196 CTS_2_G3B4I6 n399 D_push[0] VSS VDD_1V8 DFRRQHDLLX0
Xt_word_reg_24_ n164 CTS_2_G3B4I6 n407 t_word[24] VSS VDD_1V8 DFRRQHDLLX0
Xdata_push_reg_15_ n164 CTS_2_G3B4I6 n384 D_push[15] VSS VDD_1V8 DFRRQHDLLX0
Xt_word_reg_23_ n164 CTS_2_G3B4I6 n408 t_word[23] VSS VDD_1V8 DFRRQHDLLX0
Xdata_push_reg_14_ n164 CTS_2_G3B4I6 n385 D_push[14] VSS VDD_1V8 DFRRQHDLLX0
Xt_word_reg_22_ n164 CTS_2_G3B4I6 n409 t_word[22] VSS VDD_1V8 DFRRQHDLLX0
Xdata_push_reg_13_ n164 CTS_2_G3B4I6 n386 D_push[13] VSS VDD_1V8 DFRRQHDLLX0
Xt_word_reg_21_ n164 CTS_2_G3B4I6 n410 t_word[21] VSS VDD_1V8 DFRRQHDLLX0
Xdata_push_reg_12_ n164 CTS_2_G3B4I6 n387 D_push[12] VSS VDD_1V8 DFRRQHDLLX0
Xt_word_reg_20_ n164 CTS_2_G3B4I6 n411 t_word[20] VSS VDD_1V8 DFRRQHDLLX0
Xdata_push_reg_11_ n164 CTS_2_G3B4I6 n388 D_push[11] VSS VDD_1V8 DFRRQHDLLX0
Xt_word_reg_19_ n164 CTS_2_G3B4I6 n412 t_word[19] VSS VDD_1V8 DFRRQHDLLX0
Xdata_push_reg_10_ n164 CTS_2_G3B4I6 n389 D_push[10] VSS VDD_1V8 DFRRQHDLLX0
Xt_word_reg_18_ n164 CTS_2_G3B4I6 n413 t_word[18] VSS VDD_1V8 DFRRQHDLLX0
Xdata_push_reg_9_ n164 CTS_2_G3B4I6 n390 D_push[9] VSS VDD_1V8 DFRRQHDLLX0
Xt_word_reg_17_ n164 CTS_2_G3B4I6 n414 t_word[17] VSS VDD_1V8 DFRRQHDLLX0
Xdata_push_reg_8_ n164 CTS_2_G3B4I6 n391 D_push[8] VSS VDD_1V8 DFRRQHDLLX0
Xt_word_reg_16_ n164 CTS_2_G3B4I6 n415 t_word[16] VSS VDD_1V8 DFRRQHDLLX0
Xdata_push_reg_23_ n164 CTS_2_G3B4I6 n376 D_push[23] VSS VDD_1V8 DFRRQHDLLX0
Xt_word_reg_15_ n164 CTS_2_G3B4I6 n416 t_word[15] VSS VDD_1V8 DFRRQHDLLX0
Xdata_push_reg_22_ n164 CTS_2_G3B4I6 n377 D_push[22] VSS VDD_1V8 DFRRQHDLLX0
Xt_word_reg_14_ n164 CTS_2_G3B4I6 n417 t_word[14] VSS VDD_1V8 DFRRQHDLLX0
Xdata_push_reg_21_ n164 CTS_2_G3B4I6 n378 D_push[21] VSS VDD_1V8 DFRRQHDLLX0
Xt_word_reg_13_ n164 CTS_2_G3B4I6 n418 t_word[13] VSS VDD_1V8 DFRRQHDLLX0
Xdata_push_reg_20_ n164 CTS_2_G3B4I6 n379 D_push[20] VSS VDD_1V8 DFRRQHDLLX0
Xt_word_reg_12_ n164 CTS_2_G3B4I6 n419 t_word[12] VSS VDD_1V8 DFRRQHDLLX0
Xdata_push_reg_19_ n164 CTS_2_G3B4I6 n380 D_push[19] VSS VDD_1V8 DFRRQHDLLX0
Xt_word_reg_11_ n164 CTS_2_G3B4I6 n420 t_word[11] VSS VDD_1V8 DFRRQHDLLX0
Xdata_push_reg_18_ n164 CTS_2_G3B4I6 n381 D_push[18] VSS VDD_1V8 DFRRQHDLLX0
Xt_word_reg_10_ n164 CTS_2_G3B4I6 n421 t_word[10] VSS VDD_1V8 DFRRQHDLLX0
Xdata_push_reg_17_ n164 CTS_2_G3B4I6 n382 D_push[17] VSS VDD_1V8 DFRRQHDLLX0
Xt_word_reg_9_ n164 CTS_2_G3B4I6 n422 t_word[9] VSS VDD_1V8 DFRRQHDLLX0
Xdata_push_reg_16_ n164 CTS_2_G3B4I6 n383 D_push[16] VSS VDD_1V8 DFRRQHDLLX0
Xt_word_reg_8_ n164 CTS_2_G3B4I6 n423 t_word[8] VSS VDD_1V8 DFRRQHDLLX0
Xdata_push_reg_31_ n196 CTS_2_G3B4I6 n368 D_push[31] VSS VDD_1V8 DFRRQHDLLX0
Xt_word_reg_7_ n196 CTS_2_G3B4I6 n424 t_word[7] VSS VDD_1V8 DFRRQHDLLX0
Xdata_push_reg_30_ n196 CTS_2_G3B4I6 n369 D_push[30] VSS VDD_1V8 DFRRQHDLLX0
Xt_word_reg_6_ n196 CTS_2_G3B4I6 n425 t_word[6] VSS VDD_1V8 DFRRQHDLLX0
Xdata_push_reg_29_ n196 CTS_2_G3B4I6 n370 D_push[29] VSS VDD_1V8 DFRRQHDLLX0
Xt_word_reg_5_ n196 CTS_2_G3B4I6 n426 t_word[5] VSS VDD_1V8 DFRRQHDLLX0
Xdata_push_reg_28_ n196 CTS_2_G3B4I6 n371 D_push[28] VSS VDD_1V8 DFRRQHDLLX0
Xt_word_reg_4_ n196 CTS_2_G3B4I6 n427 t_word[4] VSS VDD_1V8 DFRRQHDLLX0
Xdata_push_reg_27_ n196 CTS_2_G3B4I1 n372 D_push[27] VSS VDD_1V8 DFRRQHDLLX0
Xt_word_reg_3_ n196 CTS_2_G3B4I1 n428 t_word[3] VSS VDD_1V8 DFRRQHDLLX0
Xdata_push_reg_26_ n196 CTS_2_G3B4I1 n373 D_push[26] VSS VDD_1V8 DFRRQHDLLX0
Xt_word_reg_2_ n196 CTS_2_G3B4I1 n429 t_word[2] VSS VDD_1V8 DFRRQHDLLX0
Xdata_push_reg_25_ n196 CTS_2_G3B4I1 n374 D_push[25] VSS VDD_1V8 DFRRQHDLLX0
Xt_word_reg_1_ n196 CTS_2_G3B4I1 n430 t_word[1] VSS VDD_1V8 DFRRQHDLLX0
Xdata_push_reg_24_ n196 CTS_2_G3B4I1 n375 D_push[24] VSS VDD_1V8 DFRRQHDLLX0
Xdata_push_reg_60_ n168 CTS_2_G3B4I1 n338 D_push[60] VSS VDD_1V8 DFRRQHDLLX0
Xdata_push_reg_58_ n185 CTS_2_G3B4I3 n341 D_push[58] VSS VDD_1V8 DFRRQHDLLX0
Xdata_push_reg_59_ n185 CTS_2_G3B4I3 n340 D_push[59] VSS VDD_1V8 DFRRQHDLLX0
Xdata_push_reg_57_ n185 CTS_2_G3B4I3 n342 D_push[57] VSS VDD_1V8 DFRRQHDLLX0
Xdata_push_reg_55_ n185 CTS_2_G3B4I3 n344 D_push[55] VSS VDD_1V8 DFRRQHDLLX0
Xdata_push_reg_54_ n185 CTS_2_G3B4I3 n345 D_push[54] VSS VDD_1V8 DFRRQHDLLX0
Xdata_push_reg_53_ n185 CTS_2_G3B4I3 n346 D_push[53] VSS VDD_1V8 DFRRQHDLLX0
XU109 VSS n100 n322 VDD_1V8 n319 NA2HDLLX0
XU108 VSS VDD_1V8 n322 n106 n72 n15 n73 AN22HDLLX0
XU107 VSS n100 n76 n324 VDD_1V8 NO2HDLLX0
XU106 n324 VSS VDD_1V8 n112 n189 n659 n14 ON22HDLLX0
XU105 n76 VSS n327 n321 VDD_1V8 n332 NA3HDLLX0
XU104 VSS n161 n13 VDD_1V8 n321 NA2HDLLX0
XU103 VSS n75 n72 VDD_1V8 n327 NA2HDLLX0
XU102 VSS n332 n162 n146 VDD_1V8 NO2HDLLX0
XU101 VSS n146 n14 n12 VDD_1V8 NO2HDLLX0
XU100 VSS n162 n11 n167 VDD_1V8 NO2HDLLX0
XU99 VSS n330 n10 n9 VDD_1V8 NO2HDLLX0
XU98 n317 VSS VDD_1V8 n8 n7 n337 NO3HDLLX0
XU97 VSS n150 n16 VDD_1V8 n310 n165 n7 NA4I2HDLLX0
XU96 VSS n310 n163 n133 VDD_1V8 NO2HDLLX0
XU95 VSS n133 n11 n6 VDD_1V8 NO2HDLLX0
XU94 VSS n163 n191 n112 VDD_1V8 NO2HDLLX0
XU93 VSS n150 n6 n12 VDD_1V8 NO2HDLLX0
XU92 VSS n165 n189 n167 VDD_1V8 NO2HDLLX0
XU91 VSS n8 VDD_1V8 n176 n112 n11 ON21HDLLX0
XU90 VSS VDD_1V8 n194 n118 n81 n337 n197 NA4I3HDLLX0
XU89 n81 VSS VDD_1V8 n674 n114 n239 NO3HDLLX0
XU88 VSS n114 VDD_1V8 n241 n112 n659 ON21HDLLX0
XU87 VSS n15 n73 VDD_1V8 n241 NA2HDLLX0
XU85 n5 VSS n130 n106 VDD_1V8 n97 AN21HDLLX0
XU84 VSS n130 n6 n189 VDD_1V8 NO2HDLLX0
XU83 VSS VDD_1V8 n239 n69 n329 NO2I1HDLLX0
XU82 VSS n69 n659 n4 VDD_1V8 NO2HDLLX0
XU80 VSS n72 n161 VDD_1V8 n197 AND2HDLLX0
XU79 VSS n194 n12 n167 VDD_1V8 NO2HDLLX0
XU78 n167 VSS VDD_1V8 n5 INHDLLX0
XU77 VSS n669 n238 VDD_1V8 n118 NA2HDLLX0
XU76 VSS n75 n73 VDD_1V8 n238 NA2HDLLX0
XU73 n675 VSS VDD_1V8 n672 INHDLLX1
XU72 VSS n316 n149 n159 VDD_1V8 NO2HDLLX0
XU71 VSS n159 n6 n191 VDD_1V8 NO2HDLLX0
XU70 n6 VSS VDD_1V8 n3 INHDLLX0
XU69 VSS n149 n14 n11 VDD_1V8 NO2HDLLX0
XU68 n672 VSS VDD_1V8 n653 n656 n666 NO3HDLLX0
XU67 VSS n664 n670 VDD_1V8 n656 NA2HDLLX0
XU66 VSS n161 n5 VDD_1V8 n670 NA2HDLLX0
XU65 n5 VSS VDD_1V8 n739 n329 n160 NO3HDLLX0
XU64 VSS n106 n72 VDD_1V8 n664 NA2HDLLX0
XU63 n72 VSS VDD_1V8 state_1_ n258 n329 NO3HDLLX0
XU62 VSS n653 n14 n191 VDD_1V8 NO2HDLLX0
XU61 VSS n233 n276 VDD_1V8 n191 n245 NA3I2HDLLX0
XU60 VSS n666 n11 n9 VDD_1V8 NO2HDLLX0
XU59 VSS n16 n647 n2 VDD_1V8 NO2HDLLX0
XU58 n108 n103 VSS VDD_1V8 n186 n2 n660 NA4HDLLX0
XU57 VSS n15 n13 VDD_1V8 n103 NA2HDLLX0
XU56 n15 VSS VDD_1V8 n11 INHDLLX0
XU55 n11 VSS n245 n233 VDD_1V8 n276 NA3HDLLX0
XU54 VSS n3 n106 VDD_1V8 n108 NA2HDLLX0
XU53 VSS n75 n13 VDD_1V8 n186 NA2HDLLX0
XU52 VSS n13 n329 n4 VDD_1V8 NO2HDLLX0
XU50 VSS n305 n10 n14 VDD_1V8 NO2HDLLX0
XU48 VSS n161 n3 VDD_1V8 n109 NA2HDLLX0
XU47 VSS n3 n192 n329 VDD_1V8 NO2HDLLX0
XU46 VSS VDD_1V8 n120 n71 n106 n74 n132 AN211HDLLX0
XU45 VSS n132 n14 n189 VDD_1V8 NO2HDLLX0
XU44 VSS n738 n233 VDD_1V8 n189 n245 NA3I2HDLLX0
XU43 n14 VSS state_1_ n258 VDD_1V8 n329 NA3HDLLX0
XU42 VSS n74 n12 n112 VDD_1V8 NO2HDLLX0
XU41 n112 VSS n192 VDD_1V8 n329 NA2I1HDLLX0
XU40 VSS n160 n258 VDD_1V8 n192 NA2HDLLX0
XU39 n245 n276 VSS VDD_1V8 n106 n233 NO3I2HDLLX0
XU38 VSS VDD_1V8 n176 n75 n73 n161 n71 AN22HDLLX0
XU37 n71 VSS VDD_1V8 n9 INHDLLX0
XU36 n9 VSS n739 n329 VDD_1V8 n160 NA3HDLLX0
XU35 n160 VSS VDD_1V8 state_1_ INHDLLX0
XU34 n75 VSS VDD_1V8 n12 INHDLLX0
XU33 VSS n245 n276 VDD_1V8 n12 n233 NA3I2HDLLX0
XU32 VSS VDD_1V8 n73 n329 n4 NO2I1HDLLX0
XU31 VSS n739 state_1_ VDD_1V8 n4 NA2HDLLX0
XU29 n161 VSS VDD_1V8 n10 INHDLLX0
XU28 n10 VSS n233 n738 VDD_1V8 n245 NA3HDLLX0
Xtspi_data_config_reg_0_ n185 CTS_2_G3B4I3 n433 tspi_data_config[0] n46 VSS VDD_1V8 DFRRHDLLX0
Xtspi_data_config_reg_14_ n185 CTS_2_G3B4I3 n435 tspi_data_config[14] n51 VSS VDD_1V8 DFRRHDLLX0
Xtspi_data_config_reg_11_ n185 CTS_2_G3B4I3 n438 tspi_data_config[11] n58 VSS VDD_1V8 DFRRHDLLX0
Xdata_push_reg_56_ n185 CTS_2_G3B4I3 n343 D_push[56] n29 VSS VDD_1V8 DFRRHDLLX0
Xstate_reg_0_ n185 CTS_2_G3B4I3 n645 SYNOPSYS_UNCONNECTED_81 n329 VSS VDD_1V8 DFRRHDLLX0
Xstate_reg_4_ n185 CTS_2_G3B4I3 n641 SYNOPSYS_UNCONNECTED_82 n245 VSS VDD_1V8 DFRRHDLLX0
Xstate_reg_5_ n185 CTS_2_G3B4I3 n640 SYNOPSYS_UNCONNECTED_83 n233 VSS VDD_1V8 DFRRHDLLX0
Xstate_reg_2_ n185 CTS_2_G3B4I3 n643 n738 n276 VSS VDD_1V8 DFRRHDLLX0
Xstate_reg_3_ n185 CTS_2_G3B4I3 n642 n739 n258 VSS VDD_1V8 DFRRHDLLX0
Xindex_reg_1_ n185 CTS_2_G3B4I3 n443 index[1] n737 VSS VDD_1V8 DFRRHDLLX0
Xpop_reg n237 CTS_2_G3B4I7 n336 pop n19 VSS VDD_1V8 DFRRHDLLX0
Xtspi_data_tx_reg_57_ n95 CTS_2_G3B4I4 n597 tspi_data_tx[57] n148 VSS VDD_1V8 DFRRHDLLX0
Xtspi_data_tx_reg_58_ n95 CTS_2_G3B4I4 n598 tspi_data_tx[58] n151 VSS VDD_1V8 DFRRHDLLX0
Xtspi_data_tx_reg_55_ n240 CTS_2_G3B4I4 n595 tspi_data_tx[55] n143 VSS VDD_1V8 DFRRHDLLX0
Xtspi_data_tx_reg_54_ n66 CTS_2_G3B4I2 n594 tspi_data_tx[54] n140 VSS VDD_1V8 DFRRHDLLX0
Xtspi_data_tx_reg_53_ n95 CTS_2_G3B4I4 n593 tspi_data_tx[53] n137 VSS VDD_1V8 DFRRHDLLX0
XU206 VSS VDD_1V8 n289 bst_addr[16] n288 NO2I1HDLLX0
XU205 VSS bst_addr[15] n284 VDD_1V8 n288 NA2HDLLX0
XU204 VSS VDD_1V8 n284 bst_addr[14] n283 NO2I1HDLLX0
XU203 VSS bst_addr[13] n279 VDD_1V8 n283 NA2HDLLX0
XU202 VSS VDD_1V8 n279 bst_addr[12] n278 NO2I1HDLLX0
XU201 VSS bst_addr[11] n273 VDD_1V8 n278 NA2HDLLX0
XU200 VSS VDD_1V8 n273 bst_addr[10] n272 NO2I1HDLLX0
XU199 VSS bst_addr[9] n268 VDD_1V8 n272 NA2HDLLX0
XU198 VSS VDD_1V8 n268 bst_addr[8] n267 NO2I1HDLLX0
XU197 VSS bst_addr[7] n263 VDD_1V8 n267 NA2HDLLX0
XU196 n263 VSS VDD_1V8 n256 n257 n259 NO3HDLLX0
XU195 n257 VSS bst_addr[3] bst_addr[2] VDD_1V8 bst_addr[4] NA3HDLLX0
XU194 n256 VSS VDD_1V8 bst_addr[5] INHDLLX0
XU193 n259 VSS VDD_1V8 bst_addr[6] INHDLLX0
XU192 n67 VSS n691 n104 n68 VDD_1V8 n582 ON211HDLLX0
XU191 VSS VDD_1V8 n67 address[10] data[10] n662 n671 AN22HDLLX0
XU190 n247 VSS n674 bst_addr[10] VDD_1V8 n68 AN21HDLLX0
XU189 n64 VSS n691 n128 n65 VDD_1V8 n590 ON211HDLLX0
XU188 VSS VDD_1V8 n64 address[18] data[18] n662 n671 AN22HDLLX0
XU187 n247 VSS n674 bst_addr[18] VDD_1V8 n65 AN21HDLLX0
XU186 n62 VSS n691 n134 n63 VDD_1V8 n592 ON211HDLLX0
XU185 VSS VDD_1V8 n62 address[20] data[20] n662 n671 AN22HDLLX0
XU184 n247 VSS n674 bst_addr[20] VDD_1V8 n63 AN21HDLLX0
XU183 n60 VSS n691 n137 n61 VDD_1V8 n593 ON211HDLLX0
XU182 VSS VDD_1V8 n60 address[21] data[21] n662 n671 AN22HDLLX0
XU181 n247 VSS n674 bst_addr[21] VDD_1V8 n61 AN21HDLLX0
XU180 n57 VSS n691 n190 n59 VDD_1V8 n621 ON211HDLLX0
XU179 VSS VDD_1V8 n57 address[5] data[5] n662 n671 AN22HDLLX0
XU178 n247 VSS n674 bst_addr[5] VDD_1V8 n59 AN21HDLLX0
XU177 n55 VSS n691 n140 n56 VDD_1V8 n594 ON211HDLLX0
XU176 VSS VDD_1V8 n55 address[22] data[22] n662 n671 AN22HDLLX0
XU175 n247 VSS n674 bst_addr[22] VDD_1V8 n56 AN21HDLLX0
XU174 n53 VSS n691 n110 n54 VDD_1V8 n584 ON211HDLLX0
XU173 VSS VDD_1V8 n53 address[12] data[12] n662 n671 AN22HDLLX0
XU172 n247 VSS n674 bst_addr[12] VDD_1V8 n54 AN21HDLLX0
XU171 n50 VSS n691 n143 n52 VDD_1V8 n595 ON211HDLLX0
XU170 VSS VDD_1V8 n50 address[23] data[23] n662 n671 AN22HDLLX0
XU169 n247 VSS n674 bst_addr[23] VDD_1V8 n52 AN21HDLLX0
XU168 n48 VSS n691 n122 n49 VDD_1V8 n588 ON211HDLLX0
XU167 VSS VDD_1V8 n48 address[16] data[16] n662 n671 AN22HDLLX0
XU166 n247 VSS n674 bst_addr[16] VDD_1V8 n49 AN21HDLLX0
XU165 n45 VSS n691 n119 n47 VDD_1V8 n587 ON211HDLLX0
XU164 VSS VDD_1V8 n45 address[15] data[15] n662 n671 AN22HDLLX0
XU163 n247 VSS n674 bst_addr[15] VDD_1V8 n47 AN21HDLLX0
XU162 n44 VSS n691 n178 n97 VDD_1V8 n617 ON211HDLLX0
XU161 VSS VDD_1V8 n44 address[1] data[1] n662 n671 AN22HDLLX0
XU160 n42 VSS n691 n98 n43 VDD_1V8 n580 ON211HDLLX0
XU159 VSS VDD_1V8 n42 address[8] data[8] n662 n671 AN22HDLLX0
XU158 n247 VSS n674 bst_addr[8] VDD_1V8 n43 AN21HDLLX0
XU157 n40 VSS n691 n116 n41 VDD_1V8 n586 ON211HDLLX0
XU156 VSS VDD_1V8 n40 address[14] data[14] n662 n671 AN22HDLLX0
XU155 n247 VSS n674 bst_addr[14] VDD_1V8 n41 AN21HDLLX0
XU154 n38 VSS n691 n113 n39 VDD_1V8 n585 ON211HDLLX0
XU153 VSS VDD_1V8 n38 address[13] data[13] n662 n671 AN22HDLLX0
XU152 n247 VSS n674 bst_addr[13] VDD_1V8 n39 AN21HDLLX0
XU151 n36 VSS n691 n200 n37 VDD_1V8 n623 ON211HDLLX0
XU150 VSS VDD_1V8 n36 address[7] data[7] n662 n671 AN22HDLLX0
XU149 n247 VSS n674 bst_addr[7] VDD_1V8 n37 AN21HDLLX0
XU148 n34 VSS n691 n101 n35 VDD_1V8 n581 ON211HDLLX0
XU147 VSS VDD_1V8 n34 address[9] data[9] n662 n671 AN22HDLLX0
XU146 n247 VSS n674 bst_addr[9] VDD_1V8 n35 AN21HDLLX0
XU145 n33 VSS n691 n175 n97 VDD_1V8 n616 ON211HDLLX0
XU144 VSS VDD_1V8 n33 address[0] data[0] n662 n671 AN22HDLLX0
XU143 n31 VSS n691 n107 n32 VDD_1V8 n583 ON211HDLLX0
XU142 VSS VDD_1V8 n31 address[11] data[11] n662 n671 AN22HDLLX0
XU141 n247 VSS n674 bst_addr[11] VDD_1V8 n32 AN21HDLLX0
XU140 n28 VSS n691 n193 n30 VDD_1V8 n622 ON211HDLLX0
XU139 VSS VDD_1V8 n28 address[6] data[6] n662 n671 AN22HDLLX0
XU138 n247 VSS n674 bst_addr[6] VDD_1V8 n30 AN21HDLLX0
XU137 n26 VSS n691 n181 n27 VDD_1V8 n618 ON211HDLLX0
XU136 VSS VDD_1V8 n26 address[2] data[2] n662 n671 AN22HDLLX0
XU135 n247 VSS n674 bst_addr[2] VDD_1V8 n27 AN21HDLLX0
XU134 n24 VSS n691 n131 n25 VDD_1V8 n591 ON211HDLLX0
XU133 VSS VDD_1V8 n24 address[19] data[19] n662 n671 AN22HDLLX0
XU132 n247 VSS n674 bst_addr[19] VDD_1V8 n25 AN21HDLLX0
XU131 n22 VSS n691 n125 n23 VDD_1V8 n589 ON211HDLLX0
XU130 VSS VDD_1V8 n22 address[17] data[17] n662 n671 AN22HDLLX0
XU129 n247 VSS n674 bst_addr[17] VDD_1V8 n23 AN21HDLLX0
XU128 n20 VSS n691 n187 n21 VDD_1V8 n620 ON211HDLLX0
XU127 VSS VDD_1V8 n20 address[4] data[4] n662 n671 AN22HDLLX0
XU126 n247 VSS n674 bst_addr[4] VDD_1V8 n21 AN21HDLLX0
XU125 n17 VSS n691 n184 n18 VDD_1V8 n619 ON211HDLLX0
XU124 VSS VDD_1V8 n17 address[3] data[3] n662 n671 AN22HDLLX0
XU122 VSS n242 n194 n223 VDD_1V8 NO2HDLLX0
XU121 VSS VDD_1V8 n223 n197 n315 NO2I1HDLLX0
XU120 VSS n315 VDD_1V8 index[2] n737 n650 ON21HDLLX0
XU118 n650 VSS VDD_1V8 index[0] INHDLLX0
XU116 n247 VSS n674 bst_addr[3] VDD_1V8 n18 AN21HDLLX0
XU114 n672 n679 VSS VDD_1V8 n16 n248 n176 NA4HDLLX1
XU113 VSS n316 n153 VDD_1V8 n679 NA2HDLLX0
XU112 VSS n153 n675 n655 VDD_1V8 NO2HDLLX0
XU111 VSS n317 n334 VDD_1V8 n655 NA2HDLLX0
XU110 VSS n334 n330 n319 VDD_1V8 NO2HDLLX0
XU309 VSS VDD_1V8 n204 tspi_data_tx[2] n214 data[26] n248 AN22HDLLX0
XU308 VSS n685 n203 VDD_1V8 n635 NA2HDLLX0
XU307 VSS VDD_1V8 n203 tspi_data_tx[3] n214 data[27] n248 AN22HDLLX0
XU306 VSS n685 n202 VDD_1V8 n636 NA2HDLLX0
XU305 VSS VDD_1V8 n202 tspi_data_tx[4] n214 data[28] n248 AN22HDLLX0
XU304 VSS n685 n201 VDD_1V8 n637 NA2HDLLX0
XU303 VSS VDD_1V8 n201 tspi_data_tx[5] n214 data[29] n248 AN22HDLLX0
XU302 VSS n685 n199 VDD_1V8 n638 NA2HDLLX0
XU301 VSS VDD_1V8 n199 tspi_data_tx[6] n214 data[30] n248 AN22HDLLX0
XU300 VSS n685 n198 VDD_1V8 n639 NA2HDLLX0
XU299 VSS VDD_1V8 n198 tspi_data_tx[7] n214 data[31] n248 AN22HDLLX0
XU297 n226 VSS index[2] n650 VDD_1V8 n197 NA3HDLLX0
XU294 VSS n225 n674 n194 VDD_1V8 NO2HDLLX0
XU293 VSS n191 n192 VDD_1V8 n186 n739 n246 n640 n189 ON222HDLLX0
XU292 VSS n183 n182 VDD_1V8 n641 NA2HDLLX0
XU290 n173 n172 VSS VDD_1V8 n174 n643 n176 NA4HDLLX0
XU289 VSS VDD_1V8 n172 n244 n171 n170 n169 AN211HDLLX0
XU288 n180 VSS n659 n167 n166 VDD_1V8 n169 ON211HDLLX0
XU287 VSS VDD_1V8 n166 n165 n652 n163 n162 AN211HDLLX0
XU286 VSS VDD_1V8 n173 n161 n160 n159 n239 AN211HDLLX0
XU285 n156 n155 VSS VDD_1V8 n157 n644 n158 NA4HDLLX0
XU284 n155 n152 n153 VSS VDD_1V8 n154 n177 AN31HDLLX0
XU283 VSS n302 n150 VDD_1V8 n174 n177 NA22HDLLX0
XU282 VSS VDD_1V8 n174 n149 n147 n146 n145 AN211HDLLX0
XU281 data_pop_58 VSS n144 data_pop_57 VDD_1V8 n147 AN21HDLLX0
XU280 VSS VDD_1V8 n156 n159 n142 n141 n139 AN211HDLLX0
XU279 n139 VSS VDD_1V8 n136 n135 n246 n138 ON22HDLLX0
XU278 VSS VDD_1V8 n157 n133 pndgn n132 n130 AN211HDLLX0
XU277 n127 n323 VSS VDD_1V8 n129 n645 n158 NA4HDLLX0
XU275 n176 VSS n246 n120 VDD_1V8 n121 AN21HDLLX0
XU274 VSS VDD_1V8 n123 n149 n144 n118 n675 AN211HDLLX0
XU273 n144 VSS VDD_1V8 n152 INHDLLX0
XU272 VSS n152 data_pop_59 n117 VDD_1V8 NO2HDLLX0
XU271 VSS VDD_1V8 n124 n150 pndgn n163 n652 AN22HDLLX0
XU269 n126 n115 n245 VSS VDD_1V8 n276 n114 AN31HDLLX0
XU268 n115 VSS VDD_1V8 n112 INHDLLX0
XU267 VSS VDD_1V8 n129 n133 n309 n146 n111 AN211HDLLX0
XU266 n186 VSS n244 n138 VDD_1V8 n111 AN21HDLLX0
XU265 VSS n109 n108 VDD_1V8 n138 AND2HDLLX0
XU264 n309 VSS VDD_1V8 pndgn INHDLLX0
XU263 VSS VDD_1V8 n171 n329 state_1_ n170 n246 n106 n158 AN321HDLLX0
XU262 VSS n170 n105 n660 VDD_1V8 NO2HDLLX0
XU261 n171 VSS VDD_1V8 n103 INHDLLX0
XU259 data[0] VSS VDD_1V8 data_pop[0] n313 n676 n646 AO22HDLLX1
XU258 VSS VDD_1V8 n313 n312 n311 OR2HDLLX0
XU257 VSS n109 n186 VDD_1V8 n312 NA2HDLLX0
XU256 address[0] VSS VDD_1V8 data_pop[32] n311 n676 n502 AO22HDLLX1
XU255 address[1] VSS VDD_1V8 data_pop[33] n311 n676 n501 AO22HDLLX1
XU253 VSS n102 n99 VDD_1V8 n100 n648 n311 NA4I2HDLLX0
XU250 VSS n672 n679 VDD_1V8 n96 NA2HDLLX0
XU247 n92 VSS n94 n135 n93 VDD_1V8 n642 ON211HDLLX0
XU246 n105 VSS n145 n305 VDD_1V8 n92 AN21HDLLX0
XU245 n238 VSS n244 n186 n327 VDD_1V8 n145 ON211HDLLX0
XU243 n86 n87 n89 VSS n88 VDD_1V8 OR3HDLLX0
XU242 VSS VDD_1V8 n84 n85 n82 n86 n83 NA4I3HDLLX0
XU241 VSS t_word[28] n82 t_word[31] VDD_1V8 t_word[29] t_word[30] AND4HDLLX0
XU240 t_word[26] t_word[27] VSS VDD_1V8 t_word[25] n83 t_word[24] NA4HDLLX0
XU239 t_word[22] t_word[23] VSS VDD_1V8 t_word[21] n84 t_word[20] NA4HDLLX0
XU238 t_word[18] t_word[19] VSS VDD_1V8 t_word[17] n85 t_word[16] NA4HDLLX0
XU237 t_word[14] t_word[15] VSS VDD_1V8 t_word[13] n87 t_word[12] NA4HDLLX0
XU236 t_word[10] t_word[11] VSS VDD_1V8 t_word[9] n88 t_word[8] NA4HDLLX0
XU235 t_word[6] t_word[7] VSS VDD_1V8 t_word[5] n90 t_word[4] NA4HDLLX0
XU234 t_word[2] t_word[3] VSS VDD_1V8 t_word[1] n91 n302 NA4HDLLX0
XU233 n135 VSS data_pop_59 n142 VDD_1V8 n149 NA3HDLLX0
XU232 n142 VSS VDD_1V8 n117 INHDLLX0
XU231 VSS data_pop_64 data_pop_63 VDD_1V8 n117 data_pop_62 NA3I2HDLLX0
XU230 n94 VSS VDD_1V8 n136 INHDLLX0
XU229 VSS data_pop_57 data_pop_58 VDD_1V8 n136 NA2HDLLX0
XU228 VSS n598 VDD_1V8 n81 n151 n691 ON21HDLLX0
XU227 n560 VSS VDD_1V8 n79 n301 n80 n300 ON22HDLLX0
XU226 VSS n305 n80 VDD_1V8 n79 NA2HDLLX0
XU225 n80 VSS VDD_1V8 bst_addr[21] INHDLLX0
XU224 n301 VSS n255 n305 VDD_1V8 n300 AN21HDLLX0
XU223 n109 n179 VSS VDD_1V8 n78 n255 n672 NA4HDLLX0
XU222 VSS n258 n106 VDD_1V8 n179 NA2HDLLX0
XU221 n78 VSS VDD_1V8 n102 n77 n693 NO3HDLLX0
XU220 VSS n75 n189 VDD_1V8 n310 n76 n77 NA4I2HDLLX0
XU219 n102 VSS n180 n669 VDD_1V8 n93 NA3HDLLX0
XU218 n180 VSS VDD_1V8 n74 INHDLLX0
XU216 n73 VDD_1V8 n72 VSS n154 n141 OA21HDLLX0
XU215 VSS n245 n233 VDD_1V8 n154 AND2HDLLX0
XU214 n323 VSS VDD_1V8 n330 INHDLLX0
XU213 VSS VDD_1V8 n183 n71 n70 n69 n194 AN211HDLLX0
XU212 VSS VDD_1V8 n70 n233 n245 NO2I1HDLLX0
XU211 VSS n316 n679 VDD_1V8 n314 NA2HDLLX0
XU210 n301 VSS n299 VDD_1V8 bst_addr[20] NA2I1HDLLX0
XU209 VSS bst_addr[19] n295 VDD_1V8 n299 NA2HDLLX0
XU208 VSS VDD_1V8 n295 bst_addr[18] n293 NO2I1HDLLX0
XU207 VSS bst_addr[17] n289 VDD_1V8 n293 NA2HDLLX0
XU403 VSS n285 VDD_1V8 n694 n660 n284 ON21HDLLX0
XU402 VSS n567 VDD_1V8 n283 n282 n660 bst_addr[14] ON31HDLLX0
XU401 VSS n282 VDD_1V8 bst_addr[14] n280 n281 ON21HDLLX0
XU400 bst_addr[13] VSS VDD_1V8 n279 n280 n281 n568 AO22HDLLX1
XU399 VSS n281 bst_addr[13] n660 VDD_1V8 NO2HDLLX0
XU398 VSS n280 VDD_1V8 n694 n660 n279 ON21HDLLX0
XU397 VSS n569 VDD_1V8 n278 n277 n660 bst_addr[12] ON31HDLLX0
XU396 VSS n277 VDD_1V8 bst_addr[12] n274 n275 ON21HDLLX0
XU395 bst_addr[11] VSS VDD_1V8 n273 n274 n275 n570 AO22HDLLX1
XU394 VSS n275 bst_addr[11] n660 VDD_1V8 NO2HDLLX0
XU393 VSS n274 VDD_1V8 n694 n660 n273 ON21HDLLX0
XU392 VSS n571 VDD_1V8 n272 n271 n660 bst_addr[10] ON31HDLLX0
XU391 VSS n271 VDD_1V8 bst_addr[10] n269 n270 ON21HDLLX0
XU390 bst_addr[9] VSS VDD_1V8 n268 n269 n270 n572 AO22HDLLX1
XU389 VSS n270 bst_addr[9] n660 VDD_1V8 NO2HDLLX0
XU388 VSS n269 VDD_1V8 n694 n660 n268 ON21HDLLX0
XU387 VSS n573 VDD_1V8 n267 n266 n660 bst_addr[8] ON31HDLLX0
XU386 VSS n266 VDD_1V8 bst_addr[8] n264 n265 ON21HDLLX0
XU385 bst_addr[7] VSS VDD_1V8 n263 n264 n265 n574 AO22HDLLX1
XU384 VSS n265 bst_addr[7] n660 VDD_1V8 NO2HDLLX0
XU383 VSS n264 VDD_1V8 n694 n660 n263 ON21HDLLX0
XU382 n575 VSS VDD_1V8 n260 n259 bst_addr[6] n261 n262 AN32HDLLX0
XU381 VSS n257 n660 VDD_1V8 n260 bst_addr[5] NA3I2HDLLX0
XU380 n576 VSS VDD_1V8 n257 n261 n256 n262 ON22HDLLX0
XU379 VSS n305 n256 VDD_1V8 n261 NA2HDLLX0
XU378 n257 VSS n255 n305 VDD_1V8 n262 AN21HDLLX0
XU377 n577 VSS VDD_1V8 n252 n251 bst_addr[4] n253 n254 AN32HDLLX0
XU376 n251 VSS VDD_1V8 bst_addr[4] INHDLLX0
XU375 n252 VSS bst_addr[3] bst_addr[2] VDD_1V8 n305 NA3HDLLX0
XU374 n578 VSS VDD_1V8 n249 n253 n250 n254 ON22HDLLX0
XU373 VSS n305 n250 VDD_1V8 n253 NA2HDLLX0
XU372 n250 VSS VDD_1V8 bst_addr[3] INHDLLX0
XU371 n249 VSS n255 n305 VDD_1V8 n254 AN21HDLLX0
XU370 VSS VDD_1V8 n579 n660 n694 bst_addr[2] n249 AN22HDLLX0
XU369 n249 VSS VDD_1V8 bst_addr[2] INHDLLX0
XU367 n247 VSS n684 n248 VDD_1V8 tspi_data_tx[56] n596 AO211HDLLX0
XU366 VSS n597 VDD_1V8 n243 n148 n691 ON21HDLLX0
XU364 VSS n248 tspi_data_tx[61] VDD_1V8 n238 n599 NA22HDLLX0
XU363 VSS n685 n236 VDD_1V8 n600 NA2HDLLX0
XU362 VSS VDD_1V8 n236 tspi_data_tx[16] n235 data[8] n248 AN22HDLLX0
XU361 VSS n685 n234 VDD_1V8 n601 NA2HDLLX0
XU360 VSS VDD_1V8 n234 tspi_data_tx[17] n235 data[9] n248 AN22HDLLX0
XU359 VSS n685 n232 VDD_1V8 n602 NA2HDLLX0
XU358 VSS VDD_1V8 n232 tspi_data_tx[18] n235 data[10] n248 AN22HDLLX0
XU357 VSS n685 n231 VDD_1V8 n603 NA2HDLLX0
XU356 VSS VDD_1V8 n231 tspi_data_tx[19] n235 data[11] n248 AN22HDLLX0
XU355 VSS n685 n230 VDD_1V8 n604 NA2HDLLX0
XU354 VSS VDD_1V8 n230 tspi_data_tx[20] n235 data[12] n248 AN22HDLLX0
XU353 VSS n685 n229 VDD_1V8 n605 NA2HDLLX0
XU352 VSS VDD_1V8 n229 tspi_data_tx[21] n235 data[13] n248 AN22HDLLX0
XU351 VSS n685 n228 VDD_1V8 n606 NA2HDLLX0
XU350 VSS VDD_1V8 n228 tspi_data_tx[22] n235 data[14] n248 AN22HDLLX0
XU349 VSS n685 n227 VDD_1V8 n607 NA2HDLLX0
XU348 VSS VDD_1V8 n227 tspi_data_tx[23] n235 data[15] n248 AN22HDLLX0
XU347 n235 VSS VDD_1V8 n226 INHDLLX0
XU346 VSS n225 n224 VDD_1V8 n608 NA2HDLLX0
XU345 VSS VDD_1V8 n224 tspi_data_tx[24] n223 data[0] n248 AN22HDLLX0
XU344 VSS n225 n222 VDD_1V8 n609 NA2HDLLX0
XU343 VSS VDD_1V8 n222 tspi_data_tx[25] n223 data[1] n248 AN22HDLLX0
XU342 VSS n225 n221 VDD_1V8 n610 NA2HDLLX0
XU341 VSS VDD_1V8 n221 tspi_data_tx[26] n223 data[2] n248 AN22HDLLX0
XU340 VSS n225 n220 VDD_1V8 n611 NA2HDLLX0
XU339 VSS VDD_1V8 n220 tspi_data_tx[27] n223 data[3] n248 AN22HDLLX0
XU338 VSS n225 n219 VDD_1V8 n612 NA2HDLLX0
XU337 VSS VDD_1V8 n219 tspi_data_tx[28] n223 data[4] n248 AN22HDLLX0
XU336 VSS n225 n218 VDD_1V8 n613 NA2HDLLX0
XU335 VSS VDD_1V8 n218 tspi_data_tx[29] n223 data[5] n248 AN22HDLLX0
XU334 VSS n225 n217 VDD_1V8 n614 NA2HDLLX0
XU333 VSS VDD_1V8 n217 tspi_data_tx[30] n223 data[6] n248 AN22HDLLX0
XU332 VSS n225 n216 VDD_1V8 n615 NA2HDLLX0
XU331 VSS VDD_1V8 n216 tspi_data_tx[31] n223 data[7] n248 AN22HDLLX0
XU330 VSS n685 n215 VDD_1V8 n624 NA2HDLLX0
XU329 VSS VDD_1V8 n215 tspi_data_tx[8] n214 data[16] n248 AN22HDLLX0
XU328 VSS n685 n213 VDD_1V8 n625 NA2HDLLX0
XU327 VSS VDD_1V8 n213 tspi_data_tx[9] n214 data[17] n248 AN22HDLLX0
XU326 VSS n685 n212 VDD_1V8 n626 NA2HDLLX0
XU325 VSS VDD_1V8 n212 tspi_data_tx[10] n214 data[18] n248 AN22HDLLX0
XU324 VSS n685 n211 VDD_1V8 n627 NA2HDLLX0
XU323 VSS VDD_1V8 n211 tspi_data_tx[11] n214 data[19] n248 AN22HDLLX0
XU322 VSS n685 n210 VDD_1V8 n628 NA2HDLLX0
XU321 VSS VDD_1V8 n210 tspi_data_tx[12] n214 data[20] n248 AN22HDLLX0
XU320 VSS n685 n209 VDD_1V8 n629 NA2HDLLX0
XU319 VSS VDD_1V8 n209 tspi_data_tx[13] n214 data[21] n248 AN22HDLLX0
XU318 VSS n685 n208 VDD_1V8 n630 NA2HDLLX0
XU317 VSS VDD_1V8 n208 tspi_data_tx[14] n214 data[22] n248 AN22HDLLX0
XU316 VSS n685 n207 VDD_1V8 n631 NA2HDLLX0
XU315 VSS VDD_1V8 n207 tspi_data_tx[15] n214 data[23] n248 AN22HDLLX0
XU314 VSS n685 n206 VDD_1V8 n632 NA2HDLLX0
XU313 VSS VDD_1V8 n206 tspi_data_tx[0] n214 data[24] n248 AN22HDLLX0
XU312 VSS n685 n205 VDD_1V8 n633 NA2HDLLX0
XU311 VSS VDD_1V8 n205 tspi_data_tx[1] n214 data[25] n248 AN22HDLLX0
XU310 VSS n685 n204 VDD_1V8 n634 NA2HDLLX0
XU496 VSS n485 data_pop[49] bst_addr[17] address[17] n312 VDD_1V8 n676 n311 AO222HDLLX0
XU495 VSS n486 data_pop[48] bst_addr[16] address[16] n312 VDD_1V8 n680 n311 AO222HDLLX0
XU494 VSS n487 data_pop[47] bst_addr[15] address[15] n312 VDD_1V8 n680 n311 AO222HDLLX0
XU493 VSS n488 data_pop[46] bst_addr[14] address[14] n312 VDD_1V8 n676 n311 AO222HDLLX0
XU492 VSS n489 data_pop[45] bst_addr[13] address[13] n312 VDD_1V8 n680 n311 AO222HDLLX0
XU491 VSS n490 data_pop[44] bst_addr[12] address[12] n312 VDD_1V8 n680 n311 AO222HDLLX0
XU490 VSS n491 data_pop[43] bst_addr[11] address[11] n312 VDD_1V8 n680 n311 AO222HDLLX0
XU489 VSS n492 data_pop[42] bst_addr[10] address[10] n312 VDD_1V8 n680 n311 AO222HDLLX0
XU488 VSS n493 data_pop[41] bst_addr[9] address[9] n312 VDD_1V8 n680 n311 AO222HDLLX0
XU487 VSS n494 data_pop[40] bst_addr[8] address[8] n312 VDD_1V8 n680 n311 AO222HDLLX0
XU486 VSS n495 data_pop[39] bst_addr[7] address[7] n312 VDD_1V8 n680 n311 AO222HDLLX0
XU485 VSS n496 data_pop[38] bst_addr[6] address[6] n312 VDD_1V8 n680 n311 AO222HDLLX0
XU484 VSS n497 data_pop[37] bst_addr[5] address[5] n312 VDD_1V8 n680 n311 AO222HDLLX0
XU483 VSS n498 data_pop[36] bst_addr[4] address[4] n312 VDD_1V8 n680 n311 AO222HDLLX0
XU482 VSS n499 data_pop[35] bst_addr[3] address[3] n312 VDD_1V8 n680 n311 AO222HDLLX0
XU481 VSS n500 data_pop[34] bst_addr[2] address[2] n312 VDD_1V8 n680 n311 AO222HDLLX0
XU480 D_pop[54] VSS VDD_1V8 data_pop[54] n677 n314 n503 AO22HDLLX1
XU479 D_pop[53] VSS VDD_1V8 data_pop[53] n682 n693 n504 AO22HDLLX1
XU478 D_pop[52] VSS VDD_1V8 data_pop[52] n677 n314 n505 AO22HDLLX1
XU477 D_pop[51] VSS VDD_1V8 data_pop[51] n677 n314 n506 AO22HDLLX1
XU476 D_pop[50] VSS VDD_1V8 data_pop[50] n682 n693 n507 AO22HDLLX1
XU475 D_pop[49] VSS VDD_1V8 data_pop[49] n682 n693 n508 AO22HDLLX1
XU474 D_pop[48] VSS VDD_1V8 data_pop[48] n682 n693 n509 AO22HDLLX1
XU473 D_pop[47] VSS VDD_1V8 data_pop[47] n682 n693 n510 AO22HDLLX1
XU472 D_pop[46] VSS VDD_1V8 data_pop[46] n677 n314 n511 AO22HDLLX1
XU471 D_pop[45] VSS VDD_1V8 data_pop[45] n682 n693 n512 AO22HDLLX1
XU470 D_pop[44] VSS VDD_1V8 data_pop[44] n682 n693 n513 AO22HDLLX1
XU469 D_pop[43] VSS VDD_1V8 data_pop[43] n682 n693 n514 AO22HDLLX1
XU468 D_pop[42] VSS VDD_1V8 data_pop[42] n682 n693 n515 AO22HDLLX1
XU467 D_pop[41] VSS VDD_1V8 data_pop[41] n682 n693 n516 AO22HDLLX1
XU466 D_pop[40] VSS VDD_1V8 data_pop[40] n682 n693 n517 AO22HDLLX1
XU465 D_pop[39] VSS VDD_1V8 data_pop[39] n682 n693 n518 AO22HDLLX1
XU464 D_pop[38] VSS VDD_1V8 data_pop[38] n682 n693 n519 AO22HDLLX1
XU463 D_pop[37] VSS VDD_1V8 data_pop[37] n682 n693 n520 AO22HDLLX1
XU462 D_pop[36] VSS VDD_1V8 data_pop[36] n682 n693 n521 AO22HDLLX1
XU461 D_pop[35] VSS VDD_1V8 data_pop[35] n682 n693 n522 AO22HDLLX1
XU460 D_pop[34] VSS VDD_1V8 data_pop[34] n682 n693 n523 AO22HDLLX1
XU459 D_pop[33] VSS VDD_1V8 data_pop[33] n682 n314 n524 AO22HDLLX1
XU458 D_pop[32] VSS VDD_1V8 data_pop[32] n677 n693 n525 AO22HDLLX1
XU457 D_pop[31] VSS VDD_1V8 data_pop[31] n677 n314 n526 AO22HDLLX1
XU456 D_pop[30] VSS VDD_1V8 data_pop[30] n677 n314 n527 AO22HDLLX1
XU455 D_pop[29] VSS VDD_1V8 data_pop[29] n677 n314 n528 AO22HDLLX1
XU454 D_pop[28] VSS VDD_1V8 data_pop[28] n677 n314 n529 AO22HDLLX1
XU453 D_pop[27] VSS VDD_1V8 data_pop[27] n677 n314 n530 AO22HDLLX1
XU452 D_pop[26] VSS VDD_1V8 data_pop[26] n677 n314 n531 AO22HDLLX1
XU451 D_pop[25] VSS VDD_1V8 data_pop[25] n682 n314 n532 AO22HDLLX1
XU450 D_pop[24] VSS VDD_1V8 data_pop[24] n682 n693 n533 AO22HDLLX1
XU449 D_pop[23] VSS VDD_1V8 data_pop[23] n682 n314 n534 AO22HDLLX1
XU448 D_pop[22] VSS VDD_1V8 data_pop[22] n677 n314 n535 AO22HDLLX1
XU447 D_pop[21] VSS VDD_1V8 data_pop[21] n677 n314 n536 AO22HDLLX1
XU446 D_pop[20] VSS VDD_1V8 data_pop[20] n677 n693 n537 AO22HDLLX1
XU445 D_pop[19] VSS VDD_1V8 data_pop[19] n677 n314 n538 AO22HDLLX1
XU444 D_pop[18] VSS VDD_1V8 data_pop[18] n677 n314 n539 AO22HDLLX1
XU443 D_pop[17] VSS VDD_1V8 data_pop[17] n677 n693 n540 AO22HDLLX1
XU442 D_pop[16] VSS VDD_1V8 data_pop[16] n682 n314 n541 AO22HDLLX1
XU441 D_pop[15] VSS VDD_1V8 data_pop[15] n682 n693 n542 AO22HDLLX1
XU440 D_pop[14] VSS VDD_1V8 data_pop[14] n677 n314 n543 AO22HDLLX1
XU439 D_pop[13] VSS VDD_1V8 data_pop[13] n682 n693 n544 AO22HDLLX1
XU438 D_pop[12] VSS VDD_1V8 data_pop[12] n677 n314 n545 AO22HDLLX1
XU437 D_pop[11] VSS VDD_1V8 data_pop[11] n677 n314 n546 AO22HDLLX1
XU436 D_pop[10] VSS VDD_1V8 data_pop[10] n677 n314 n547 AO22HDLLX1
XU435 D_pop[9] VSS VDD_1V8 data_pop[9] n677 n314 n548 AO22HDLLX1
XU434 D_pop[8] VSS VDD_1V8 data_pop[8] n677 n314 n549 AO22HDLLX1
XU433 D_pop[7] VSS VDD_1V8 data_pop[7] n682 n693 n550 AO22HDLLX1
XU432 D_pop[6] VSS VDD_1V8 data_pop[6] n682 n314 n551 AO22HDLLX1
XU431 D_pop[5] VSS VDD_1V8 data_pop[5] n682 n693 n552 AO22HDLLX1
XU430 D_pop[4] VSS VDD_1V8 data_pop[4] n677 n314 n553 AO22HDLLX1
XU429 D_pop[3] VSS VDD_1V8 data_pop[3] n682 n693 n554 AO22HDLLX1
XU428 D_pop[2] VSS VDD_1V8 data_pop[2] n677 n693 n555 AO22HDLLX1
XU427 D_pop[1] VSS VDD_1V8 data_pop[1] n677 n314 n556 AO22HDLLX1
XU426 D_pop[0] VSS VDD_1V8 data_pop[0] n677 n314 n557 AO22HDLLX1
XU425 VSS n677 n310 n309 VDD_1V8 NO2HDLLX1
XU424 VSS n558 VDD_1V8 n307 n306 n308 bst_addr[23] ON31HDLLX0
XU423 n306 VSS VDD_1V8 n304 bst_addr[23] bst_addr[23] n308 n305 AN32HDLLX0
XU422 VSS VDD_1V8 n559 n307 n303 bst_addr[22] n308 AN22HDLLX0
XU421 n308 VSS VDD_1V8 bst_addr[22] INHDLLX0
XU420 VSS n301 n660 VDD_1V8 n307 bst_addr[21] NA3I2HDLLX0
XU419 n303 VSS VDD_1V8 n304 INHDLLX0
XU418 VSS n304 VDD_1V8 n300 n660 bst_addr[21] ON21HDLLX0
XU417 VSS n561 VDD_1V8 n299 n298 n660 bst_addr[20] ON31HDLLX0
XU416 VSS n298 VDD_1V8 bst_addr[20] n296 n297 ON21HDLLX0
XU415 bst_addr[19] VSS VDD_1V8 n295 n296 n297 n562 AO22HDLLX1
XU414 VSS n297 bst_addr[19] n660 VDD_1V8 NO2HDLLX0
XU413 VSS n296 VDD_1V8 n694 n660 n295 ON21HDLLX0
XU412 VSS n563 VDD_1V8 n293 n292 n660 bst_addr[18] ON31HDLLX0
XU411 VSS n292 VDD_1V8 bst_addr[18] n290 n291 ON21HDLLX0
XU410 bst_addr[17] VSS VDD_1V8 n289 n290 n291 n564 AO22HDLLX1
XU409 VSS n291 bst_addr[17] n660 VDD_1V8 NO2HDLLX0
XU408 VSS n290 VDD_1V8 n694 n660 n289 ON21HDLLX0
XU407 VSS n565 VDD_1V8 n288 n287 n660 bst_addr[16] ON31HDLLX0
XU406 VSS n287 VDD_1V8 bst_addr[16] n285 n286 ON21HDLLX0
XU405 bst_addr[15] VSS VDD_1V8 n284 n285 n286 n566 AO22HDLLX1
XU404 VSS n286 bst_addr[15] n660 VDD_1V8 NO2HDLLX0
XU590 data_read[30] VSS VDD_1V8 t_word[30] n649 n648 n401 AO22HDLLX1
XU589 data_read[29] VSS VDD_1V8 t_word[29] n649 n648 n402 AO22HDLLX1
XU588 data_read[28] VSS VDD_1V8 t_word[28] n649 n648 n403 AO22HDLLX1
XU587 data_read[27] VSS VDD_1V8 t_word[27] n649 n648 n404 AO22HDLLX1
XU586 data_read[26] VSS VDD_1V8 t_word[26] n649 n648 n405 AO22HDLLX1
XU585 data_read[25] VSS VDD_1V8 t_word[25] n649 n648 n406 AO22HDLLX1
XU584 data_read[24] VSS VDD_1V8 t_word[24] n649 n648 n407 AO22HDLLX1
XU583 data_read[23] VSS VDD_1V8 t_word[23] n649 n648 n408 AO22HDLLX1
XU582 data_read[22] VSS VDD_1V8 t_word[22] n649 n648 n409 AO22HDLLX1
XU581 data_read[21] VSS VDD_1V8 t_word[21] n649 n648 n410 AO22HDLLX1
XU580 data_read[20] VSS VDD_1V8 t_word[20] n649 n648 n411 AO22HDLLX1
XU579 data_read[19] VSS VDD_1V8 t_word[19] n649 n648 n412 AO22HDLLX1
XU578 data_read[18] VSS VDD_1V8 t_word[18] n649 n648 n413 AO22HDLLX1
XU577 data_read[17] VSS VDD_1V8 t_word[17] n649 n648 n414 AO22HDLLX1
XU576 data_read[16] VSS VDD_1V8 t_word[16] n649 n648 n415 AO22HDLLX1
XU575 data_read[15] VSS VDD_1V8 t_word[15] n649 n648 n416 AO22HDLLX1
XU574 data_read[14] VSS VDD_1V8 t_word[14] n649 n648 n417 AO22HDLLX1
XU573 data_read[13] VSS VDD_1V8 t_word[13] n649 n648 n418 AO22HDLLX1
XU572 data_read[12] VSS VDD_1V8 t_word[12] n649 n648 n419 AO22HDLLX1
XU571 data_read[11] VSS VDD_1V8 t_word[11] n649 n648 n420 AO22HDLLX1
XU570 data_read[10] VSS VDD_1V8 t_word[10] n649 n648 n421 AO22HDLLX1
XU569 data_read[9] VSS VDD_1V8 t_word[9] n649 n648 n422 AO22HDLLX1
XU568 data_read[8] VSS VDD_1V8 t_word[8] n649 n648 n423 AO22HDLLX1
XU567 data_read[7] VSS VDD_1V8 t_word[7] n649 n648 n424 AO22HDLLX1
XU566 data_read[6] VSS VDD_1V8 t_word[6] n649 n648 n425 AO22HDLLX1
XU565 data_read[5] VSS VDD_1V8 t_word[5] n649 n648 n426 AO22HDLLX1
XU564 data_read[4] VSS VDD_1V8 t_word[4] n649 n648 n427 AO22HDLLX1
XU563 data_read[3] VSS VDD_1V8 t_word[3] n649 n648 n428 AO22HDLLX1
XU562 data_read[2] VSS VDD_1V8 t_word[2] n649 n648 n429 AO22HDLLX1
XU561 data_read[1] VSS VDD_1V8 t_word[1] n649 n648 n430 AO22HDLLX1
XU560 data_read[0] VSS VDD_1V8 n302 n649 n648 n431 AO22HDLLX1
XU558 n673 VSS VDD_1V8 n337 tspi_send_data n432 AO21HDLLX0
XU557 VSS VDD_1V8 n433 n46 n334 n335 n333 AN22HDLLX0
XU556 VSS tspi_config_en n673 VDD_1V8 n334 n434 NA22HDLLX0
XU555 n673 VSS VDD_1V8 n679 INHDLLX0
XU554 n331 VSS n335 n51 n332 VDD_1V8 n435 ON211HDLLX0
XU553 n737 n650 VSS VDD_1V8 index[2] n331 n330 NA4HDLLX0
XU552 n335 VSS VDD_1V8 n333 INHDLLX0
XU551 n436 VSS n327 n326 VDD_1V8 n328 NA3HDLLX0
XU550 n333 VSS n325 tspi_data_config[13] VDD_1V8 n328 AN21HDLLX0
XU549 n325 VSS n324 n333 VDD_1V8 tspi_data_config[12] n437 AO211HDLLX0
XU548 n325 VSS VDD_1V8 n737 n333 n323 NO3HDLLX0
XU547 n326 n320 VSS VDD_1V8 n321 n438 n322 NA4HDLLX0
XU546 n320 VSS n58 VDD_1V8 n333 NA2I1HDLLX0
XU545 VSS n333 VDD_1V8 n679 n318 n319 ON21HDLLX0
XU544 n672 n315 VSS VDD_1V8 n316 n318 n317 NA4HDLLX0
XU543 index[2] n737 VSS VDD_1V8 n330 n326 index[0] NA4HDLLX0
XU542 D_pop[64] VSS VDD_1V8 data_pop_64 n677 n693 n439 AO22HDLLX1
XU541 D_pop[63] VSS VDD_1V8 data_pop_63 n677 n314 n440 AO22HDLLX1
XU540 D_pop[62] VSS VDD_1V8 data_pop_62 n677 n693 n441 AO22HDLLX1
XU539 index[2] VSS VDD_1V8 data_pop_59 n313 n680 n442 AO22HDLLX1
XU538 index[1] VSS VDD_1V8 data_pop_58 n313 n680 n443 AO22HDLLX1
XU537 index[0] VSS VDD_1V8 data_pop_57 n313 n680 n444 AO22HDLLX1
XU536 data[31] VSS VDD_1V8 data_pop[31] n313 n676 n445 AO22HDLLX1
XU535 data[30] VSS VDD_1V8 data_pop[30] n313 n676 n446 AO22HDLLX1
XU534 data[29] VSS VDD_1V8 data_pop[29] n313 n676 n447 AO22HDLLX1
XU533 data[28] VSS VDD_1V8 data_pop[28] n313 n676 n448 AO22HDLLX1
XU532 data[27] VSS VDD_1V8 data_pop[27] n313 n676 n449 AO22HDLLX1
XU531 data[26] VSS VDD_1V8 data_pop[26] n313 n676 n450 AO22HDLLX1
XU530 data[25] VSS VDD_1V8 data_pop[25] n313 n676 n451 AO22HDLLX1
XU529 data[24] VSS VDD_1V8 data_pop[24] n313 n676 n452 AO22HDLLX1
XU528 data[23] VSS VDD_1V8 data_pop[23] n313 n676 n453 AO22HDLLX1
XU527 data[22] VSS VDD_1V8 data_pop[22] n313 n676 n454 AO22HDLLX1
XU526 data[21] VSS VDD_1V8 data_pop[21] n313 n676 n455 AO22HDLLX1
XU525 data[20] VSS VDD_1V8 data_pop[20] n313 n676 n456 AO22HDLLX1
XU524 data[19] VSS VDD_1V8 data_pop[19] n313 n676 n457 AO22HDLLX1
XU523 data[18] VSS VDD_1V8 data_pop[18] n313 n676 n458 AO22HDLLX1
XU522 data[17] VSS VDD_1V8 data_pop[17] n313 n676 n459 AO22HDLLX1
XU521 data[16] VSS VDD_1V8 data_pop[16] n313 n676 n460 AO22HDLLX1
XU520 data[15] VSS VDD_1V8 data_pop[15] n313 n676 n461 AO22HDLLX1
XU519 data[14] VSS VDD_1V8 data_pop[14] n313 n676 n462 AO22HDLLX1
XU518 data[13] VSS VDD_1V8 data_pop[13] n313 n676 n463 AO22HDLLX1
XU517 data[12] VSS VDD_1V8 data_pop[12] n313 n676 n464 AO22HDLLX1
XU516 data[11] VSS VDD_1V8 data_pop[11] n313 n676 n465 AO22HDLLX1
XU515 data[10] VSS VDD_1V8 data_pop[10] n313 n676 n466 AO22HDLLX1
XU514 data[9] VSS VDD_1V8 data_pop[9] n313 n676 n467 AO22HDLLX1
XU513 data[8] VSS VDD_1V8 data_pop[8] n313 n676 n468 AO22HDLLX1
XU512 data[7] VSS VDD_1V8 data_pop[7] n313 n680 n469 AO22HDLLX1
XU511 data[6] VSS VDD_1V8 data_pop[6] n313 n676 n470 AO22HDLLX1
XU510 data[5] VSS VDD_1V8 data_pop[5] n313 n676 n471 AO22HDLLX1
XU509 data[4] VSS VDD_1V8 data_pop[4] n313 n676 n472 AO22HDLLX1
XU508 data[3] VSS VDD_1V8 data_pop[3] n313 n680 n473 AO22HDLLX1
XU507 data[2] VSS VDD_1V8 data_pop[2] n313 n676 n474 AO22HDLLX1
XU506 data[1] VSS VDD_1V8 data_pop[1] n313 n676 n475 AO22HDLLX1
XU505 D_pop[59] VSS VDD_1V8 data_pop_59 n682 n693 n476 AO22HDLLX1
XU504 D_pop[58] VSS VDD_1V8 data_pop_58 n682 n693 n477 AO22HDLLX1
XU503 D_pop[57] VSS VDD_1V8 data_pop_57 n682 n693 n478 AO22HDLLX1
XU502 bst_addr[23] VSS VDD_1V8 address[23] n312 n311 n479 AO22HDLLX1
XU501 VSS n480 data_pop[54] bst_addr[22] address[22] n312 VDD_1V8 n676 n311 AO222HDLLX0
XU500 VSS n481 data_pop[53] bst_addr[21] address[21] n312 VDD_1V8 n680 n311 AO222HDLLX0
XU499 VSS n482 data_pop[52] bst_addr[20] address[20] n312 VDD_1V8 n676 n311 AO222HDLLX0
XU498 VSS n483 data_pop[51] bst_addr[19] address[19] n312 VDD_1V8 n676 n311 AO222HDLLX0
XU497 VSS n484 data_pop[50] bst_addr[18] address[18] n312 VDD_1V8 n676 n311 AO222HDLLX0
XU620 VSS n661 VDD_1V8 n670 n668 index[1] ON21HDLLX2
XU298 VSS n214 index[1] n226 VDD_1V8 NO2HDLLX0
XU600 VSS VDD_1V8 n663 n656 n688 NO2I1HDLLX2
XU670 VSS n336 VDD_1V8 n683 n679 n19 ON21HDLLX0
XU668 VSS VDD_1V8 D_push[60] n675 n686 n687 n338 OA22HDLLX0
XU667 VSS push n673 VDD_1V8 n672 n339 NA22HDLLX0
XU666 VSS D_push[59] n688 VDD_1V8 n670 n340 NA22HDLLX0
XU665 VSS n341 VDD_1V8 n667 n668 n737 ON21HDLLX0
XU664 D_push[58] VSS n666 n688 VDD_1V8 n667 AN21HDLLX0
XU663 VSS D_push[57] n688 VDD_1V8 n665 n342 NA22HDLLX0
XU662 VSS VDD_1V8 n343 n664 n29 n688 n689 AN22HDLLX0
XU661 address[23] VSS VDD_1V8 n688 n663 D_push[55] n344 AO22HDLLX1
XU660 address[22] VSS VDD_1V8 n688 n663 D_push[54] n345 AO22HDLLX1
XU659 address[21] VSS VDD_1V8 n688 n663 D_push[53] n346 AO22HDLLX1
XU658 address[20] VSS VDD_1V8 n688 n663 D_push[52] n347 AO22HDLLX1
XU657 address[19] VSS VDD_1V8 n688 n663 D_push[51] n348 AO22HDLLX1
XU656 address[18] VSS VDD_1V8 n688 n663 D_push[50] n349 AO22HDLLX1
XU655 address[17] VSS VDD_1V8 n688 n663 D_push[49] n350 AO22HDLLX1
XU654 address[16] VSS VDD_1V8 n688 n663 D_push[48] n351 AO22HDLLX1
XU653 address[15] VSS VDD_1V8 n688 n663 D_push[47] n352 AO22HDLLX1
XU652 address[14] VSS VDD_1V8 n688 n663 D_push[46] n353 AO22HDLLX1
XU651 address[13] VSS VDD_1V8 n688 n663 D_push[45] n354 AO22HDLLX1
XU650 address[12] VSS VDD_1V8 n688 n663 D_push[44] n355 AO22HDLLX1
XU649 address[11] VSS VDD_1V8 n688 n663 D_push[43] n356 AO22HDLLX1
XU648 address[10] VSS VDD_1V8 n688 n663 D_push[42] n357 AO22HDLLX1
XU647 address[9] VSS VDD_1V8 n688 n663 D_push[41] n358 AO22HDLLX1
XU646 address[8] VSS VDD_1V8 n688 n663 D_push[40] n359 AO22HDLLX1
XU645 address[7] VSS VDD_1V8 n688 n663 D_push[39] n360 AO22HDLLX1
XU644 address[6] VSS VDD_1V8 n688 n663 D_push[38] n361 AO22HDLLX1
XU643 address[5] VSS VDD_1V8 n688 n663 D_push[37] n362 AO22HDLLX1
XU642 address[4] VSS VDD_1V8 n688 n663 D_push[36] n363 AO22HDLLX1
XU641 address[3] VSS VDD_1V8 n688 n663 D_push[35] n364 AO22HDLLX1
XU640 address[2] VSS VDD_1V8 n688 n663 D_push[34] n365 AO22HDLLX1
XU639 address[1] VSS VDD_1V8 n688 n663 D_push[33] n366 AO22HDLLX1
XU638 address[0] VSS VDD_1V8 n688 n663 D_push[32] n367 AO22HDLLX1
XU637 t_word[7] VSS VDD_1V8 n686 n661 D_push[31] n368 AO22HDLLX1
XU636 t_word[6] VSS VDD_1V8 n686 n661 D_push[30] n369 AO22HDLLX1
XU635 t_word[5] VSS VDD_1V8 n686 n661 D_push[29] n370 AO22HDLLX1
XU634 t_word[4] VSS VDD_1V8 n686 n661 D_push[28] n371 AO22HDLLX1
XU632 t_word[3] VSS VDD_1V8 n686 n661 D_push[27] n372 AO22HDLLX1
XU631 t_word[2] VSS VDD_1V8 n686 n661 D_push[26] n373 AO22HDLLX1
XU630 t_word[1] VSS VDD_1V8 n686 n661 D_push[25] n374 AO22HDLLX1
XU629 n302 VSS VDD_1V8 n686 n661 D_push[24] n375 AO22HDLLX1
XU628 t_word[15] VSS VDD_1V8 n686 n661 D_push[23] n376 AO22HDLLX1
XU627 t_word[14] VSS VDD_1V8 n686 n661 D_push[22] n377 AO22HDLLX1
XU626 t_word[13] VSS VDD_1V8 n686 n661 D_push[21] n378 AO22HDLLX1
XU625 t_word[12] VSS VDD_1V8 n686 n661 D_push[20] n379 AO22HDLLX1
XU624 t_word[11] VSS VDD_1V8 n686 n661 D_push[19] n380 AO22HDLLX1
XU623 t_word[10] VSS VDD_1V8 n686 n661 D_push[18] n381 AO22HDLLX1
XU622 t_word[9] VSS VDD_1V8 n686 n661 D_push[17] n382 AO22HDLLX1
XU621 t_word[8] VSS VDD_1V8 n686 n661 D_push[16] n383 AO22HDLLX1
XU619 t_word[23] VSS VDD_1V8 n686 n658 D_push[15] n384 AO22HDLLX1
XU618 t_word[22] VSS VDD_1V8 n686 n658 D_push[14] n385 AO22HDLLX1
XU617 t_word[21] VSS VDD_1V8 n686 n658 D_push[13] n386 AO22HDLLX1
XU616 t_word[20] VSS VDD_1V8 n686 n658 D_push[12] n387 AO22HDLLX1
XU615 t_word[19] VSS VDD_1V8 n686 n658 D_push[11] n388 AO22HDLLX1
XU614 t_word[18] VSS VDD_1V8 n686 n658 D_push[10] n389 AO22HDLLX1
XU613 t_word[17] VSS VDD_1V8 n686 n658 D_push[9] n390 AO22HDLLX1
XU611 t_word[16] VSS VDD_1V8 n686 n658 D_push[8] n391 AO22HDLLX1
XU610 t_word[31] VSS VDD_1V8 n686 n663 D_push[7] n392 AO22HDLLX1
XU609 t_word[30] VSS VDD_1V8 n686 n663 D_push[6] n393 AO22HDLLX1
XU608 t_word[29] VSS VDD_1V8 n686 n663 D_push[5] n394 AO22HDLLX1
XU607 t_word[28] VSS VDD_1V8 n686 n663 D_push[4] n395 AO22HDLLX1
XU606 t_word[27] VSS VDD_1V8 n686 n663 D_push[3] n396 AO22HDLLX1
XU605 t_word[26] VSS VDD_1V8 n686 n663 D_push[2] n397 AO22HDLLX1
XU604 t_word[25] VSS VDD_1V8 n686 n663 D_push[1] n398 AO22HDLLX1
XU601 t_word[24] VSS VDD_1V8 n686 n663 D_push[0] n399 AO22HDLLX1
XU597 VSS n657 n655 n654 VDD_1V8 NO2HDLLX1
XU596 VSS VDD_1V8 n680 n653 n665 n654 n658 NA4I3HDLLX0
XU595 n665 n737 n651 VSS VDD_1V8 index[0] n666 AN31HDLLX0
XU594 VSS n651 index[2] n664 VDD_1V8 NO2HDLLX0
XU593 VSS n670 n668 VDD_1V8 n658 NA2HDLLX1
XU592 VSS n664 index[2] VDD_1V8 n668 n650 NA3I2HDLLX0
XU591 data_read[31] VSS VDD_1V8 t_word[31] n649 n648 n400 AO22HDLLX1
XU27 VSS n662 n247 VDD_1V8 n736 n225 NA3I2HDLLX0
XU276 n121 VSS n124 n123 VDD_1V8 n126 n127 NO4I3HDLLX0
XU291 n177 VSS n321 n179 VDD_1V8 n180 n182 NO4I3HDLLX0
XU559 VSS n647 n244 VDD_1V8 n649 AND2HDLLX0
XU365 n239 VSS n241 n669 VDD_1V8 n242 n243 NO4I3HDLLX0
XU252 n132 VSS n238 n179 VDD_1V8 n97 n99 NO4I3HDLLX0
XU251 VSS VDD_1V8 n150 n96 n660 n648 n165 NA4I3HDLLX2
XU217 n141 VSS n103 n323 VDD_1V8 n183 n93 NO4I3HDLLX0
Xplace15 n246 VSS VDD_1V8 n244 INHDLLX0
Xplace18 n652 VSS VDD_1V8 n302 INHDLLX0
Xplace19 n659 VSS VDD_1V8 n106 INHDLLX0
Xplace22 n669 VSS VDD_1V8 n247 INHDLLX0
Xplace30 n683 VSS VDD_1V8 n682 INHDLLX0
Xplace31 n684 VSS VDD_1V8 n225 INHDLLX0
Xplace34 n687 VSS VDD_1V8 n686 INHDLLX0
Xplace36 n689 VSS VDD_1V8 n688 INHDLLX0
Xplace11 n196 VSS VDD_1V8 reset INHDLLX1
Xplace12 n237 VSS VDD_1V8 reset INHDLLX1
Xplace13 n240 VSS VDD_1V8 reset INHDLLX1
Xplace10 n195 VSS VDD_1V8 reset INHDLLX1
Xplace9 n188 VSS VDD_1V8 reset INHDLLX1
Xplace6 n164 VSS VDD_1V8 reset INHDLLX1
Xplace8 n185 VSS VDD_1V8 reset INHDLLX1
Xplace3 n1 VSS VDD_1V8 reset INHDLLX0
Xplace5 n95 VSS VDD_1V8 reset INHDLLX1
Xplace4 n66 VSS VDD_1V8 reset INHDLLX1
Xplace7 n168 VSS VDD_1V8 reset INHDLLX1
Xplace38 n691 VSS VDD_1V8 n248 INHDLLX0
Xplace32 n685 VSS VDD_1V8 n736 INHDLLX0
Xplace25 n676 VSS VDD_1V8 n316 INHDLLX0
Xplace23 n671 VSS VDD_1V8 n242 INHDLLX0
Xplace29 VSS VDD_1V8 n682 n677 BUHDLLX0
Xplace33 VSS VDD_1V8 n686 n657 BUHDLLX0
Xplace35 VSS VDD_1V8 n688 n657 BUHDLLX0
Xplace21 n662 VSS VDD_1V8 n238 INHDLLX0
Xplace41 n694 VSS VDD_1V8 n255 INHDLLX0
Xplace14 VSS VDD_1V8 n244 end_send BUHDLLX1
Xplace27 n680 VSS VDD_1V8 n316 INHDLLX0
Xplace17 VSS VDD_1V8 n302 t_word[0] BUHDLLX0
Xplace40 VSS VDD_1V8 n693 n314 BUHDLLX0
Xplace24 n674 VSS VDD_1V8 n97 INHDLLX0
Xplace20 n660 VSS VDD_1V8 n305 INHDLLX0
XINHDLLX2_G3B1I5 CTS_2_G3B4I5 VSS VDD_1V8 CTS_2_G3B3I1 INHDLLX2
XINHDLLX8_G3B1I6 VSS VDD_1V8 CTS_2_G3B4I6 CTS_2_G3B3I1 INHDLLX8
XINHDLLX6_G3B2I1 VSS VDD_1V8 n701 CTS_2_G3B3I1 INHDLLX6
XINHDLLX8_G3B1I7 VSS VDD_1V8 CTS_2_G3B4I7 CTS_2_G3B3I2 INHDLLX8
XINHDLLX8_G3B1I4 VSS VDD_1V8 CTS_2_G3B4I4 CTS_2_G3B3I2 INHDLLX8
XINHDLLX6_G3B1I1 VSS VDD_1V8 CTS_2_G3B4I1 CTS_2_G3B3I1 INHDLLX8
XINHDLLX8_G3B1I2 VSS VDD_1V8 CTS_2_G3B4I2 CTS_2_G3B3I2 INHDLLX8
XINHDLLX12_G3B1I3 VDD_1V8 VSS CTS_2_G3B4I3 CTS_2_G3B3I2 INHDLLX12
XINHDLLX6_G3B2I2 VSS VDD_1V8 CTS_2_G3B3I2 n701 INHDLLX8
XBUHDLLX12_GB_MV VSS VDD_1V8 CLK n701 BUHDLLX6
.ENDS

.SUBCKT control clk reset codif_inst_deco[6] codif_inst_deco[5] codif_inst_deco[4]
+ codif_inst_deco[3] codif_inst_deco[2] codif_inst_deco[1] codif_inst_deco[0] mem_rdy_mem_cntrlr
+ error_drs_mem_cntrlr Zero_alu int_A int_T int_E r_1_w_0_mbc b_mbc h_mbc enable_mbc
+ pop_intrpt ld_id_instrl_deco ld_addrs ld_pc s_addrs s_pc1[1] s_pc1[0] s_pc2[1]
+ s_pc2[0] s_alu[2] s_alu[1] s_alu[0] s_reg_w[3] s_reg_w[2] s_reg_w[1] s_reg_w[0]
+ s_csr[2] s_csr[1] s_csr[0] write_reg_fl csr_write cntrl_alu[3] cntrl_alu[2] cntrl_alu[1]
+ cntrl_alu[0] sign_ext inv_r1 rst_tmr VSS VDD_1V8 IN0 IN1 clk_cts_4
Xst7 nxt_state[7] clk reset cur_state[7] VSS VDD_1V8 dff_async_rst_1324
Xst6 nxt_state[6] clk reset cur_state[6] VSS VDD_1V8 dff_async_rst_1325
Xst5 nxt_state[5] clk reset cur_state[5] VSS VDD_1V8 dff_async_rst_1326
Xst4 nxt_state[4] clk reset cur_state[4] VSS VDD_1V8 dff_async_rst_1327
Xst3 nxt_state[3] clk reset cur_state[3] VSS VDD_1V8 dff_async_rst_1328
Xst2 nxt_state[2] clk reset cur_state[2] VSS VDD_1V8 dff_async_rst_1329
Xst1 nxt_state[1] clk reset cur_state[1] VSS VDD_1V8 dff_async_rst_1330
Xst0 nxt_state[0] clk reset cur_state[0] VSS VDD_1V8 dff_async_rst_1331
XU578 VSS n362 n387 cur_state[0] VDD_1V8 n517 n553 AO31HDLLX0
XU732 VSS n658 VDD_1V8 n684 n661 cur_state[0] n654 OA211HDLLX0
XU36 VSS n471 n713 n38 VDD_1V8 NO2HDLLX0
XU513 VSS VDD_1V8 n427 n275 n642 n324 n276 OA22HDLLX0
XActv_ntrpt_reg reset enbl_ntrpt N2319 SYNOPSYS_UNCONNECTED_70 N2319 VSS VDD_1V8 DFRRHDLLX0
Xwrite_reg_fl_pre_reg write_reg_fl_pre VSS VDD_1V8 N2318 N2317 DLHQHDLLX0
Xplace16 VSS VDD_1V8 n513 cur_state[5] BUHDLLX0
Xplace10 VSS VDD_1V8 n427 cur_state[3] BUHDLLX0
Xplace8 VSS VDD_1V8 n413 cur_state[2] BUHDLLX0
Xplace7 n394 VSS VDD_1V8 cur_state[1] INHDLLX0
Xplace9 n426 VSS VDD_1V8 n413 INHDLLX0
Xplace17 n516 VSS VDD_1V8 n513 INHDLLX0
Xplace18 VSS VDD_1V8 n517 cur_state[6] BUHDLLX0
Xplace11 n429 VSS VDD_1V8 n427 INHDLLX0
Xplace19 n549 VSS VDD_1V8 n517 INHDLLX0
XU5 VSS n429 n426 VDD_1V8 n569 NA2HDLLX0
Xplace14 VSS VDD_1V8 n488 cur_state[4] BUHDLLX0
XU18 VSS n517 n516 VDD_1V8 n457 NA2HDLLX0
XU17 VSS cur_state[7] n394 VDD_1V8 n535 NA2HDLLX0
XU11 VSS n516 n549 VDD_1V8 n555 NA2HDLLX0
XU19 n378 VSS VDD_1V8 n569 n457 n535 NO3HDLLX0
XU24 VSS n513 n549 VDD_1V8 n610 NA2HDLLX0
Xplace15 n505 VSS VDD_1V8 n488 INHDLLX0
XU12 VSS n296 cur_state[7] n555 VDD_1V8 NO2HDLLX0
XU26 VSS n522 cur_state[1] n569 VDD_1V8 NO2HDLLX0
XU25 VSS n688 cur_state[7] n610 VDD_1V8 NO2HDLLX0
XU21 VSS n378 n505 VDD_1V8 n478 NA2HDLLX0
XU32 n4 VSS VDD_1V8 int_T INHDLLX0
XU27 n522 VSS n378 n688 VDD_1V8 n2 AN21HDLLX0
XU22 VSS VDD_1V8 n5 N2319 n478 NO2I1HDLLX0
XU28 VSS n488 n296 VDD_1V8 n492 NA2HDLLX0
Xplace47 n711 VSS VDD_1V8 codif_inst_deco[3] INHDLLX0
Xplace46 n710 VSS VDD_1V8 codif_inst_deco[4] INHDLLX0
XU23 int_A int_T VSS VDD_1V8 n3 int_E NO22HDLLX0
XU33 n6 VSS VDD_1V8 int_A n5 n5 n4 int_E AN32HDLLX0
XU29 n488 VDD_1V8 n2 VSS n492 n7 OA21HDLLX0
XU113 VSS n344 codif_inst_deco[5] n710 VDD_1V8 NO2HDLLX0
XU130 VSS n416 n710 n711 VDD_1V8 NO2HDLLX0
XU150 VSS n507 cur_state[0] n394 VDD_1V8 NO2HDLLX0
XU30 VSS VDD_1V8 n463 n7 n3 n5 error_drs_mem_cntrlr AN22HDLLX0
Xplace5 n360 VSS VDD_1V8 cur_state[0] INHDLLX0
XU116 VSS n421 codif_inst_deco[1] codif_inst_deco[3] VDD_1V8 NO2HDLLX0
XU34 VSS n478 Zero_alu VDD_1V8 n6 n8 NA22HDLLX0
Xplace43 n707 VSS VDD_1V8 codif_inst_deco[6] INHDLLX0
Xplace45 n709 VSS VDD_1V8 codif_inst_deco[5] INHDLLX0
Xplace42 n706 VSS VDD_1V8 codif_inst_deco[1] INHDLLX0
XU110 VSS codif_inst_deco[0] codif_inst_deco[2] VDD_1V8 n356 NA2HDLLX0
XU137 VSS n302 codif_inst_deco[5] n706 VDD_1V8 NO2HDLLX0
XU35 VSS VDD_1V8 n38 n8 n7 mem_rdy_mem_cntrlr MU2IHDLLX0
XU203 n424 VSS VDD_1V8 n416 INHDLLX0
XU133 VSS n710 n711 VDD_1V8 n345 NA2HDLLX0
XU65 VSS n394 n360 VDD_1V8 n605 NA2HDLLX0
XU197 VSS codif_inst_deco[6] codif_inst_deco[5] VDD_1V8 n423 NA2HDLLX0
Xplace38 n694 VSS VDD_1V8 n507 INHDLLX0
Xplace49 n713 VSS VDD_1V8 n463 INHDLLX0
Xplace50 n714 VSS VDD_1V8 n421 INHDLLX0
Xplace51 n715 VSS VDD_1V8 n344 INHDLLX0
XU124 VSS codif_inst_deco[3] n709 VDD_1V8 n438 NA2HDLLX0
XU103 VSS n707 n710 VDD_1V8 n422 NA2HDLLX0
XU99 VSS codif_inst_deco[1] codif_inst_deco[3] VDD_1V8 n255 NA2HDLLX0
XU97 VSS n334 cur_state[0] n426 VDD_1V8 NO2HDLLX0
XU123 VSS n62 n707 n710 VDD_1V8 NO2HDLLX0
XU46 VSS n388 n427 n426 VDD_1V8 NO2HDLLX0
XU51 VSS n426 cur_state[0] VDD_1V8 n568 NA2HDLLX0
Xplace33 n674 VSS VDD_1V8 n605 INHDLLX0
XU49 VSS n427 n426 VDD_1V8 n560 NA2HDLLX0
XU15 VSS n521 cur_state[1] n360 VDD_1V8 NO2HDLLX0
XU134 n248 VSS VDD_1V8 n345 INHDLLX0
XU125 VSS n156 VDD_1V8 n714 n707 n438 ON21HDLLX0
XU122 VSS n710 n709 VDD_1V8 n158 NA2HDLLX0
XU485 VSS n434 codif_inst_deco[6] n706 VDD_1V8 NO2HDLLX0
XU119 n28 VSS VDD_1V8 codif_inst_deco[2] INHDLLX0
XU105 VSS n431 n422 n709 VDD_1V8 NO2HDLLX0
XU98 n100 VSS VDD_1V8 n334 INHDLLX0
XU198 VSS n153 VDD_1V8 n706 n707 codif_inst_deco[4] ON21HDLLX0
XU396 VSS n215 VDD_1V8 n715 n707 n421 ON21HDLLX0
XU611 VSS n425 VDD_1V8 n422 n423 n424 ON21HDLLX0
XU196 n348 VSS VDD_1V8 n422 INHDLLX0
XU111 VSS n449 codif_inst_deco[0] codif_inst_deco[2] VDD_1V8 NO2HDLLX0
XU393 n157 VSS VDD_1V8 n302 INHDLLX0
XU343 VSS n687 n413 n694 VDD_1V8 NO2HDLLX0
XU100 n66 VSS VDD_1V8 n255 INHDLLX0
XU193 VSS n417 codif_inst_deco[6] n709 VDD_1V8 NO2HDLLX0
XU389 VSS n428 codif_inst_deco[5] n422 VDD_1V8 NO2HDLLX0
XU191 VSS n433 n422 n706 VDD_1V8 NO2HDLLX0
XU615 n435 VSS VDD_1V8 n434 INHDLLX0
XU455 VSS n208 codif_inst_deco[3] n715 VDD_1V8 NO2HDLLX0
XU568 n347 VSS VDD_1V8 n416 n417 n417 n345 n706 AN32HDLLX0
XU460 VSS VDD_1V8 n210 codif_inst_deco[6] codif_inst_deco[4] n706 n709 AN211HDLLX0
XU570 n444 VSS n438 VDD_1V8 n348 NA2I1HDLLX0
XU612 VSS VDD_1V8 n430 n706 n711 n428 n425 AN22HDLLX0
Xplace52 n716 VSS VDD_1V8 n471 INHDLLX0
XU614 VSS VDD_1V8 n437 codif_inst_deco[3] n709 n433 n431 AN22HDLLX0
XU390 VSS VDD_1V8 n155 codif_inst_deco[3] n417 codif_inst_deco[4] n153 AN22HDLLX0
XU394 VSS VDD_1V8 n157 codif_inst_deco[1] codif_inst_deco[6] n156 codif_inst_deco[4]
+ n158 n160 AN321HDLLX0
XU456 n715 VSS n707 codif_inst_deco[3] VDD_1V8 n257 AN21HDLLX0
XU397 n159 VSS VDD_1V8 n215 n449 n449 n706 codif_inst_deco[5] AN32HDLLX0
XU458 VSS VDD_1V8 n209 codif_inst_deco[6] n709 n248 n345 AN22HDLLX0
XU275 VSS n100 n568 VDD_1V8 n553 NA2HDLLX0
Xplace32 n667 VSS VDD_1V8 n569 INHDLLX0
XU463 VSS n297 VDD_1V8 n706 n711 codif_inst_deco[4] ON21HDLLX0
Xplace30 n660 VSS VDD_1V8 n521 INHDLLX0
XU571 n350 VSS codif_inst_deco[6] n715 VDD_1V8 n421 NA3HDLLX0
Xplace26 n639 VSS VDD_1V8 n388 INHDLLX0
XU64 VSS n513 n517 VDD_1V8 n636 NA2HDLLX0
Xplace25 n638 VSS VDD_1V8 n560 INHDLLX0
XU77 VSS n413 n674 VDD_1V8 n223 NA2HDLLX0
XU344 VSS n427 n687 VDD_1V8 n323 NA2HDLLX0
XU120 VSS n28 codif_inst_deco[0] VDD_1V8 n443 NA2HDLLX0
XU192 n419 VSS VDD_1V8 n433 INHDLLX0
XU87 VSS n427 n413 VDD_1V8 n580 NA2HDLLX0
XU71 VSS cur_state[1] cur_state[0] VDD_1V8 n603 NA2HDLLX0
XU200 n436 VSS codif_inst_deco[5] n711 VDD_1V8 codif_inst_deco[4] NA3HDLLX0
XU114 VSS VDD_1V8 n60 codif_inst_deco[4] codif_inst_deco[1] codif_inst_deco[6] n344 AN211HDLLX0
XU254 VSS n627 n394 n429 VDD_1V8 NO2HDLLX0
XU138 VSS n27 codif_inst_deco[3] n422 VDD_1V8 NO2HDLLX0
XU108 VSS codif_inst_deco[5] n711 VDD_1V8 n346 NA2HDLLX0
XU253 VSS n497 cur_state[1] n427 VDD_1V8 NO2HDLLX0
XU58 VSS n38 n463 VDD_1V8 n333 NA2HDLLX0
XU118 VSS VDD_1V8 n22 codif_inst_deco[6] n714 codif_inst_deco[5] n709 AN22HDLLX0
XU127 VSS n24 VDD_1V8 n708 n156 n62 ON21HDLLX0
XU143 VSS n413 cur_state[0] VDD_1V8 n548 NA2HDLLX0
XU131 VSS n416 n707 VDD_1V8 n154 NA2HDLLX0
XU112 codif_inst_deco[4] VSS n66 n711 VDD_1V8 n23 AN21HDLLX0
XU551 n467 VSS VDD_1V8 n323 INHDLLX0
XU569 n352 VSS VDD_1V8 n419 n347 n347 n346 n438 AN32HDLLX0
XU121 n22 VSS n443 n23 VDD_1V8 n25 AN21HDLLX0
XU572 VSS n351 VDD_1V8 n350 n444 codif_inst_deco[1] ON21HDLLX0
XU613 n441 VSS VDD_1V8 n714 n430 n430 codif_inst_deco[4] codif_inst_deco[5] AN32HDLLX0
XU616 n439 VSS VDD_1V8 n435 n437 n437 n436 n438 AN32HDLLX0
XU457 VSS n213 VDD_1V8 n257 n706 n431 n208 ON31HDLLX0
XU459 n212 n436 n706 VSS VDD_1V8 n209 n443 AN31HDLLX0
XU461 n211 n345 n422 VSS VDD_1V8 n210 n356 AN31HDLLX0
XU464 VSS n214 n297 n709 VDD_1V8 NO2HDLLX0
XU488 VSS n248 n709 VDD_1V8 n249 NA2HDLLX0
XU505 VSS n466 n555 n716 VDD_1V8 NO2HDLLX0
XU381 VSS n496 n580 n603 VDD_1V8 NO2HDLLX0
Xplace53 n717 VSS VDD_1V8 n333 INHDLLX0
XU391 n154 VSS n428 n706 n155 VDD_1V8 n163 ON211HDLLX0
XU392 n162 n424 n707 VSS VDD_1V8 n302 n443 AN31HDLLX0
Xplace41 n705 VSS VDD_1V8 n553 INHDLLX0
XU398 VSS n161 VDD_1V8 n159 n356 n160 ON21HDLLX0
Xplace28 n653 VSS VDD_1V8 n457 INHDLLX0
Xplace27 n642 VSS VDD_1V8 n610 INHDLLX0
Xplace24 n633 VSS VDD_1V8 n603 INHDLLX0
Xplace22 n606 VSS VDD_1V8 n636 INHDLLX0
Xplace21 n595 VSS VDD_1V8 cur_state[7] INHDLLX0
XU308 VSS n604 n388 n638 VDD_1V8 NO2HDLLX0
XU163 n619 VSS VDD_1V8 n223 INHDLLX0
XU167 VSS n429 n516 VDD_1V8 n177 NA2HDLLX0
XU182 VSS n273 n639 n360 VDD_1V8 NO2HDLLX0
XU208 VSS n315 n569 n660 VDD_1V8 NO2HDLLX0
XU225 VSS n219 n516 n716 VDD_1V8 NO2HDLLX0
XU140 VSS n442 codif_inst_deco[0] n28 VDD_1V8 NO2HDLLX0
XU255 VSS n414 n497 n627 VDD_1V8 NO2HDLLX0
XU52 VSS n176 n549 n568 VDD_1V8 NO2HDLLX0
XU60 VSS n455 n429 n610 VDD_1V8 NO2HDLLX0
XU43 VSS n517 n429 VDD_1V8 n456 NA2HDLLX0
XU40 VSS n667 cur_state[0] VDD_1V8 n274 NA2HDLLX0
XU83 VSS n427 n513 VDD_1V8 n335 NA2HDLLX0
XU94 n383 VSS VDD_1V8 n429 n360 n517 NO3HDLLX0
XU106 n299 VSS VDD_1V8 n431 INHDLLX0
XU144 n324 VSS VDD_1V8 n548 INHDLLX0
XU139 VSS VDD_1V8 n29 n706 n27 n302 MU2IHDLLX0
XU135 VSS VDD_1V8 n30 n707 n709 n248 n416 AN211HDLLX0
XU115 VSS n23 codif_inst_deco[5] VDD_1V8 n60 n26 NA22HDLLX0
XU132 n420 VSS VDD_1V8 n154 INHDLLX0
XU128 VSS n69 VDD_1V8 n158 n24 n443 codif_inst_deco[1] ON31HDLLX0
XU427 VSS n398 VDD_1V8 n274 n560 cur_state[0] ON21HDLLX0
XU56 VSS n387 n513 n471 VDD_1V8 NO2HDLLX0
XU377 VSS n622 cur_state[7] n517 VDD_1V8 NO2HDLLX0
XU53 n178 VSS VDD_1V8 n176 INHDLLX0
XU364 VSS n674 n426 VDD_1V8 n589 NA2HDLLX0
XU399 VSS VDD_1V8 n164 n442 n163 n162 n161 AN211HDLLX0
XU152 VSS n427 n516 VDD_1V8 n547 NA2HDLLX0
XU382 n638 VSS n496 n521 VDD_1V8 n678 AN21HDLLX0
XU8 VSS n513 cur_state[0] VDD_1V8 n657 NA2HDLLX0
XU431 VSS n462 n717 n426 VDD_1V8 NO2HDLLX0
XU368 VSS n429 n549 VDD_1V8 n608 NA2HDLLX0
XU283 VSS n334 n414 VDD_1V8 n676 NA2HDLLX0
Xplace23 n630 VSS VDD_1V8 n580 INHDLLX0
XU511 VSS n273 n516 VDD_1V8 n530 NA2HDLLX0
Xplace31 n664 VSS VDD_1V8 n555 INHDLLX0
XU506 VSS VDD_1V8 n268 cur_state[0] n705 n642 n466 AN22HDLLX0
XU501 VSS n275 n705 n429 VDD_1V8 NO2HDLLX0
XU489 n250 VSS VDD_1V8 codif_inst_deco[6] n249 n707 n715 n438 AN32HDLLX0
XU472 VSS n224 VDD_1V8 n580 n627 n513 ON21HDLLX0
XU469 n220 n713 n273 VSS VDD_1V8 n517 n606 AN31HDLLX0
XU468 n221 VSS n517 VDD_1V8 n604 n638 n219 n549 AN221HDLLX0
XU465 VSS n216 VDD_1V8 n449 n214 n215 ON21HDLLX0
XU462 VSS VDD_1V8 n217 n442 n213 n212 n211 AN211HDLLX0
XU624 n455 n457 VSS VDD_1V8 n458 n456 NO3I2HDLLX0
XU623 VSS VDD_1V8 n459 n606 n496 n653 n619 AN22HDLLX0
XU617 VSS VDD_1V8 n445 n708 n441 n442 n439 AN22HDLLX0
XU610 VSS VDD_1V8 n446 n420 n421 n431 n706 AN22HDLLX0
XU608 VSS VDD_1V8 n418 n421 n416 n417 n428 AN22HDLLX0
XU552 n414 VSS n467 n324 VDD_1V8 n675 AN21HDLLX0
XU565 VSS n343 VDD_1V8 n421 n442 n712 ON21HDLLX0
XU567 n357 VSS VDD_1V8 n433 codif_inst_deco[3] n711 n434 n344 AN32HDLLX0
XU573 VSS VDD_1V8 n355 n442 n352 n449 n351 AN22HDLLX0
XU574 n354 VSS n428 n714 VDD_1V8 n712 NA3HDLLX0
XU84 VSS n341 cur_state[0] n429 VDD_1V8 NO2HDLLX0
XU210 VSS n603 n605 VDD_1V8 n594 NA2HDLLX0
XU141 VSS n31 VDD_1V8 n29 n442 n30 n420 ON31HDLLX0
XU209 n388 VSS n315 n633 VDD_1V8 n225 AN21HDLLX0
XU242 VSS n517 n595 VDD_1V8 n625 NA2HDLLX0
XU215 VSS cur_state[1] n413 VDD_1V8 n597 NA2HDLLX0
XU243 VSS n513 n667 VDD_1V8 n683 NA2HDLLX0
XU310 VSS n593 n560 n660 VDD_1V8 NO2HDLLX0
XU258 VSS n513 n383 VDD_1V8 n125 NA2HDLLX0
XU187 VSS n87 n639 n694 VDD_1V8 NO2HDLLX0
XU227 VSS n413 n507 VDD_1V8 n523 NA2HDLLX0
XU320 VSS n394 n426 VDD_1V8 n242 NA2HDLLX0
XU62 VSS cur_state[1] n595 VDD_1V8 n390 NA2HDLLX0
XU109 VSS n33 VDD_1V8 n299 codif_inst_deco[6] n66 n346 OA211HDLLX0
XU129 VSS VDD_1V8 n32 n449 n26 n25 n69 AN211HDLLX0
XU81 VSS n536 n595 n555 VDD_1V8 NO2HDLLX0
XU348 VSS n335 n177 VDD_1V8 n661 NA2HDLLX0
XU95 VSS n383 n516 VDD_1V8 n198 NA2HDLLX0
XU328 VSS n461 n413 n394 VDD_1V8 NO2HDLLX0
XU176 VSS n654 n517 n595 VDD_1V8 NO2HDLLX0
XU345 VSS n668 n580 n605 VDD_1V8 NO2HDLLX0
XU466 VSS VDD_1V8 n218 n217 n216 n517 n639 AN211HDLLX0
XU259 VSS n701 n426 n125 VDD_1V8 NO2HDLLX0
XU470 VSS n222 VDD_1V8 n220 n221 cur_state[0] ON21HDLLX0
XU175 VSS n643 n427 n603 VDD_1V8 NO2HDLLX0
XU68 VSS n563 cur_state[1] cur_state[7] VDD_1V8 NO2HDLLX0
XU172 VSS n394 n516 VDD_1V8 n634 NA2HDLLX0
XU287 VSS n654 n580 VDD_1V8 n367 NA2HDLLX0
XU473 n224 n223 VSS VDD_1V8 n657 n226 n225 NA4HDLLX0
XU183 n598 VSS VDD_1V8 n273 INHDLLX0
XU628 n464 VSS VDD_1V8 n462 n394 n394 n463 n513 AN32HDLLX0
XU627 VSS VDD_1V8 n465 n461 n516 cur_state[0] n608 AN211HDLLX0
XU625 n460 n459 n589 VSS VDD_1V8 n523 n458 AN31HDLLX0
XU618 n447 VSS VDD_1V8 n443 n445 n445 n444 n446 AN32HDLLX0
XU241 VSS n504 n580 n660 VDD_1V8 NO2HDLLX0
XU609 VSS n448 VDD_1V8 n418 n711 n419 ON21HDLLX0
XU233 VSS n415 n426 n549 VDD_1V8 NO2HDLLX0
XU232 n227 VSS VDD_1V8 cur_state[0] n580 n513 NO3HDLLX0
XU230 n600 VSS VDD_1V8 n87 INHDLLX0
XU218 VSS n201 n639 n603 VDD_1V8 NO2HDLLX0
XU486 VSS VDD_1V8 n253 n434 n431 codif_inst_deco[3] n715 AN22HDLLX0
XU487 n252 VSS VDD_1V8 n449 INHDLLX0
XU353 VSS n623 n580 n694 VDD_1V8 NO2HDLLX0
XU85 n335 VSS n341 cur_state[0] VDD_1V8 n312 AN21HDLLX0
XU490 VSS n251 VDD_1V8 codif_inst_deco[1] n250 n431 ON21HDLLX0
XU507 VSS n269 VDD_1V8 n268 n549 n705 ON21HDLLX0
Xplace36 n686 VSS VDD_1V8 n625 INHDLLX0
Xplace34 n677 VSS VDD_1V8 n390 INHDLLX0
XU510 n509 VSS VDD_1V8 n657 INHDLLX0
XU512 n530 VSS n664 n274 VDD_1V8 n277 AN21HDLLX0
Xplace13 n440 VSS VDD_1V8 n488 INHDLLX0
XU96 n194 VSS VDD_1V8 n198 INHDLLX0
XU340 VSS n680 n639 n605 VDD_1V8 NO2HDLLX0
XU538 VSS n638 n633 VDD_1V8 n308 NA2HDLLX0
XU371 VSS n413 n633 VDD_1V8 n584 NA2HDLLX0
XU372 VSS n141 VDD_1V8 n580 n603 n547 ON21HDLLX0
XU329 n662 VSS VDD_1V8 n461 INHDLLX0
XU378 n207 VSS VDD_1V8 n622 INHDLLX0
XU322 VSS n402 cur_state[7] n125 VDD_1V8 NO2HDLLX0
XU400 n165 n360 n429 VSS VDD_1V8 n164 n426 AN31HDLLX0
XU406 VSS n388 n521 VDD_1V8 n669 NA2HDLLX0
XU50 VSS n373 n610 n560 VDD_1V8 NO2HDLLX0
XU48 VSS n384 cur_state[0] n639 VDD_1V8 NO2HDLLX0
XU412 VSS n242 n597 VDD_1V8 n311 NA2HDLLX0
XU413 n681 VSS VDD_1V8 n177 INHDLLX0
XU42 VSS n413 n513 VDD_1V8 n406 NA2HDLLX0
XU41 n288 VSS VDD_1V8 n274 INHDLLX0
XU414 VSS n179 cur_state[1] n178 VDD_1V8 NO2HDLLX0
XU416 VSS n267 n664 n606 VDD_1V8 NO2HDLLX0
XU418 VSS n532 n560 n636 VDD_1V8 NO2HDLLX0
XU422 n278 VSS VDD_1V8 n457 n560 n569 n642 ON22HDLLX0
XU321 n411 VSS VDD_1V8 n242 INHDLLX0
XU428 VSS VDD_1V8 n183 n387 n398 n642 n273 AN22HDLLX0
XU429 VSS n630 n606 VDD_1V8 n375 NA2HDLLX0
XU319 VSS n403 n178 n547 VDD_1V8 NO2HDLLX0
XU446 VSS n200 n198 n597 VDD_1V8 NO2HDLLX0
XU447 n560 VSS n516 n633 VDD_1V8 n199 AN21HDLLX0
XU450 n202 VSS VDD_1V8 n471 n549 n517 n426 n463 AN32HDLLX0
XU263 n326 VSS VDD_1V8 n125 INHDLLX0
XU297 n542 VSS VDD_1V8 n536 INHDLLX0
XU153 VSS n39 VDD_1V8 n360 n522 n463 n38 ON31HDLLX0
XU148 VSS n166 n427 n516 VDD_1V8 NO2HDLLX0
XU142 n31 VSS n33 n356 n32 VDD_1V8 n34 ON211HDLLX0
XU286 n484 VSS VDD_1V8 n683 INHDLLX0
XU740 n679 VSS VDD_1V8 n513 n675 n516 n676 n678 AN32HDLLX0
XU669 VSS n656 n427 n521 VDD_1V8 NO2HDLLX0
XU709 VSS VDD_1V8 n596 n667 n594 n668 n593 AN211HDLLX0
XU211 n631 VSS VDD_1V8 n594 INHDLLX0
XU566 VSS n359 VDD_1V8 n343 n356 n711 ON21HDLLX0
XU575 n354 VSS n357 n356 n355 VDD_1V8 n358 ON211HDLLX0
XU347 VSS cur_state[0] n595 VDD_1V8 n561 NA2HDLLX0
XU168 VSS n175 n333 n177 VDD_1V8 NO2HDLLX0
XU169 VSS n146 VDD_1V8 n549 n513 n413 ON21HDLLX0
XU188 codif_inst_deco[5] VSS n706 codif_inst_deco[3] VDD_1V8 n61 AN21HDLLX0
XU199 VSS VDD_1V8 n65 codif_inst_deco[5] n423 codif_inst_deco[3] n153 AN22HDLLX0
XU202 VSS VDD_1V8 n68 n417 n706 codif_inst_deco[6] n66 AN22HDLLX0
XU204 VSS n67 VDD_1V8 n248 n707 codif_inst_deco[5] ON21HDLLX0
XU309 n508 VSS VDD_1V8 n335 INHDLLX0
XU298 VSS n652 n440 n542 VDD_1V8 NO2HDLLX0
XU296 VSS n412 n394 n580 VDD_1V8 NO2HDLLX0
XU294 VSS n629 n394 n639 VDD_1V8 NO2HDLLX0
XU288 n484 VSS n367 n394 VDD_1V8 n534 AN21HDLLX0
XU272 VSS n510 cur_state[7] n513 VDD_1V8 NO2HDLLX0
XU271 VSS n638 n674 VDD_1V8 n483 NA2HDLLX0
XU266 VSS n667 n674 VDD_1V8 n583 NA2HDLLX0
XU451 n203 VSS n604 n202 VDD_1V8 n521 NA3HDLLX0
XU449 VSS VDD_1V8 n204 n680 n201 n387 n333 AN22HDLLX0
XU448 VSS VDD_1V8 n205 n606 n643 n200 n199 AN211HDLLX0
XU432 VSS VDD_1V8 n497 n521 n716 n623 n462 n429 n184 AN321HDLLX0
XU423 n546 VSS VDD_1V8 n267 INHDLLX0
XU419 VSS VDD_1V8 n180 n461 n633 n532 n194 AN22HDLLX0
XU417 VSS VDD_1V8 n181 n267 n504 n653 n680 AN22HDLLX0
XU415 VSS VDD_1V8 n470 n681 n311 n326 n179 AN22HDLLX0
XU402 VSS n176 n166 VDD_1V8 n374 NA2HDLLX0
XU401 VSS VDD_1V8 n167 n384 n165 n664 n219 AN22HDLLX0
XU388 VSS VDD_1V8 n168 n403 n312 n415 n713 AN22HDLLX0
XU374 VSS n142 VDD_1V8 n513 n643 n674 ON21HDLLX0
XU373 VSS VDD_1V8 n567 n513 n411 n517 n141 AN211HDLLX0
XU741 VSS VDD_1V8 n682 n681 n687 n680 n679 AN211HDLLX0
XU369 n289 VSS VDD_1V8 n608 INHDLLX0
XU540 n625 VSS n668 n484 VDD_1V8 n633 n309 AO211HDLLX0
XU539 VSS VDD_1V8 n310 n669 n308 n513 n463 AN211HDLLX0
XU664 VSS n511 n427 n605 VDD_1V8 NO2HDLLX0
XU530 VSS n300 codif_inst_deco[1] n709 VDD_1V8 NO2HDLLX0
XU529 VSS n301 codif_inst_deco[4] n711 VDD_1V8 NO2HDLLX0
XU528 VSS codif_inst_deco[6] n345 VDD_1V8 n303 NA2HDLLX0
XU517 n279 VSS VDD_1V8 n278 n360 n360 n716 n667 AN32HDLLX0
XU516 VSS n280 VDD_1V8 n471 n288 n383 ON21HDLLX0
XU515 n281 VSS VDD_1V8 n606 n384 n384 n717 n664 AN32HDLLX0
XU514 VSS VDD_1V8 n282 n509 n630 n277 n276 AN211HDLLX0
XU675 n601 n603 n638 VSS VDD_1V8 n517 cur_state[7] AN31HDLLX0
XU508 VSS VDD_1V8 n270 n429 n716 n701 n269 AN22HDLLX0
XU504 VSS VDD_1V8 n271 n532 n267 n275 n360 AN22HDLLX0
XU503 VSS VDD_1V8 n272 n606 n398 n664 n273 AN22HDLLX0
XU493 n256 VSS VDD_1V8 n443 n715 codif_inst_deco[6] NO3HDLLX0
XU491 n254 VSS VDD_1V8 n356 n251 n252 n253 ON22HDLLX0
XU474 VSS n228 VDD_1V8 n654 n226 n227 ON21HDLLX0
XU471 n229 VSS VDD_1V8 n222 n563 n563 n569 n513 AN32HDLLX0
XU467 VSS n230 VDD_1V8 n218 n677 n513 n383 ON31HDLLX0
XU710 n599 VSS VDD_1V8 n596 n549 n517 n597 n598 AN32HDLLX0
XU454 VSS VDD_1V8 n600 n207 n584 n625 n231 OA22HDLLX0
XU629 VSS VDD_1V8 n468 n465 n466 n467 n464 AN22HDLLX0
XU725 VSS VDD_1V8 n635 n517 n394 n656 n426 AN211HDLLX0
XU626 VSS VDD_1V8 n469 n507 n532 n668 n460 AN211HDLLX0
XU619 n450 VSS VDD_1V8 n447 n516 n516 n448 n449 AN32HDLLX0
XU733 n659 VSS VDD_1V8 n656 n658 n658 n657 n427 AN32HDLLX0
XU735 n663 VSS n662 n661 VDD_1V8 n686 NA3HDLLX0
XU549 n670 VSS VDD_1V8 n687 INHDLLX0
XU607 VSS n471 n549 VDD_1V8 n451 NA2HDLLX0
XU602 n407 VSS VDD_1V8 n426 n634 n406 n394 ON22HDLLX0
XU600 VSS VDD_1V8 n404 n461 n403 n677 n402 AN22HDLLX0
XU588 VSS VDD_1V8 n376 n717 n373 n463 n403 AN22HDLLX0
XU560 n336 VSS VDD_1V8 n471 n426 n426 n456 n335 AN32HDLLX0
XU585 VSS n631 n426 VDD_1V8 n495 NA2HDLLX0
XU584 VSS VDD_1V8 n369 n687 n536 n388 n622 AN22HDLLX0
XU580 VSS VDD_1V8 n363 n471 n429 cur_state[0] n517 AN211HDLLX0
XU576 n361 n359 n710 VSS VDD_1V8 codif_inst_deco[5] n358 AN31HDLLX0
Xplace39 n696 VSS VDD_1V8 n688 INHDLLX0
XU92 VSS n389 n716 n560 VDD_1V8 NO2HDLLX0
XU74 VSS n633 n426 VDD_1V8 n528 NA2HDLLX0
XU72 n603 VSS n517 n413 VDD_1V8 n135 AN21HDLLX0
XU67 VSS n427 n674 VDD_1V8 n243 NA2HDLLX0
XU13 n368 VSS VDD_1V8 n296 INHDLLX0
XU251 VSS n537 n595 n610 VDD_1V8 NO2HDLLX0
XU161 VSS n653 n595 VDD_1V8 n405 NA2HDLLX0
XU248 VSS n408 VDD_1V8 n654 n547 n394 ON21HDLLX0
XU224 n77 VSS VDD_1V8 n394 n630 n630 n360 n513 AN32HDLLX0
XU145 n34 VSS n324 n388 VDD_1V8 n35 AN21HDLLX0
XU226 n76 VSS VDD_1V8 n219 INHDLLX0
XU216 n325 VSS VDD_1V8 n597 INHDLLX0
XU220 VSS n592 n201 n638 VDD_1V8 NO2HDLLX0
XU154 VSS VDD_1V8 n40 n517 n312 n413 n39 AN22HDLLX0
XU663 VSS VDD_1V8 n514 n508 n509 n638 n507 AN22HDLLX0
XU680 n617 VSS VDD_1V8 n534 INHDLLX0
XU665 VSS VDD_1V8 n512 n511 n595 n510 n517 AN211HDLLX0
XU643 VSS n621 cur_state[7] n546 VDD_1V8 NO2HDLLX0
XU674 VSS n618 VDD_1V8 n528 n394 n569 ON21HDLLX0
XU738 VSS n671 VDD_1V8 n669 n670 n427 ON21HDLLX0
XU736 VSS VDD_1V8 n665 n413 n394 cur_state[0] n663 AN211HDLLX0
XU316 VSS n700 n505 n535 VDD_1V8 NO2HDLLX0
XU299 n124 VSS VDD_1V8 n652 INHDLLX0
XU657 VSS n556 n429 n694 VDD_1V8 NO2HDLLX0
XU640 n632 VSS VDD_1V8 n589 INHDLLX0
XU334 VSS n372 n595 n125 VDD_1V8 NO2HDLLX0
XU713 VSS n604 n605 VDD_1V8 n686 n607 NA22HDLLX0
XU742 VSS n685 VDD_1V8 n682 n683 n660 ON21HDLLX0
XU337 VSS n386 n610 n580 VDD_1V8 NO2HDLLX0
XU342 VSS n673 n335 n178 VDD_1V8 NO2HDLLX0
XU93 n427 VSS VDD_1V8 n389 n606 n37 AO21HDLLX0
XU349 VSS VDD_1V8 n128 n625 n561 n242 n661 AN211HDLLX0
XU82 VSS n653 n713 VDD_1V8 n18 NA2HDLLX0
XU75 n14 n243 n528 VSS VDD_1V8 n135 n595 AN31HDLLX0
XU70 VSS n664 n429 VDD_1V8 n322 NA2HDLLX0
XU166 VSS n395 n426 n660 VDD_1V8 NO2HDLLX0
XU170 VSS VDD_1V8 n50 n717 n667 n175 n146 AN211HDLLX0
XU57 VSS n46 n427 n360 VDD_1V8 NO2HDLLX0
XU173 n51 VSS VDD_1V8 n178 n634 n463 NO3HDLLX0
XU252 VSS n440 n537 VDD_1V8 n591 NA2HDLLX0
XU180 VSS n579 n324 n429 VDD_1V8 NO2HDLLX0
XU189 VSS n64 VDD_1V8 n60 n61 codif_inst_deco[4] ON21HDLLX0
XU234 n415 VSS n638 n619 VDD_1V8 n516 n79 AO211HDLLX0
XU231 VSS n80 VDD_1V8 n600 n580 n507 ON21HDLLX0
XU194 n62 VSS n417 n714 VDD_1V8 n419 n63 AO211HDLLX0
XU228 n78 VSS VDD_1V8 n523 n77 n77 n76 n549 AN32HDLLX0
XU201 n436 VSS n348 n706 n65 VDD_1V8 n71 ON211HDLLX0
XU221 n97 VSS VDD_1V8 n592 INHDLLX0
XU217 VSS n520 n426 n198 VDD_1V8 NO2HDLLX0
XU205 n70 n67 n424 VSS VDD_1V8 n68 n356 AN31HDLLX0
XU212 VSS VDD_1V8 n74 n631 n595 n569 n549 AN211HDLLX0
XU403 n374 n198 VSS VDD_1V8 n167 n169 n168 NA4HDLLX0
XU44 n456 VSS cur_state[0] n406 VDD_1V8 n11 AN21HDLLX0
XU407 n263 VSS VDD_1V8 n669 n405 n463 NO3HDLLX0
XU475 n229 n228 VSS VDD_1V8 n230 n232 n231 NA4HDLLX0
XU408 n170 VSS VDD_1V8 n625 n583 n483 n555 ON22HDLLX0
XU420 n180 VSS n463 n470 n181 VDD_1V8 n182 ON211HDLLX0
XU54 VSS VDD_1V8 n384 n653 n178 n10 n373 NA4I3HDLLX0
XU424 VSS n295 VDD_1V8 n669 n560 n605 ON21HDLLX0
XU426 n482 VSS VDD_1V8 n583 INHDLLX0
XU492 n259 n255 n428 VSS VDD_1V8 n442 n254 AN31HDLLX0
XU494 n258 VSS VDD_1V8 n256 n706 n706 n257 n442 AN32HDLLX0
XU630 n468 VSS n471 n470 n469 VDD_1V8 n472 ON211HDLLX0
XU497 VSS n261 VDD_1V8 n324 n595 n664 ON21HDLLX0
XU433 n186 VSS VDD_1V8 n184 n555 n394 n185 ON22HDLLX0
XU622 VSS VDD_1V8 n484 n560 n634 n360 n473 OA22HDLLX0
XU620 VSS VDD_1V8 n452 n629 n451 n522 n450 AN22HDLLX0
Xplace40 n704 VSS VDD_1V8 n405 INHDLLX0
XU509 n272 VSS n271 n284 n270 VDD_1V8 n384 NA4I1HDLLX0
XU606 VSS VDD_1V8 n453 n415 n414 cur_state[7] cur_state[0] AN211HDLLX0
XU605 VSS VDD_1V8 n454 n497 n716 n412 n411 AN211HDLLX0
XU603 VSS VDD_1V8 n409 cur_state[0] n580 n408 n407 AN211HDLLX0
XU601 VSS n410 VDD_1V8 n404 n405 n669 ON21HDLLX0
XU518 n280 n279 VSS VDD_1V8 n281 n283 n282 NA4HDLLX0
XU589 n377 n374 n375 VSS VDD_1V8 n376 n390 AN31HDLLX0
XU525 VSS n296 n505 VDD_1V8 n577 NA2HDLLX0
XU527 VSS n715 n714 VDD_1V8 n707 codif_inst_deco[1] n297 n305 n299 ON222HDLLX0
XU444 VSS n197 VDD_1V8 n696 n625 n631 ON21HDLLX0
XU586 n370 VSS VDD_1V8 n625 n369 n369 n495 n523 AN32HDLLX0
XU531 VSS n304 n302 n300 n348 n301 VDD_1V8 n303 n714 AO222HDLLX0
XU583 n371 VSS VDD_1V8 n594 n367 n560 n368 ON22HDLLX0
XU581 VSS VDD_1V8 n364 n517 n638 cur_state[1] n363 AN211HDLLX0
XU561 n337 n406 n636 VSS VDD_1V8 n336 n360 AN31HDLLX0
XU559 VSS n500 n427 n610 VDD_1V8 NO2HDLLX0
XU579 VSS VDD_1V8 n365 n429 n360 n642 n362 AN22HDLLX0
XU577 VSS n366 VDD_1V8 n610 n608 n361 ON21HDLLX0
XU452 n206 n203 n204 VSS VDD_1V8 n205 cur_state[7] AN31HDLLX0
XU155 n636 VSS n694 n547 n40 VDD_1V8 n41 ON211HDLLX0
XU537 n314 VSS VDD_1V8 n523 INHDLLX0
XU375 n143 n142 n683 VSS VDD_1V8 n567 n595 AN31HDLLX0
XU553 VSS n326 n325 VDD_1V8 n487 NA2HDLLX0
XU146 n36 VSS VDD_1V8 n664 n35 n555 n274 n100 AN32HDLLX0
XU541 VSS VDD_1V8 n313 n312 n311 n310 n309 AN211HDLLX0
XU734 VSS VDD_1V8 n666 n413 n694 n687 n659 AN211HDLLX0
XU267 VSS n630 n605 VDD_1V8 n557 NA2HDLLX0
XU726 n637 VSS VDD_1V8 cur_state[0] n635 n635 n634 n636 AN32HDLLX0
XU370 VSS n289 n674 VDD_1V8 n529 NA2HDLLX0
XU149 VSS n247 VDD_1V8 n223 n603 n413 ON21HDLLX0
XU285 VSS n672 n516 n625 VDD_1V8 NO2HDLLX0
XU277 VSS n667 n633 VDD_1V8 n480 NA2HDLLX0
XU558 VSS n338 n413 n716 VDD_1V8 NO2HDLLX0
XU359 VSS cur_state[7] n505 VDD_1V8 n174 NA2HDLLX0
XU362 VSS n488 cur_state[7] VDD_1V8 n615 NA2HDLLX0
XU247 n639 VSS n413 n660 n100 VDD_1V8 n92 ON211HDLLX0
XU246 VSS n513 n638 VDD_1V8 n145 NA2HDLLX0
XU235 VSS VDD_1V8 n81 n513 n80 n227 n79 AN211HDLLX0
XU229 n82 n713 n395 VSS VDD_1V8 n653 n78 AN31HDLLX0
XU222 VSS VDD_1V8 n83 n606 n325 n520 n97 AN211HDLLX0
XU213 n75 VSS VDD_1V8 n513 n74 n74 n535 n390 AN32HDLLX0
XU206 VSS VDD_1V8 n72 n442 n71 n70 n69 AN211HDLLX0
XU195 VSS VDD_1V8 n73 n712 n64 n449 n63 AN22HDLLX0
XU184 n55 VSS VDD_1V8 n389 n360 n360 n426 n517 AN32HDLLX0
XU181 VSS VDD_1V8 n56 n579 n716 n455 n555 AN22HDLLX0
XU178 VSS VDD_1V8 n52 n427 n603 n643 n691 AN211HDLLX0
XU174 VSS VDD_1V8 n53 n427 n521 cur_state[7] n51 AN211HDLLX0
XU171 VSS VDD_1V8 n54 n674 n395 n606 n50 AN22HDLLX0
XU350 n507 VSS n128 n484 VDD_1V8 n129 AN21HDLLX0
XU346 VSS VDD_1V8 n130 n296 n412 n653 n668 AN22HDLLX0
XU330 VSS VDD_1V8 n639 n591 n639 n124 n633 n121 OA32HDLLX0
XU323 VSS VDD_1V8 n116 n411 n403 n563 n402 AN22HDLLX0
XU147 VSS VDD_1V8 n43 cur_state[0] n37 n194 n36 AN211HDLLX0
XU156 VSS VDD_1V8 n42 n521 n166 n247 n41 AN211HDLLX0
XU737 VSS VDD_1V8 n692 n668 n704 n666 n665 AN211HDLLX0
XU739 VSS VDD_1V8 n690 n672 n673 n677 n671 AN22HDLLX0
XU743 VSS VDD_1V8 n689 n686 n687 n688 n685 AN22HDLLX0
XU317 n291 VSS VDD_1V8 n700 INHDLLX0
XU644 n558 VSS VDD_1V8 n621 INHDLLX0
XU647 VSS s_csr_pre[2] n615 n487 VDD_1V8 NO2HDLLX0
XU311 VSS VDD_1V8 n111 n604 n594 n508 n593 AN211HDLLX0
XU651 n489 VSS VDD_1V8 n623 INHDLLX0
XU306 VSS cur_state[4] n595 VDD_1V8 n644 NA2HDLLX0
XU666 n512 VSS n514 n595 n488 VDD_1V8 n515 ON211HDLLX0
XU676 n530 n529 VSS VDD_1V8 n555 n531 n601 NA4HDLLX0
XU293 VSS n426 n603 VDD_1V8 n108 NA2HDLLX0
XU681 n539 n535 n705 VSS VDD_1V8 n536 n686 AN31HDLLX0
XU682 n538 VSS VDD_1V8 n537 n638 n638 n516 n677 AN32HDLLX0
XU686 VSS n552 VDD_1V8 n513 n429 n517 ON21HDLLX0
XU687 n553 VSS n632 cur_state[1] VDD_1V8 n545 AN21HDLLX0
XU692 VSS VDD_1V8 n559 n622 n557 n686 n556 AN22HDLLX0
XU289 n506 VSS VDD_1V8 n547 INHDLLX0
XU696 VSS n572 VDD_1V8 n567 n584 n516 ON21HDLLX0
XU697 n568 n684 VSS VDD_1V8 n569 n570 n664 NA4HDLLX0
XU712 n611 n603 n604 VSS VDD_1V8 n513 n602 AN31HDLLX0
XU714 VSS VDD_1V8 n609 n608 n607 n653 n622 AN211HDLLX0
XU278 n101 VSS VDD_1V8 n480 INHDLLX0
XU719 n620 VSS n516 VDD_1V8 n619 n618 n617 n516 AN221HDLLX0
XU722 VSS VDD_1V8 n628 n426 n549 n427 n513 AN211HDLLX0
XU727 n633 VSS n637 n664 VDD_1V8 n641 AN21HDLLX0
XU273 VSS VDD_1V8 n117 n630 n510 n667 n704 AN22HDLLX0
XU547 VSS VDD_1V8 n321 n606 n414 n517 n497 AN22HDLLX0
XU557 VSS VDD_1V8 n340 n334 n608 n413 n333 AN22HDLLX0
XU562 VSS VDD_1V8 n339 n338 n500 n532 n337 AN211HDLLX0
XU445 VSS VDD_1V8 n236 n687 n197 n388 n704 AN22HDLLX0
XU582 VSS VDD_1V8 n381 n365 n366 n507 n364 AN22HDLLX0
XU587 VSS VDD_1V8 n380 n372 n461 n371 n370 AN211HDLLX0
XU590 n379 cur_state[0] n378 VSS VDD_1V8 n463 n377 AN31HDLLX0
XU593 VSS VDD_1V8 n393 n653 n413 n532 n384 AN211HDLLX0
XU594 VSS VDD_1V8 n392 n386 n387 n388 n717 AN22HDLLX0
XU595 VSS n391 VDD_1V8 n360 n555 n389 ON21HDLLX0
XU604 n410 VSS n409 n716 VDD_1V8 n476 AN21HDLLX0
XU442 VSS cur_state[0] n333 VDD_1V8 n294 NA2HDLLX0
XU160 VSS n524 cur_state[1] n429 VDD_1V8 NO2HDLLX0
XU621 n452 VSS n454 n555 n453 VDD_1V8 n475 ON211HDLLX0
XU631 VSS VDD_1V8 n474 n595 n654 n473 n472 AN22HDLLX0
XU439 VSS VDD_1V8 n195 n194 n584 n513 n325 AN22HDLLX0
XU434 n187 n333 n482 VSS VDD_1V8 n642 n186 AN31HDLLX0
XU425 VSS VDD_1V8 n188 n546 n278 n507 n295 AN22HDLLX0
XU55 VSS VDD_1V8 n13 n288 n516 n11 n10 AN211HDLLX0
XU421 n189 n716 n394 VSS VDD_1V8 n520 n182 AN31HDLLX0
XU409 VSS VDD_1V8 n171 n673 n394 n263 n170 AN211HDLLX0
XU405 VSS VDD_1V8 n172 n642 n668 n517 n315 AN22HDLLX0
XU404 n173 n333 n426 VSS VDD_1V8 n383 n169 AN31HDLLX0
XU639 n640 VSS VDD_1V8 n549 n569 n633 NO3HDLLX0
XU453 n235 n716 n326 VSS VDD_1V8 n677 n206 AN31HDLLX0
XU38 VSS n521 n716 VDD_1V8 n9 NA2HDLLX0
XU384 VSS n507 n406 VDD_1V8 n147 NA2HDLLX0
XU383 VSS n148 VDD_1V8 cur_state[1] n146 n166 ON21HDLLX0
XU376 VSS VDD_1V8 n144 n289 n595 n143 n688 AN211HDLLX0
XU476 n234 n713 n633 VSS VDD_1V8 n638 n232 AN31HDLLX0
XU363 n571 VSS VDD_1V8 n615 INHDLLX0
XU360 n573 VSS VDD_1V8 n174 INHDLLX0
XU480 VSS n242 n584 VDD_1V8 n613 NA2HDLLX0
XU544 n316 VSS n463 n704 VDD_1V8 n522 NA3HDLLX0
XU543 VSS VDD_1V8 n317 n688 n360 n378 n315 AN22HDLLX0
XU542 n318 n314 n508 VSS VDD_1V8 n654 n313 AN31HDLLX0
XU535 n498 VSS n655 n520 VDD_1V8 n440 NA3HDLLX0
XU533 VSS VDD_1V8 n443 n714 n710 n306 n423 NA4I3HDLLX0
XU495 VSS VDD_1V8 n260 n259 n258 n600 n368 AN211HDLLX0
XU498 VSS n262 VDD_1V8 n261 n561 n463 ON21HDLLX0
XU502 VSS VDD_1V8 n286 n705 n429 n275 n384 AN211HDLLX0
XU519 VSS VDD_1V8 n285 n563 n284 n677 n283 AN22HDLLX0
XU532 VSS VDD_1V8 n307 n708 n305 n442 n304 AN22HDLLX0
XU526 n695 VSS VDD_1V8 n577 INHDLLX0
XU88 VSS n20 VDD_1V8 n664 n46 n341 ON21HDLLX0
XU86 VSS VDD_1V8 n21 n517 n18 n413 n312 AN22HDLLX0
XU89 n19 VSS VDD_1V8 n563 INHDLLX0
XU76 n15 n322 n413 VSS VDD_1V8 n563 n14 AN31HDLLX0
XU61 VSS VDD_1V8 n12 n717 n46 n387 n455 AN22HDLLX0
XU281 VSS n576 n505 n696 VDD_1V8 NO2HDLLX0
XU718 VSS n626 n633 n426 VDD_1V8 NO2HDLLX0
XU78 n223 VSS n636 n243 n15 VDD_1V8 n16 ON211HDLLX0
XU693 n558 VSS n561 n560 n559 VDD_1V8 n562 ON211HDLLX0
XU689 VSS VDD_1V8 n550 n664 n627 n606 n548 AN211HDLLX0
XU688 n546 VSS n545 n547 VDD_1V8 n551 AN21HDLLX0
XU279 n524 VSS n101 n705 VDD_1V8 n102 AN21HDLLX0
XU290 VSS n506 n633 VDD_1V8 n104 NA2HDLLX0
XU683 n538 VSS n627 n617 n539 VDD_1V8 n540 ON211HDLLX0
XU720 VSS VDD_1V8 n624 n623 n622 n621 n620 AN211HDLLX0
XU679 VSS VDD_1V8 n541 n426 n360 n429 n577 AN211HDLLX0
XU63 n12 VSS n390 n13 VDD_1V8 n17 AN21HDLLX0
XU677 VSS VDD_1V8 n533 n517 n629 n532 n531 AN211HDLLX0
XU715 n612 VSS VDD_1V8 n609 n440 cur_state[4] n610 n611 AN32HDLLX0
XU672 VSS n704 n505 VDD_1V8 n585 NA2HDLLX0
XU670 VSS n581 n522 n591 VDD_1V8 NO2HDLLX0
XU667 n518 VSS n655 VDD_1V8 n630 n667 n515 n535 AN221HDLLX0
XU662 VSS VDD_1V8 n519 n633 n674 n506 n681 AN22HDLLX0
XU300 n649 VSS VDD_1V8 n412 n124 n667 NO3HDLLX0
XU723 VSS VDD_1V8 n647 n638 n549 n629 n628 AN211HDLLX0
XU661 VSS n504 n695 VDD_1V8 s_pc1_pre[0] AND2HDLLX0
XU303 n110 VSS VDD_1V8 n522 INHDLLX0
XU304 n108 VSS n542 n427 VDD_1V8 n109 AN21HDLLX0
XU157 n44 VSS VDD_1V8 n42 n595 n390 n43 ON22HDLLX0
XU307 n113 VSS VDD_1V8 n644 INHDLLX0
XU652 n591 VSS n489 n577 VDD_1V8 n490 AN21HDLLX0
XU650 n491 VSS n603 VDD_1V8 cur_state[4] n440 n696 n660 AN221HDLLX0
XU312 n112 VSS VDD_1V8 n639 n111 n111 n657 n694 AN32HDLLX0
XU641 VSS VDD_1V8 n575 n413 n605 n427 n632 AN211HDLLX0
XU744 n693 VSS VDD_1V8 cur_state[4] n689 n440 n690 n692 AN32HDLLX0
XU318 n651 VSS VDD_1V8 n414 INHDLLX0
XU520 n287 VSS VDD_1V8 n691 n285 n285 n323 n286 AN32HDLLX0
XU499 n636 n262 VSS VDD_1V8 n368 n264 n627 NA4HDLLX0
XU496 n265 n716 n482 VSS VDD_1V8 n688 n260 AN31HDLLX0
XU534 n320 n306 n429 VSS VDD_1V8 n307 n523 AN31HDLLX0
XU536 n699 VSS VDD_1V8 n498 INHDLLX0
XU482 n243 VSS n405 n592 VDD_1V8 n244 AN21HDLLX0
XU481 n245 VSS VDD_1V8 n696 n613 n427 NO3HDLLX0
XU545 VSS VDD_1V8 n319 n316 n317 n318 n488 AN22HDLLX0
XU361 n683 VSS n166 n426 n135 VDD_1V8 n137 ON211HDLLX0
XU365 n597 n589 VSS VDD_1V8 n427 n136 n664 NA4HDLLX0
XU477 n237 VSS VDD_1V8 n234 n440 cur_state[4] n235 n236 AN32HDLLX0
XU379 n151 VSS VDD_1V8 n207 n144 n144 n589 n584 AN32HDLLX0
XU380 n150 n145 n177 VSS VDD_1V8 n549 n291 AN31HDLLX0
XU385 n149 n147 n148 VSS VDD_1V8 n678 n615 AN31HDLLX0
XU39 n59 VSS VDD_1V8 n368 n9 n657 n595 ON22HDLLX0
XU410 n171 VSS n173 n394 n172 VDD_1V8 n192 ON211HDLLX0
XU411 n191 n394 n175 VSS VDD_1V8 n176 n174 AN31HDLLX0
XU435 n190 n187 n188 VSS VDD_1V8 n189 n644 AN31HDLLX0
XU632 n477 VSS VDD_1V8 n488 n474 n505 n475 n476 AN32HDLLX0
XU440 n196 n480 n549 VSS VDD_1V8 n195 n615 AN31HDLLX0
XU443 n238 n294 n516 VSS VDD_1V8 n522 n549 AN31HDLLX0
XU597 n691 n507 VSS VDD_1V8 n396 n395 NO22HDLLX0
XU596 n397 n391 n392 VSS VDD_1V8 n393 n390 AN31HDLLX0
XU591 n379 VSS cur_state[7] n381 n380 VDD_1V8 n382 ON211HDLLX0
XU268 n557 VSS n405 n583 VDD_1V8 n96 AN21HDLLX0
XU563 VSS n342 VDD_1V8 n340 n339 n341 n513 ON31HDLLX0
XU554 n327 VSS VDD_1V8 n716 n487 n636 n675 ON22HDLLX0
XU550 n328 VSS VDD_1V8 n670 n322 n480 n610 ON22HDLLX0
XU548 VSS n329 VDD_1V8 n321 n547 n394 ON21HDLLX0
XU90 n45 n20 n580 VSS VDD_1V8 n21 n19 AN31HDLLX0
XU728 VSS VDD_1V8 n645 n643 n642 n641 n640 AN211HDLLX0
XU724 VSS VDD_1V8 n646 n631 n632 n513 n681 AN22HDLLX0
XU179 VSS VDD_1V8 n58 n52 n53 n54 n560 AN22HDLLX0
XU185 n57 n55 n598 VSS VDD_1V8 n56 n390 AN31HDLLX0
XU207 VSS VDD_1V8 n86 n73 n72 cur_state[7] n513 AN211HDLLX0
XU214 VSS n85 VDD_1V8 n75 n691 n225 ON21HDLLX0
XU236 n84 VSS VDD_1V8 cur_state[7] n81 n595 n82 n83 AN32HDLLX0
XU249 VSS VDD_1V8 n93 n516 n92 n312 n408 AN211HDLLX0
XU260 n701 VSS n488 n655 VDD_1V8 n266 AN21HDLLX0
XU336 VSS n126 cur_state[4] n535 VDD_1V8 NO2HDLLX0
XU331 VSS n122 VDD_1V8 n121 n662 n591 ON21HDLLX0
XU357 n132 n684 n583 VSS VDD_1V8 n580 n636 AN31HDLLX0
XU355 VSS VDD_1V8 n133 cur_state[7] n341 cur_state[4] n555 AN211HDLLX0
XU354 VSS n134 n655 n623 VDD_1V8 NO2HDLLX0
XU351 n129 VSS n549 n323 n130 VDD_1V8 n131 ON211HDLLX0
XU324 VSS n118 VDD_1V8 n116 n603 n117 ON21HDLLX0
XU158 VSS VDD_1V8 n47 n46 n536 n45 n44 AN211HDLLX0
XU745 n697 n360 n695 VSS VDD_1V8 n638 n693 AN31HDLLX0
XU747 n703 VSS VDD_1V8 enbl_ntrpt INHDLLX0
XU748 n700 VSS n699 n701 VDD_1V8 n702 AN21HDLLX0
XU642 VSS n486 VDD_1V8 cur_state[4] n575 n517 ON21HDLLX0
XU645 n485 n394 n440 VSS VDD_1V8 n484 n558 AN31HDLLX0
XU649 VSS VDD_1V8 n494 n507 n594 n638 n604 AN22HDLLX0
XU653 VSS VDD_1V8 n493 n667 n491 n490 s_pc1_pre[1] AN211HDLLX0
XU655 VSS VDD_1V8 n497 n667 n495 n499 n496 NA4I3HDLLX0
XU658 n503 VSS VDD_1V8 n521 n556 n667 NO3HDLLX0
XU659 VSS n500 n700 VDD_1V8 n501 NA2HDLLX0
XU301 n106 n105 cur_state[4] VSS VDD_1V8 n686 n649 AN31HDLLX0
XU291 VSS VDD_1V8 n107 n534 n557 n672 n104 AN22HDLLX0
XU282 n587 VSS VDD_1V8 n576 INHDLLX0
XU280 n696 VSS n103 VDD_1V8 n102 n694 n117 n405 n483 OA222HDLLX0
XU269 n97 VSS n96 n688 VDD_1V8 n98 AN21HDLLX0
XU265 n525 VSS n704 n603 VDD_1V8 n667 NA3HDLLX0
XU264 VSS VDD_1V8 n99 n688 n326 n677 n630 AN22HDLLX0
XU441 n240 n700 n506 VSS VDD_1V8 n705 n196 AN31HDLLX0
XU438 VSS n488 n537 VDD_1V8 n582 NA2HDLLX0
XU313 VSS VDD_1V8 n114 n113 n112 n686 n649 AN211HDLLX0
XU436 VSS VDD_1V8 n193 n505 n192 n191 n190 AN211HDLLX0
XU358 VSS VDD_1V8 n139 n132 n133 n134 n440 AN22HDLLX0
XU164 VSS VDD_1V8 n90 n704 n524 n517 n619 AN22HDLLX0
XU186 VSS VDD_1V8 n89 n426 n59 n58 n57 AN211HDLLX0
XU386 VSS VDD_1V8 n152 n505 n151 n150 n149 AN211HDLLX0
XU237 VSS VDD_1V8 n88 n87 n86 n85 n84 AN211HDLLX0
XU366 VSS VDD_1V8 n138 n571 n137 n573 n136 AN22HDLLX0
XU546 VSS VDD_1V8 n331 n695 n320 n699 n319 AN211HDLLX0
XU524 VSS VDD_1V8 n332 n516 n517 n482 n295 AN22HDLLX0
XU522 VSS n290 n642 n289 VDD_1V8 NO2HDLLX0
XU244 n91 VSS VDD_1V8 n625 n683 n631 NO3HDLLX0
XU521 VSS VDD_1V8 n292 n537 n288 n440 n287 AN211HDLLX0
XU250 VSS n95 VDD_1V8 n93 n145 cur_state[1] ON21HDLLX0
XU483 VSS n246 VDD_1V8 n505 n244 n245 ON21HDLLX0
XU256 VSS VDD_1V8 n591 n568 n591 n600 n414 n94 OA32HDLLX0
XU352 VSS VDD_1V8 n140 n680 n642 n673 n131 AN211HDLLX0
XU478 n238 VSS n237 n573 VDD_1V8 n239 AN21HDLLX0
XU338 n502 VSS VDD_1V8 n386 n126 n126 n383 n413 AN32HDLLX0
XU335 n127 VSS n537 VDD_1V8 n604 n627 n372 n537 AN221HDLLX0
XU332 n123 n700 n664 VSS VDD_1V8 n413 n122 AN31HDLLX0
XU326 n119 VSS n414 n576 VDD_1V8 n324 NA3HDLLX0
XU325 n120 n651 n334 VSS VDD_1V8 n688 n118 AN31HDLLX0
XU668 VSS VDD_1V8 n527 n519 n573 n520 n518 AN22HDLLX0
XU671 n523 VSS n524 n656 n581 VDD_1V8 n526 ON211HDLLX0
XU678 n544 VSS n654 VDD_1V8 n668 n618 n533 n654 AN221HDLLX0
XU684 VSS VDD_1V8 n543 n440 n603 n541 n540 AN22HDLLX0
XU690 VSS VDD_1V8 n566 n687 n552 n551 n550 AN211HDLLX0
XU694 n565 VSS VDD_1V8 n440 n562 n488 n563 n564 AN32HDLLX0
XU699 n578 n603 n575 VSS VDD_1V8 n576 n574 AN31HDLLX0
XU703 n605 VSS n427 n413 VDD_1V8 n588 AN21HDLLX0
XU704 VSS n585 n427 VDD_1V8 n586 n584 NA3I2HDLLX0
XU706 n589 n597 VSS VDD_1V8 n652 n590 n427 NA4HDLLX0
XU708 VSS VDD_1V8 n616 n638 n605 n517 n604 AN211HDLLX0
XU716 n613 VSS n612 n642 VDD_1V8 n614 AN21HDLLX0
XU721 VSS n650 VDD_1V8 n625 n624 n626 n627 ON31HDLLX0
XU729 n648 n645 n646 VSS VDD_1V8 n647 n644 AN31HDLLX0
XU731 n698 n651 n652 VSS VDD_1V8 n705 s_pc1_pre[0] AN31HDLLX0
XU555 VSS VDD_1V8 n330 n553 n329 n328 n327 AN211HDLLX0
XU564 VSS VDD_1V8 n401 n563 n372 n413 n342 AN22HDLLX0
XU592 VSS VDD_1V8 n400 n440 n383 n700 n382 AN22HDLLX0
XU598 VSS VDD_1V8 n399 n536 n398 n397 n396 AN211HDLLX0
XU80 n674 n429 VSS VDD_1V8 n471 n48 n688 NA4HDLLX0
XU79 VSS VDD_1V8 n49 n667 n59 n17 n16 AN211HDLLX0
XU633 n477 n478 VSS VDD_1V8 n479 cur_state[0] NO22HDLLX0
XU635 n505 VSS n696 n522 VDD_1V8 n481 AN21HDLLX0
XU305 n115 n110 n595 VSS VDD_1V8 n513 n109 AN31HDLLX0
XU746 VSS n698 n697 VDD_1V8 N2318 NA2HDLLX0
XU749 VSS VDD_1V8 n1 n702 n703 IN0 reset AN22HDLLX0
XU646 VSS s_addrs_pre VDD_1V8 n485 n486 n640 ON21HDLLX0
XU654 ld_pc_pre VSS VDD_1V8 n492 n493 n493 n669 n494 AN32HDLLX0
XU656 VSS s_csr_pre[1] VDD_1V8 n498 n499 n582 ON21HDLLX0
XU660 n501 VSS n503 n582 n502 VDD_1V8 s_csr_pre[0] ON211HDLLX0
XU673 n585 n525 VSS VDD_1V8 n526 s_reg_w_pre[2] n527 NA4HDLLX0
XU685 s_reg_w_pre[1] VSS VDD_1V8 n440 n543 n543 n542 n544 AN32HDLLX0
XU695 VSS s_alu_pre[1] VDD_1V8 n565 n644 n566 ON21HDLLX0
XU700 s_alu_pre[0] VSS VDD_1V8 n577 n578 n578 n605 n579 AN32HDLLX0
XU701 VSS n581 n580 VDD_1V8 s_pc2_pre[1] AND2HDLLX0
XU702 VSS rst_tmr_pre n583 n582 VDD_1V8 NO2HDLLX0
XU705 VSS sign_ext_pre VDD_1V8 n586 n587 n588 ON21HDLLX0
XU707 VSS inv_r1_pre VDD_1V8 n590 n591 n592 ON21HDLLX0
XU717 VSS cntrl_alu_pre[2] VDD_1V8 n614 n615 n616 ON21HDLLX0
XU730 n649 VSS n648 n650 VDD_1V8 n440 cntrl_alu_pre[0] AO211HDLLX0
XU556 nxt_state[6] VSS VDD_1V8 n644 n331 n331 n330 n332 AN32HDLLX0
XU599 nxt_state[1] VSS VDD_1V8 n440 n400 n400 n399 n401 AN32HDLLX0
XU634 VSS nxt_state[0] VDD_1V8 n479 n577 n480 ON21HDLLX0
XU636 VSS r_1_w_0_mbc_pre VDD_1V8 n481 n505 n482 ON21HDLLX0
XU637 VSS pop_intrpt_pre n483 n582 VDD_1V8 NO2HDLLX0
XU638 VSS ld_id_instrl_deco_pre n669 n577 VDD_1V8 NO2HDLLX0
XU479 n239 VSS n639 n582 n240 VDD_1V8 nxt_state[5] ON211HDLLX0
XU484 VSS b_mbc_pre VDD_1V8 n587 n246 n247 n604 ON31HDLLX0
XU523 VSS n478 n294 VDD_1V8 n291 n292 n290 nxt_state[4] n293 ON222HDLLX0
XU367 n138 VSS n140 n440 n139 VDD_1V8 cntrl_alu_pre[1] ON211HDLLX0
XU387 n492 VSS n644 n529 n152 VDD_1V8 s_reg_w_pre[0] ON211HDLLX0
XU437 n291 VSS n701 n615 n193 VDD_1V8 nxt_state[7] ON211HDLLX0
XU261 VSS VDD_1V8 csr_write_pre n94 n488 n95 n266 AN22HDLLX0
XU270 h_mbc_pre VSS VDD_1V8 n98 n505 n488 n525 n99 AN32HDLLX0
XU284 ld_addrs_pre VSS VDD_1V8 n587 n676 n103 n488 ON22HDLLX0
XU302 VSS cntrl_alu_pre[3] VDD_1V8 n106 n107 cur_state[4] ON21HDLLX0
XU314 VSS s_pc2_pre[0] VDD_1V8 n114 n115 n488 ON21HDLLX0
XU327 VSS n125 n488 VDD_1V8 n413 n120 n119 enable_mbc_pre n291 ON321HDLLX0
XU333 VSS s_alu_pre[2] VDD_1V8 n123 n124 n243 ON21HDLLX0
XU339 VSS s_reg_w_pre[3] VDD_1V8 n502 n440 n127 ON21HDLLX0
XU238 nxt_state[3] VSS VDD_1V8 n88 n440 cur_state[4] n89 n90 AN32HDLLX0
XU245 N2317 VSS VDD_1V8 n91 n440 cur_state[4] n704 n504 AN32HDLLX0
XU159 nxt_state[2] VSS VDD_1V8 n47 n440 cur_state[4] n48 n49 AN32HDLLX0
Xplace3 n241 VSS VDD_1V8 IN1 INHDLLX1
Xplace48 n712 VSS VDD_1V8 n443 INHDLLX0
Xplace44 n708 VSS VDD_1V8 n356 INHDLLX0
Xplace37 n691 VSS VDD_1V8 n654 INHDLLX0
Xplace35 n684 VSS VDD_1V8 n627 INHDLLX0
Xplace29 n655 VSS VDD_1V8 n535 INHDLLX0
Xenbl_ntrpt_reg VSS clk n1 enbl_ntrpt VDD_1V8 DFRQHDLLX0
Xinv_r1_reg n241 clk_cts_4 inv_r1_pre inv_r1 VSS VDD_1V8 DFRRQHDLLX0
Xsign_ext_reg n241 clk sign_ext_pre sign_ext VSS VDD_1V8 DFRRQHDLLX0
Xcntrl_alu_reg_0_ n241 clk cntrl_alu_pre[0] cntrl_alu[0] VSS VDD_1V8 DFRRQHDLLX0
Xcntrl_alu_reg_1_ n241 clk cntrl_alu_pre[1] cntrl_alu[1] VSS VDD_1V8 DFRRQHDLLX0
Xcntrl_alu_reg_2_ n241 clk cntrl_alu_pre[2] cntrl_alu[2] VSS VDD_1V8 DFRRQHDLLX0
Xcntrl_alu_reg_3_ n241 clk cntrl_alu_pre[3] cntrl_alu[3] VSS VDD_1V8 DFRRQHDLLX0
Xcsr_write_reg n241 clk csr_write_pre csr_write VSS VDD_1V8 DFRRQHDLLX0
Xwrite_reg_fl_reg n241 clk write_reg_fl_pre write_reg_fl VSS VDD_1V8 DFRRQHDLLX0
Xrst_tmr_reg reset clk rst_tmr_pre rst_tmr VSS VDD_1V8 DFRRQHDLLX0
Xs_pc2_reg_0_ n241 clk_cts_4 s_pc2_pre[0] s_pc2[0] VSS VDD_1V8 DFRRQHDLLX0
Xs_pc2_reg_1_ n241 clk_cts_4 s_pc2_pre[1] s_pc2[1] VSS VDD_1V8 DFRRQHDLLX0
Xs_alu_reg_0_ n241 clk_cts_4 s_alu_pre[0] s_alu[0] VSS VDD_1V8 DFRRQHDLLX0
Xs_alu_reg_1_ n241 clk s_alu_pre[1] s_alu[1] VSS VDD_1V8 DFRRQHDLLX0
Xs_alu_reg_2_ n241 clk s_alu_pre[2] s_alu[2] VSS VDD_1V8 DFRRQHDLLX0
Xs_reg_w_reg_0_ n241 clk_cts_4 s_reg_w_pre[0] s_reg_w[0] VSS VDD_1V8 DFRRQHDLLX0
Xs_reg_w_reg_1_ n241 clk_cts_4 s_reg_w_pre[1] s_reg_w[1] VSS VDD_1V8 DFRRQHDLLX0
Xs_reg_w_reg_2_ n241 clk s_reg_w_pre[2] s_reg_w[2] VSS VDD_1V8 DFRRQHDLLX0
Xs_reg_w_reg_3_ n241 clk_cts_4 s_reg_w_pre[3] s_reg_w[3] VSS VDD_1V8 DFRRQHDLLX0
Xs_pc1_reg_0_ n241 clk s_pc1_pre[0] s_pc1[0] VSS VDD_1V8 DFRRQHDLLX0
Xs_pc1_reg_1_ n241 clk s_pc1_pre[1] s_pc1[1] VSS VDD_1V8 DFRRQHDLLX0
Xs_csr_reg_0_ n241 clk s_csr_pre[0] s_csr[0] VSS VDD_1V8 DFRRQHDLLX0
Xs_csr_reg_1_ n241 clk s_csr_pre[1] s_csr[1] VSS VDD_1V8 DFRRQHDLLX0
Xs_csr_reg_2_ n241 clk s_csr_pre[2] s_csr[2] VSS VDD_1V8 DFRRQHDLLX0
Xld_pc_reg n241 clk_cts_4 ld_pc_pre ld_pc VSS VDD_1V8 DFRRQHDLLX0
Xs_addrs_reg n241 clk s_addrs_pre s_addrs VSS VDD_1V8 DFRRQHDLLX0
Xld_addrs_reg n241 clk_cts_4 ld_addrs_pre ld_addrs VSS VDD_1V8 DFRRQHDLLX0
Xld_id_instrl_deco_reg n241 clk_cts_4 ld_id_instrl_deco_pre ld_id_instrl_deco VSS
+ VDD_1V8 DFRRQHDLLX0
Xpop_intrpt_reg n241 clk pop_intrpt_pre pop_intrpt VSS VDD_1V8 DFRRQHDLLX0
Xenable_mbc_reg n241 clk_cts_4 enable_mbc_pre enable_mbc VSS VDD_1V8 DFRRQHDLLX0
Xh_mbc_reg n241 clk_cts_4 h_mbc_pre h_mbc VSS VDD_1V8 DFRRQHDLLX0
Xb_mbc_reg n241 clk_cts_4 b_mbc_pre b_mbc VSS VDD_1V8 DFRRQHDLLX0
Xr_1_w_0_mbc_reg n241 clk r_1_w_0_mbc_pre r_1_w_0_mbc VSS VDD_1V8 DFRRQHDLLX0
XU698 n573 VSS VDD_1V8 n571 n572 n570 n574 AO22HDLLX1
XU9 s_pc1_pre[1] VSS s_csr_pre[2] VDD_1V8 n498 NA2I1HDLLX0
XU500 n263 VSS n265 n264 VDD_1V8 n266 n293 NO4I3HDLLX0
XU430 VSS n185 VDD_1V8 n183 n457 n548 n375 OA211HDLLX0
XU691 VSS n564 VDD_1V8 n553 n555 n429 n552 OA211HDLLX0
XU295 n629 VSS n145 n108 VDD_1V8 n177 n105 NO4I3HDLLX0
XU711 n599 VSS n516 n600 VDD_1V8 n601 n602 NO4I3HDLLX0
.ENDS

.SUBCKT mbc_max13 clk reset address[24] address[23] address[22] address[21] address[20]
+ address[19] address[18] address[17] address[16] address[15] address[14] address[13]
+ address[12] address[11] address[10] address[9] address[8] address[7] address[6]
+ address[5] address[4] address[3] address[2] address[1] address[0] d_write[31]
+ d_write[30] d_write[29] d_write[28] d_write[27] d_write[26] d_write[25] d_write[24]
+ d_write[23] d_write[22] d_write[21] d_write[20] d_write[19] d_write[18] d_write[17]
+ d_write[16] d_write[15] d_write[14] d_write[13] d_write[12] d_write[11] d_write[10]
+ d_write[9] d_write[8] d_write[7] d_write[6] d_write[5] d_write[4] d_write[3] d_write[2]
+ d_write[1] d_write[0] b h enable r_w d_pop[61] d_pop[60] d_pop[59] d_pop[58] d_pop[57]
+ d_pop[56] d_pop[55] d_pop[54] d_pop[53] d_pop[52] d_pop[51] d_pop[50] d_pop[49]
+ d_pop[48] d_pop[47] d_pop[46] d_pop[45] d_pop[44] d_pop[43] d_pop[42] d_pop[41]
+ d_pop[40] d_pop[39] d_pop[38] d_pop[37] d_pop[36] d_pop[35] d_pop[34] d_pop[33]
+ d_pop[32] d_pop[31] d_pop[30] d_pop[29] d_pop[28] d_pop[27] d_pop[26] d_pop[25]
+ d_pop[24] d_pop[23] d_pop[22] d_pop[21] d_pop[20] d_pop[19] d_pop[18] d_pop[17]
+ d_pop[16] d_pop[15] d_pop[14] d_pop[13] d_pop[12] d_pop[11] d_pop[10] d_pop[9]
+ d_pop[8] d_pop[7] d_pop[6] d_pop[5] d_pop[4] d_pop[3] d_pop[2] d_pop[1] d_pop[0]
+ pndng q[31] q[30] q[29] q[28] q[27] q[26] q[25] q[24] q[23] q[22] q[21] q[20]
+ q[19] q[18] q[17] q[16] q[15] q[14] q[13] q[12] q[11] q[10] q[9] q[8] q[7] q[6]
+ q[5] q[4] q[3] q[2] q[1] q[0] sign_ext d_read[31] d_read[30] d_read[29] d_read[28]
+ d_read[27] d_read[26] d_read[25] d_read[24] d_read[23] d_read[22] d_read[21] d_read[20]
+ d_read[19] d_read[18] d_read[17] d_read[16] d_read[15] d_read[14] d_read[13] d_read[12]
+ d_read[11] d_read[10] d_read[9] d_read[8] d_read[7] d_read[6] d_read[5] d_read[4]
+ d_read[3] d_read[2] d_read[1] d_read[0] a[10] a[9] a[8] a[7] a[6] a[5] a[4] a[3]
+ a[2] a[1] a[0] d[31] d[30] d[29] d[28] d[27] d[26] d[25] d[24] d[23] d[22] d[21]
+ d[20] d[19] d[18] d[17] d[16] d[15] d[14] d[13] d[12] d[11] d[10] d[9] d[8] d[7]
+ d[6] d[5] d[4] d[3] d[2] d[1] d[0] d_psh[64] d_psh[63] d_psh[62] d_psh[61] d_psh[60]
+ d_psh[59] d_psh[58] d_psh[57] d_psh[33] d_psh[32] d_psh[31] d_psh[30] d_psh[29]
+ d_psh[28] d_psh[27] d_psh[26] d_psh[25] d_psh[24] d_psh[23] d_psh[22] d_psh[21]
+ d_psh[20] d_psh[19] d_psh[18] d_psh[17] d_psh[16] d_psh[15] d_psh[14] d_psh[13]
+ d_psh[12] d_psh[11] d_psh[10] d_psh[9] d_psh[8] d_psh[7] d_psh[6] d_psh[5] d_psh[4]
+ d_psh[3] d_psh[2] d_psh[1] d_psh[0] psh mem_rdy pop_mbc error_drs clk_mem cen
+ sl wen VSS VDD_1V8 IN0 IN1 IN2 IN3 clk_cts_4
Xmux_sel_rd b h rd_fll sign_ext n171 n181 d_read_pre[31] d_read_pre[30] d_read_pre[29]
+ d_read_pre[28] d_read_pre[27] d_read_pre[26] d_read_pre[25] d_read_pre[24] d_read_pre[23]
+ d_read_pre[22] d_read_pre[21] d_read_pre[20] d_read_pre[19] d_read_pre[18] d_read_pre[17]
+ d_read_pre[16] d_read_pre[15] d_read_pre[14] d_read_pre[13] d_read_pre[12] d_read_pre[11]
+ d_read_pre[10] d_read_pre[9] d_read_pre[8] d_read_pre[7] d_read_pre[6] d_read_pre[5]
+ d_read_pre[4] d_read_pre[3] d_read_pre[2] d_read_pre[1] d_read_pre[0] q[31] q[30]
+ q[29] q[28] q[27] q[26] q[25] q[24] q[23] q[22] q[21] q[20] q[19] q[18] q[17]
+ q[16] q[15] q[14] q[13] q[12] q[11] q[10] q[9] q[8] q[7] q[6] q[5] q[4] q[3] q[2]
+ q[1] q[0] VSS VDD_1V8 address[0] address[1] mux_rd
Xcond_sel_reg_2_ cond_sel[2] VSS VDD_1V8 N449 N438 DLHQHDLLX0
Xerror_drs_reg error_drs VSS VDD_1V8 N446 N438 DLHQHDLLX0
Xboot_reg boot VSS VDD_1V8 N441 N438 DLHQHDLLX0
Xmem_rdy_reg mem_rdy VSS VDD_1V8 N443 N438 DLHQHDLLX0
Xpop_mbc_reg pop_mbc VSS VDD_1V8 N444 N438 DLHQHDLLX0
Xcen_reg cen VSS VDD_1V8 N440 N438 DLHQHDLLX0
Xrd_fll_reg rd_fll VSS VDD_1V8 N452 N451 DLHQHDLLX0
Xcond_sel_reg_1_ cond_sel[1] VSS VDD_1V8 N448 N438 DLHQHDLLX0
Xcond_sel_reg_3_ cond_sel[3] VSS VDD_1V8 N450 N438 DLHQHDLLX0
Xpsh_reg psh VSS VDD_1V8 N445 N438 DLHQHDLLX0
Xld_d_read_reg ld_d_read VSS VDD_1V8 N442 N438 DLHQHDLLX0
Xcond_sel_reg_0_ cond_sel[0] VSS VDD_1V8 N447 N438 DLHQHDLLX0
XU92 n33 VSS VDD_1V8 b INHDLLX0
XU97 n31 VSS VDD_1V8 h INHDLLX0
XU93 VSS n80 n33 h VDD_1V8 NO2HDLLX0
XU98 VSS n31 n33 VDD_1V8 n58 NA2HDLLX0
XU99 n5 VSS VDD_1V8 n58 INHDLLX0
XU94 n85 VSS VDD_1V8 n80 INHDLLX0
XU100 address[16] address[15] n1 VSS address[14] VDD_1V8 OR3HDLLX0
XU102 VSS n16 address[23] address[24] VDD_1V8 NO2HDLLX0
XU103 n6 VSS VDD_1V8 n16 INHDLLX0
XU95 VSS VDD_1V8 n4 address[0] n85 address[17] address[18] AN211HDLLX0
XU96 n3 VSS VDD_1V8 address[20] address[19] address[13] NO3HDLLX0
XU101 VSS VDD_1V8 n2 address[1] n5 address[21] n1 AN211HDLLX0
Xplace7 n182 VSS VDD_1V8 cond_sel[0] INHDLLX0
XU110 d_pop[59] d_pop[57] VSS VDD_1V8 n9 d_pop[58] NO3I2HDLLX0
XU104 n17 n2 n3 VSS VDD_1V8 n4 n6 AN31HDLLX0
XU111 n9 VSS d_pop[61] n182 VDD_1V8 n8 AN21HDLLX0
XU105 n15 VSS VDD_1V8 r_w INHDLLX0
XU118 n18 VSS VDD_1V8 b n182 h NO3HDLLX0
XU113 n10 VSS VDD_1V8 cond_sel[1] INHDLLX0
XU112 n8 VSS n182 n9 d_pop[60] VDD_1V8 n11 ON211HDLLX0
XU109 VSS VDD_1V8 n12 pndng enable cond_sel[0] n182 AN22HDLLX0
XU117 n19 VSS VDD_1V8 n17 INHDLLX0
XU107 n7 VSS VDD_1V8 r_w n182 cond_sel[0] n15 n5 AN32HDLLX0
XU116 VSS VDD_1V8 n22 n15 n16 cond_sel[0] n182 AN22HDLLX0
XU114 VSS VDD_1V8 n13 n11 n12 cond_sel[1] n10 AN22HDLLX0
XU119 VSS VDD_1V8 n21 n182 n19 cond_sel[1] n18 AN211HDLLX0
XU108 VSS n14 VDD_1V8 n6 cond_sel[3] n7 n17 ON31HDLLX0
Xplace4 n162 VSS VDD_1V8 state[4] INHDLLX0
XU115 n24 VSS VDD_1V8 cond_sel[3] n13 n14 cond_sel[1] ON22HDLLX0
XU120 VSS VDD_1V8 n23 cond_sel[1] n22 cond_sel[3] n21 AN211HDLLX0
XU121 VSS VDD_1V8 n173 n24 cond_sel[2] n23 MU2IHDLLX0
XU88 VSS state[1] n245 VDD_1V8 n158 NA2HDLLX0
XU67 VSS state[3] n162 VDD_1V8 n151 NA2HDLLX0
Xplace5 n171 VSS VDD_1V8 address[1] INHDLLX0
Xplace6 n181 VSS VDD_1V8 address[0] INHDLLX0
Xplace10 n185 VSS VDD_1V8 n173 INHDLLX0
XU89 VSS n120 state[3] n158 VDD_1V8 NO2HDLLX0
XU62 VSS n164 state[1] state[3] VDD_1V8 NO2HDLLX0
XU68 n139 VSS VDD_1V8 n151 INHDLLX0
XU251 VSS n244 n162 VDD_1V8 n125 NA2HDLLX0
XU128 VSS n25 VDD_1V8 n139 n185 n245 ON21HDLLX0
XU269 VSS n162 n253 VDD_1V8 n157 NA2HDLLX0
XU63 VSS state[4] n164 VDD_1V8 n133 NA2HDLLX0
XU69 VSS n254 n139 VDD_1V8 n124 NA2HDLLX0
XU90 VSS n244 n120 VDD_1V8 n131 NA2HDLLX0
Xplace3 n146 VSS VDD_1V8 state[1] INHDLLX0
Xplace8 VSS VDD_1V8 n183 boot BUHDLLX0
XU124 n175 VSS VDD_1V8 n133 INHDLLX0
XU270 VSS n127 n157 state[1] VDD_1V8 NO2HDLLX0
XU91 VSS N446 n162 n131 VDD_1V8 NO2HDLLX0
XU70 VSS n145 n124 state[1] VDD_1V8 NO2HDLLX0
XU188 VSS n60 n171 address[0] VDD_1V8 NO2HDLLX0
XU142 n86 VSS n171 h VDD_1V8 n33 NA3HDLLX0
XU253 VSS n138 n254 state[3] VDD_1V8 NO2HDLLX0
XU129 VSS VDD_1V8 n26 n245 n185 n146 n25 AN211HDLLX0
XU263 n152 VSS VDD_1V8 state[3] n125 n245 NO3HDLLX0
XU297 n174 VSS VDD_1V8 n254 n151 state[1] NO3HDLLX0
XU281 VSS n131 n132 VDD_1V8 state[3] n157 n245 OA31HDLLX0
XU271 n167 VSS VDD_1V8 n127 INHDLLX0
XU256 n123 VSS VDD_1V8 n138 INHDLLX0
XU259 n166 VSS VDD_1V8 n120 INHDLLX0
XU280 VSS n139 n253 VDD_1V8 n153 NA2HDLLX0
XU258 VSS state[4] n138 VDD_1V8 n134 NA2HDLLX0
XU219 VSS n84 n171 n181 VDD_1V8 NO2HDLLX0
XU71 n165 VSS VDD_1V8 n145 INHDLLX0
XU122 VSS n173 n244 VDD_1V8 n144 NA2HDLLX0
XU125 n122 VSS n244 n175 VDD_1V8 n254 NA3HDLLX0
Xplace9 n184 VSS VDD_1V8 n183 INHDLLX0
XU189 n59 VSS VDD_1V8 n60 INHDLLX0
XU143 VSS n86 n58 VDD_1V8 n37 AND2HDLLX0
XU160 VSS n38 n181 address[1] VDD_1V8 NO2HDLLX0
XU304 n168 VSS VDD_1V8 mem_rdy INHDLLX0
XU130 n175 VSS n26 n245 VDD_1V8 n27 AN21HDLLX0
XU144 VSS n34 address[1] address[0] VDD_1V8 NO2HDLLX0
XU131 VSS n245 n173 VDD_1V8 n160 NA2HDLLX0
XU298 VSS n154 VDD_1V8 n174 n185 n152 N446 ON31HDLLX0
XU147 n81 VSS address[1] n33 VDD_1V8 h NA3HDLLX0
XU145 n32 VSS VDD_1V8 n34 INHDLLX0
XU186 VSS n108 n183 n58 VDD_1V8 NO2HDLLX0
XU126 n29 VSS VDD_1V8 n122 INHDLLX0
XU290 VSS n141 VDD_1V8 n146 n144 n245 n139 OA211HDLLX0
XU288 N450 VSS VDD_1V8 n146 n157 state[3] NO3HDLLX0
XU282 VSS n172 VDD_1V8 n132 n153 n158 ON21HDLLX0
XU299 n155 VSS VDD_1V8 n153 n154 n154 n185 state[1] AN32HDLLX0
XU277 n146 VSS n125 state[3] VDD_1V8 n126 AN21HDLLX0
XU275 n161 VSS VDD_1V8 n124 n253 n146 NO3HDLLX0
XU265 VSS n156 state[1] n125 VDD_1V8 NO2HDLLX0
XU303 VSS n170 VDD_1V8 n165 n166 state[4] ON21HDLLX0
XU260 VSS VDD_1V8 n116 n253 n151 n134 n166 AN22HDLLX0
XU305 VSS VDD_1V8 n169 n185 n168 state[3] n167 AN211HDLLX0
XU257 VSS VDD_1V8 n118 n123 n244 state[1] n146 AN22HDLLX0
XU132 n28 VSS VDD_1V8 n160 n133 n27 n244 ON22HDLLX0
XU191 VSS VDD_1V8 n75 n86 n85 n60 n183 AN211HDLLX0
XU190 n76 VSS n81 VDD_1V8 n85 n59 n183 n81 AN221HDLLX0
XU157 VSS n53 n183 n37 VDD_1V8 NO2HDLLX0
XU218 VSS n110 n183 n81 VDD_1V8 NO2HDLLX0
XU220 VSS VDD_1V8 n109 n86 n85 n84 n183 AN211HDLLX0
XU64 VSS n245 n244 VDD_1V8 n128 NA2HDLLX0
XU162 VSS VDD_1V8 n54 n81 n85 n38 n183 AN211HDLLX0
XU72 n117 VSS VDD_1V8 n124 INHDLLX0
XU161 VSS n55 n80 n38 VDD_1V8 n184 AND3HDLLX0
XU295 n164 VSS n162 n160 n244 VDD_1V8 n148 ON211HDLLX0
XU212 VSS VDD_1V8 n78 n108 d_pop[23] n183 d_write[23] AN22HDLLX0
XU213 VSS VDD_1V8 n77 n75 n76 d_write[7] d_read[23] AN22HDLLX0
XU215 n89 VSS VDD_1V8 d_write[0] INHDLLX0
XU216 address[0] n184 VSS VDD_1V8 address[1] n113 n80 NA4HDLLX0
XU217 VSS VDD_1V8 n88 n108 d_pop[24] n183 d_write[24] AN22HDLLX0
XU221 VSS VDD_1V8 n87 n109 n110 d_write[8] d_read[24] AN22HDLLX0
XU223 n92 VSS VDD_1V8 d_write[1] INHDLLX0
XU74 VSS n117 n253 VDD_1V8 n129 NA2HDLLX0
XU291 n142 n152 n173 VSS VDD_1V8 state[1] n141 AN31HDLLX0
XU289 n143 VSS VDD_1V8 N450 n254 n245 n253 n139 AN32HDLLX0
XU284 VSS n164 n253 VDD_1V8 n135 NA2HDLLX0
XU283 n133 VSS n245 n167 n134 VDD_1V8 n136 ON211HDLLX0
XU278 VSS VDD_1V8 n130 n164 n128 n127 n126 AN211HDLLX0
XU273 VSS n158 n253 VDD_1V8 n147 n139 NA3I2HDLLX0
XU300 n159 n254 n156 VSS VDD_1V8 n173 n155 AN31HDLLX0
XU302 n179 n253 n254 VSS VDD_1V8 n164 n161 AN31HDLLX0
XU266 VSS n121 VDD_1V8 n245 n156 n139 ON21HDLLX0
XU264 n177 VSS n120 n253 VDD_1V8 state[4] NA3HDLLX0
XU261 VSS VDD_1V8 n119 n118 n162 n117 n116 AN211HDLLX0
XU306 n178 VSS n172 VDD_1V8 n173 n185 n169 n170 AN221HDLLX0
XU307 VSS n176 VDD_1V8 n244 n174 n175 ON21HDLLX0
XU254 VSS VDD_1V8 n115 state[1] n162 n117 n138 AN211HDLLX0
XU252 VSS VDD_1V8 n137 n125 n175 NO2I1HDLLX0
XU249 VSS VDD_1V8 n111 n109 n110 d_write[15] d_read[31] AN22HDLLX0
XU248 VSS VDD_1V8 n112 n108 d_pop[31] n183 d_write[31] AN22HDLLX0
XU247 n114 VSS VDD_1V8 d_write[7] INHDLLX0
XU133 VSS VDD_1V8 n30 N446 n185 n29 n28 AN211HDLLX0
XU245 VSS VDD_1V8 n105 n109 n110 d_write[14] d_read[30] AN22HDLLX0
XU244 VSS VDD_1V8 n106 n108 d_pop[30] n183 d_write[30] AN22HDLLX0
XU243 n107 VSS VDD_1V8 d_write[6] INHDLLX0
XU241 VSS VDD_1V8 n102 n109 n110 d_write[13] d_read[29] AN22HDLLX0
XU240 VSS VDD_1V8 n103 n108 d_pop[29] n183 d_write[29] AN22HDLLX0
XU239 n104 VSS VDD_1V8 d_write[5] INHDLLX0
XU135 VSS VDD_1V8 d_psh[63] address[23] address[24] NO2I1HDLLX0
XU237 VSS VDD_1V8 n99 n109 n110 d_write[12] d_read[28] AN22HDLLX0
XU236 VSS VDD_1V8 n100 n108 d_pop[28] n183 d_write[28] AN22HDLLX0
XU235 n101 VSS VDD_1V8 d_write[4] INHDLLX0
XU233 VSS VDD_1V8 n96 n109 n110 d_write[11] d_read[27] AN22HDLLX0
XU232 VSS VDD_1V8 n97 n108 d_pop[27] n183 d_write[27] AN22HDLLX0
XU231 n98 VSS VDD_1V8 d_write[3] INHDLLX0
XU229 VSS VDD_1V8 n93 n109 n110 d_write[10] d_read[26] AN22HDLLX0
XU228 VSS VDD_1V8 n94 n108 d_pop[26] n183 d_write[26] AN22HDLLX0
XU227 n95 VSS VDD_1V8 d_write[2] INHDLLX0
XU225 VSS VDD_1V8 n90 n109 n110 d_write[9] d_read[25] AN22HDLLX0
XU224 VSS VDD_1V8 n91 n108 d_pop[25] n183 d_write[25] AN22HDLLX0
XU146 n35 VSS n37 VDD_1V8 n85 n32 n183 n37 AN221HDLLX0
XU148 VSS VDD_1V8 n36 n81 n85 n34 n183 AN211HDLLX0
XU158 VSS VDD_1V8 n40 d_write[8] d_pop[8] n183 n53 AN22HDLLX0
XU163 VSS VDD_1V8 n39 n54 n55 d_write[0] d_read[8] AN22HDLLX0
XU165 VSS VDD_1V8 n42 n53 d_pop[9] n183 d_write[9] AN22HDLLX0
XU166 VSS VDD_1V8 n41 n54 n55 d_write[1] d_read[9] AN22HDLLX0
XU168 VSS VDD_1V8 n44 n53 d_pop[10] n183 d_write[10] AN22HDLLX0
XU169 VSS VDD_1V8 n43 n54 n55 d_write[2] d_read[10] AN22HDLLX0
XU171 VSS VDD_1V8 n46 n53 d_pop[11] n183 d_write[11] AN22HDLLX0
XU172 VSS VDD_1V8 n45 n54 n55 d_write[3] d_read[11] AN22HDLLX0
XU174 VSS VDD_1V8 n48 n53 d_pop[12] n183 d_write[12] AN22HDLLX0
XU175 VSS VDD_1V8 n47 n54 n55 d_write[4] d_read[12] AN22HDLLX0
XU293 VSS VDD_1V8 n150 n152 n253 n175 n185 AN22HDLLX0
XU177 VSS VDD_1V8 n50 n53 d_pop[13] n183 d_write[13] AN22HDLLX0
XU178 VSS VDD_1V8 n49 n54 n55 d_write[5] d_read[13] AN22HDLLX0
XU180 VSS VDD_1V8 n52 n53 d_pop[14] n183 d_write[14] AN22HDLLX0
XU181 VSS VDD_1V8 n51 n54 n55 d_write[6] d_read[14] AN22HDLLX0
XU183 VSS VDD_1V8 n57 n53 d_pop[15] n183 d_write[15] AN22HDLLX0
XU184 VSS VDD_1V8 n56 n54 n55 d_write[7] d_read[15] AN22HDLLX0
XU187 VSS VDD_1V8 n62 n108 d_pop[16] n183 d_write[16] AN22HDLLX0
XU192 VSS VDD_1V8 n61 n75 n76 d_write[0] d_read[16] AN22HDLLX0
XU194 VSS VDD_1V8 n64 n108 d_pop[17] n183 d_write[17] AN22HDLLX0
XU195 VSS VDD_1V8 n63 n75 n76 d_write[1] d_read[17] AN22HDLLX0
XU197 VSS VDD_1V8 n66 n108 d_pop[18] n183 d_write[18] AN22HDLLX0
XU198 VSS VDD_1V8 n65 n75 n76 d_write[2] d_read[18] AN22HDLLX0
XU200 VSS VDD_1V8 n68 n108 d_pop[19] n183 d_write[19] AN22HDLLX0
XU201 VSS VDD_1V8 n67 n75 n76 d_write[3] d_read[19] AN22HDLLX0
XU203 VSS VDD_1V8 n70 n108 d_pop[20] n183 d_write[20] AN22HDLLX0
XU204 VSS VDD_1V8 n69 n75 n76 d_write[4] d_read[20] AN22HDLLX0
XU206 VSS VDD_1V8 n72 n108 d_pop[21] n183 d_write[21] AN22HDLLX0
XU207 VSS VDD_1V8 n71 n75 n76 d_write[5] d_read[21] AN22HDLLX0
XU209 VSS VDD_1V8 n74 n108 d_pop[22] n183 d_write[22] AN22HDLLX0
XU210 VSS VDD_1V8 n73 n75 n76 d_write[6] d_read[22] AN22HDLLX0
XU294 VSS VDD_1V8 n149 N450 n144 n145 n160 AN22HDLLX0
XU156 VSS d[7] d_pop[7] d_write[7] d_read[7] n35 VDD_1V8 n183 n36 AO222HDLLX0
XU164 VSS n40 n39 VDD_1V8 d[8] NA2HDLLX0
XU167 VSS n42 n41 VDD_1V8 d[9] NA2HDLLX0
XU170 VSS n44 n43 VDD_1V8 d[10] NA2HDLLX0
XU173 VSS n46 n45 VDD_1V8 d[11] NA2HDLLX0
XU176 VSS n48 n47 VDD_1V8 d[12] NA2HDLLX0
XU179 VSS n50 n49 VDD_1V8 d[13] NA2HDLLX0
XU182 VSS n52 n51 VDD_1V8 d[14] NA2HDLLX0
XU185 VSS n57 n56 VDD_1V8 d[15] NA2HDLLX0
XU193 VSS n62 n61 VDD_1V8 d[16] NA2HDLLX0
XU196 VSS n64 n63 VDD_1V8 d[17] NA2HDLLX0
XU199 VSS n66 n65 VDD_1V8 d[18] NA2HDLLX0
XU202 VSS n68 n67 VDD_1V8 d[19] NA2HDLLX0
XU205 VSS n70 n69 VDD_1V8 d[20] NA2HDLLX0
XU208 VSS n72 n71 VDD_1V8 d[21] NA2HDLLX0
XU211 VSS n74 n73 VDD_1V8 d[22] NA2HDLLX0
XU214 VSS n78 n77 VDD_1V8 d[23] NA2HDLLX0
XU222 n87 VSS n89 n113 n88 VDD_1V8 d[24] ON211HDLLX0
XU75 n129 VSS n133 n128 n165 VDD_1V8 N449 ON211HDLLX0
XU77 VSS a[9] VDD_1V8 n184 d_pop[43] address[11] MU2HDLLX0
XU78 VSS a[8] VDD_1V8 n184 d_pop[42] address[10] MU2HDLLX0
XU79 VSS a[7] VDD_1V8 n184 d_pop[41] address[9] MU2HDLLX0
XU80 VSS a[6] VDD_1V8 n184 d_pop[40] address[8] MU2HDLLX0
XU81 VSS a[5] VDD_1V8 n184 d_pop[39] address[7] MU2HDLLX0
XU82 VSS a[4] VDD_1V8 n184 d_pop[38] address[6] MU2HDLLX0
XU83 VSS a[3] VDD_1V8 n184 d_pop[37] address[5] MU2HDLLX0
XU84 VSS a[2] VDD_1V8 n184 d_pop[36] address[4] MU2HDLLX0
XU85 VSS a[1] VDD_1V8 n184 d_pop[35] address[3] MU2HDLLX0
XU86 VSS a[10] VDD_1V8 n184 d_pop[44] address[12] MU2HDLLX0
XU87 VSS a[0] VDD_1V8 n184 d_pop[34] address[2] MU2HDLLX0
XU155 VSS d[6] d_pop[6] d_write[6] d_read[6] n35 VDD_1V8 n183 n36 AO222HDLLX0
XU226 n90 VSS n92 n113 n91 VDD_1V8 d[25] ON211HDLLX0
XU230 n93 VSS n95 n113 n94 VDD_1V8 d[26] ON211HDLLX0
XU234 n96 VSS n98 n113 n97 VDD_1V8 d[27] ON211HDLLX0
XU238 n99 VSS n101 n113 n100 VDD_1V8 d[28] ON211HDLLX0
XU242 n102 VSS n104 n113 n103 VDD_1V8 d[29] ON211HDLLX0
XU246 n105 VSS n107 n113 n106 VDD_1V8 d[30] ON211HDLLX0
XU250 n111 VSS n114 n113 n112 VDD_1V8 d[31] ON211HDLLX0
XU255 VSS n137 n115 VDD_1V8 N439 NA2HDLLX0
XU262 VSS N440 VDD_1V8 n119 n137 n245 ON21HDLLX0
XU267 VSS n152 n177 N441 VDD_1V8 n121 NA3I1HDLLX0
XU268 VSS N442 VDD_1V8 n122 n125 n166 ON21HDLLX0
XU272 VSS N443 n167 n123 VDD_1V8 NO2HDLLX0
XU274 VSS n147 n177 VDD_1V8 N444 NA2HDLLX0
XU276 n146 VSS VDD_1V8 n161 n152 N445 AO21HDLLX0
XU279 N448 VSS n131 n129 VDD_1V8 n130 NA3HDLLX0
XU285 VSS VDD_1V8 n172 n161 n135 N447 n136 NA4I3HDLLX0
XU286 VSS n164 n138 VDD_1V8 N438 state[4] NA3I2HDLLX0
XU287 n166 VSS state[4] n138 n137 VDD_1V8 N451 ON211HDLLX0
XU292 VSS nxt_state[3] VDD_1V8 n142 n143 n173 ON21HDLLX0
XU296 n148 n147 VSS VDD_1V8 n149 nxt_state[2] n150 NA4HDLLX0
XU301 nxt_state[1] VSS VDD_1V8 n157 n159 n159 n158 n160 AN32HDLLX0
XU308 n177 n176 VSS VDD_1V8 n178 nxt_state[0] n179 NA4HDLLX0
XU134 VSS nxt_state[4] VDD_1V8 n30 n144 n165 ON21HDLLX0
XU136 d_psh[62] VSS VDD_1V8 d_psh[63] INHDLLX0
XU137 VSS VDD_1V8 N452 n128 n133 NO2I1HDLLX0
XU138 VSS n33 n184 VDD_1V8 d_psh[57] NA2HDLLX0
XU139 VSS n31 n184 VDD_1V8 d_psh[58] NA2HDLLX0
XU140 VSS r_w n184 VDD_1V8 d_psh[59] NA2HDLLX0
XU149 VSS d[0] n35 d_read[0] d_pop[0] n36 VDD_1V8 d_write[0] n183 AO222HDLLX0
XU150 VSS d[1] d_pop[1] d_write[1] d_read[1] n35 VDD_1V8 n183 n36 AO222HDLLX0
XU151 VSS d[2] d_pop[2] d_write[2] d_read[2] n35 VDD_1V8 n183 n36 AO222HDLLX0
XU152 VSS d[3] d_pop[3] d_write[3] d_read[3] n35 VDD_1V8 n183 n36 AO222HDLLX0
XU153 VSS d[4] d_pop[4] d_write[4] d_read[4] n35 VDD_1V8 n183 n36 AO222HDLLX0
XU154 VSS d[5] d_pop[5] d_write[5] d_read[5] n35 VDD_1V8 n183 n36 AO222HDLLX0
Xd_read_reg_26_ d_read[26] VSS IN1 VDD_1V8 d_read_pre[26] ld_d_read DLHRQHDLLX0
Xd_read_reg_25_ d_read[25] VSS IN1 VDD_1V8 d_read_pre[25] ld_d_read DLHRQHDLLX0
Xd_read_reg_24_ d_read[24] VSS IN1 VDD_1V8 d_read_pre[24] ld_d_read DLHRQHDLLX0
Xd_read_reg_23_ d_read[23] VSS IN1 VDD_1V8 d_read_pre[23] ld_d_read DLHRQHDLLX0
Xd_read_reg_22_ d_read[22] VSS IN1 VDD_1V8 d_read_pre[22] ld_d_read DLHRQHDLLX0
Xd_read_reg_21_ d_read[21] VSS IN1 VDD_1V8 d_read_pre[21] ld_d_read DLHRQHDLLX0
Xd_read_reg_20_ d_read[20] VSS IN1 VDD_1V8 d_read_pre[20] ld_d_read DLHRQHDLLX0
Xd_read_reg_19_ d_read[19] VSS reset VDD_1V8 d_read_pre[19] ld_d_read DLHRQHDLLX0
Xd_read_reg_18_ d_read[18] VSS reset VDD_1V8 d_read_pre[18] ld_d_read DLHRQHDLLX0
Xd_read_reg_17_ d_read[17] VSS reset VDD_1V8 d_read_pre[17] ld_d_read DLHRQHDLLX0
Xd_read_reg_16_ d_read[16] VSS reset VDD_1V8 d_read_pre[16] ld_d_read DLHRQHDLLX0
Xd_read_reg_15_ d_read[15] VSS IN1 VDD_1V8 d_read_pre[15] ld_d_read DLHRQHDLLX0
Xd_read_reg_14_ d_read[14] VSS IN1 VDD_1V8 d_read_pre[14] ld_d_read DLHRQHDLLX0
Xd_read_reg_13_ d_read[13] VSS IN1 VDD_1V8 d_read_pre[13] ld_d_read DLHRQHDLLX0
Xd_read_reg_12_ d_read[12] VSS IN1 VDD_1V8 d_read_pre[12] ld_d_read DLHRQHDLLX0
Xd_read_reg_11_ d_read[11] VSS IN1 VDD_1V8 d_read_pre[11] ld_d_read DLHRQHDLLX0
Xd_read_reg_10_ d_read[10] VSS IN1 VDD_1V8 d_read_pre[10] ld_d_read DLHRQHDLLX0
Xd_read_reg_9_ d_read[9] VSS IN1 VDD_1V8 d_read_pre[9] ld_d_read DLHRQHDLLX0
Xd_read_reg_8_ d_read[8] VSS IN1 VDD_1V8 d_read_pre[8] ld_d_read DLHRQHDLLX0
Xd_read_reg_7_ d_read[7] VSS IN3 VDD_1V8 d_read_pre[7] ld_d_read DLHRQHDLLX0
Xd_read_reg_6_ d_read[6] VSS reset VDD_1V8 d_read_pre[6] ld_d_read DLHRQHDLLX0
Xd_read_reg_5_ d_read[5] VSS IN1 VDD_1V8 d_read_pre[5] ld_d_read DLHRQHDLLX0
Xd_read_reg_4_ d_read[4] VSS IN1 VDD_1V8 d_read_pre[4] ld_d_read DLHRQHDLLX0
Xd_read_reg_3_ d_read[3] VSS IN1 VDD_1V8 d_read_pre[3] ld_d_read DLHRQHDLLX0
Xd_read_reg_2_ d_read[2] VSS reset VDD_1V8 d_read_pre[2] ld_d_read DLHRQHDLLX0
Xd_read_reg_1_ d_read[1] VSS reset VDD_1V8 d_read_pre[1] ld_d_read DLHRQHDLLX0
Xd_read_reg_0_ d_read[0] VSS reset VDD_1V8 d_read_pre[0] ld_d_read DLHRQHDLLX0
Xstate_reg_3_ IN0 clk nxt_state[3] state[3] VSS VDD_1V8 DFRRQHDLLX0
Xstate_reg_1_ IN0 clk nxt_state[1] state[1] VSS VDD_1V8 DFRRQHDLLX0
Xstate_reg_4_ IN0 clk nxt_state[4] state[4] VSS VDD_1V8 DFRRQHDLLX0
Xstate_reg_2_ IN0 clk nxt_state[2] n254 n245 VSS VDD_1V8 DFRRHDLLX0
Xstate_reg_0_ IN0 clk nxt_state[0] n253 n244 VSS VDD_1V8 DFRRHDLLX0
XU314 VSS clk_mem clk_cts_4 cen VDD_1V8 NO2HDLLX1
Xd_read_reg_31_ d_read[31] VSS IN2 VDD_1V8 d_read_pre[31] ld_d_read DLHRQHDLLX0
Xd_read_reg_30_ d_read[30] VSS IN1 VDD_1V8 d_read_pre[30] ld_d_read DLHRQHDLLX0
Xd_read_reg_29_ d_read[29] VSS IN1 VDD_1V8 d_read_pre[29] ld_d_read DLHRQHDLLX0
Xd_read_reg_28_ d_read[28] VSS IN1 VDD_1V8 d_read_pre[28] ld_d_read DLHRQHDLLX0
Xd_read_reg_27_ d_read[27] VSS IN1 VDD_1V8 d_read_pre[27] ld_d_read DLHRQHDLLX0
XU29 VSS VDD_1V8 d_psh[7] d_write[7] BUHDLLX1
XU31 VSS VDD_1V8 d_psh[5] d_write[5] BUHDLLX1
XU30 VSS VDD_1V8 d_psh[6] d_write[6] BUHDLLX1
XU36 VSS VDD_1V8 d_psh[0] d_write[0] BUHDLLX1
XU16 VSS VDD_1V8 d_psh[20] d_write[20] BUHDLLX1
XU6 VSS VDD_1V8 d_psh[30] d_write[30] BUHDLLX1
XU18 VSS VDD_1V8 d_psh[18] d_write[18] BUHDLLX1
XU22 VSS VDD_1V8 d_psh[14] d_write[14] BUHDLLX1
XU17 VSS VDD_1V8 d_psh[19] d_write[19] BUHDLLX1
XU20 VSS VDD_1V8 d_psh[16] d_write[16] BUHDLLX1
XU27 VSS VDD_1V8 d_psh[9] d_write[9] BUHDLLX1
XU24 VSS VDD_1V8 d_psh[12] d_write[12] BUHDLLX1
XU5 VSS VDD_1V8 d_psh[31] d_write[31] BUHDLLX1
XU21 VSS VDD_1V8 d_psh[15] d_write[15] BUHDLLX1
XU25 VSS VDD_1V8 d_psh[11] d_write[11] BUHDLLX1
XU26 VSS VDD_1V8 d_psh[10] d_write[10] BUHDLLX1
XU23 VSS VDD_1V8 d_psh[13] d_write[13] BUHDLLX1
XU15 VSS VDD_1V8 d_psh[21] d_write[21] BUHDLLX1
XU8 VSS VDD_1V8 d_psh[28] d_write[28] BUHDLLX1
XU14 VSS VDD_1V8 d_psh[22] d_write[22] BUHDLLX1
XU19 VSS VDD_1V8 d_psh[17] d_write[17] BUHDLLX1
XU28 VSS VDD_1V8 d_psh[8] d_write[8] BUHDLLX1
XU32 VSS VDD_1V8 d_psh[4] d_write[4] BUHDLLX1
XU34 VSS VDD_1V8 d_psh[2] d_write[2] BUHDLLX1
XU33 VSS VDD_1V8 d_psh[3] d_write[3] BUHDLLX1
XU12 VSS VDD_1V8 d_psh[24] d_write[24] BUHDLLX1
XU9 VSS VDD_1V8 d_psh[27] d_write[27] BUHDLLX1
XU35 VSS VDD_1V8 d_psh[1] d_write[1] BUHDLLX1
XU7 VSS VDD_1V8 d_psh[29] d_write[29] BUHDLLX1
XU11 VSS VDD_1V8 d_psh[25] d_write[25] BUHDLLX1
XU13 VSS VDD_1V8 d_psh[23] d_write[23] BUHDLLX1
XU10 VSS VDD_1V8 d_psh[26] d_write[26] BUHDLLX1
Xwen_reg wen VSS VDD_1V8 N439 N438 DLHQHDLLX1
.ENDS

.SUBCKT CSK_sin_mux A[31] A[30] A[29] A[28] A[27] A[26] A[25] A[24] A[23] A[22] A[21]
+ A[20] A[19] A[18] A[17] A[16] A[15] A[14] A[13] A[12] A[11] A[10] A[9] A[8] A[7]
+ A[6] A[5] A[4] A[3] A[2] A[1] A[0] B[31] B[30] B[29] B[28] B[27] B[26] B[25] B[24]
+ B[23] B[22] B[21] B[20] B[19] B[18] B[17] B[16] B[15] B[14] B[13] B[12] B[11]
+ B[10] B[9] B[8] B[7] B[6] B[5] B[4] B[3] B[2] B[1] B[0] Cin Cout S[31] S[30] S[29]
+ S[28] S[27] S[26] S[25] S[24] S[23] S[22] S[21] S[20] S[19] S[18] S[17] S[16]
+ S[15] S[14] S[13] S[12] S[11] S[10] S[9] S[8] S[7] S[6] S[5] S[4] S[3] S[2] S[1]
+ S[0] VSS VDD_1V8
Xgenblk1_7__csk_bloque_inst A[31] A[30] A[29] A[28] B[31] B[30] B[29] B[28] cout[6]
+ S[31] S[30] S[29] S[28] SYNOPSYS_UNCONNECTED_62 VSS VDD_1V8 csk_bloque_0
Xgenblk1_6__csk_bloque_inst A[27] A[26] A[25] A[24] B[27] B[26] B[25] B[24] cout[5]
+ S[27] S[26] S[25] S[24] cout[6] VSS VDD_1V8 csk_bloque_1
Xgenblk1_5__csk_bloque_inst A[23] A[22] A[21] A[20] B[23] B[22] B[21] B[20] cout[4]
+ S[23] S[22] S[21] S[20] cout[5] VSS VDD_1V8 csk_bloque_2
Xgenblk1_4__csk_bloque_inst A[19] A[18] A[17] A[16] B[19] B[18] B[17] B[16] cout[3]
+ S[19] S[18] S[17] S[16] cout[4] VSS VDD_1V8 csk_bloque_3
Xgenblk1_3__csk_bloque_inst A[15] A[14] A[13] A[12] B[15] B[14] B[13] B[12] cout[2]
+ S[15] S[14] S[13] S[12] cout[3] VSS VDD_1V8 csk_bloque_4
Xgenblk1_2__csk_bloque_inst A[11] A[10] A[9] A[8] B[11] B[10] B[9] B[8] cout[1]
+ S[11] S[10] S[9] S[8] cout[2] VSS VDD_1V8 csk_bloque_5
Xgenblk1_1__csk_bloque_inst A[7] A[6] A[5] A[4] B[7] B[6] B[5] B[4] cout[0] S[7]
+ S[6] S[5] S[4] cout[1] VSS VDD_1V8 csk_bloque_6
Xgenblk1_0__csk_bloque_inst A[3] A[2] A[1] A[0] B[3] B[2] B[1] B[0] VSS S[3] S[2]
+ S[1] S[0] cout[0] VSS VDD_1V8 csk_bloque_7
.ENDS

.SUBCKT Barrel_Shifter A[31] A[30] A[29] A[28] A[27] A[26] A[25] A[24] A[23] A[22]
+ A[21] A[20] A[19] A[18] A[17] A[16] A[15] A[14] A[13] A[12] A[11] A[10] A[9] A[8]
+ A[7] A[6] A[5] A[4] A[3] A[2] A[1] A[0] B[31] B[30] B[29] B[28] B[27] B[26] B[25]
+ B[24] B[23] B[22] B[21] B[20] B[19] B[18] B[17] B[16] B[15] B[14] B[13] B[12]
+ B[11] B[10] B[9] B[8] B[7] B[6] B[5] B[4] B[3] B[2] B[1] B[0] Alu_cntrl[1] Alu_cntrl[0]
+ Y[31] Y[30] Y[29] Y[28] Y[27] Y[26] Y[25] Y[24] Y[23] Y[22] Y[21] Y[20] Y[19]
+ Y[18] Y[17] Y[16] Y[15] Y[14] Y[13] Y[12] Y[11] Y[10] Y[9] Y[8] Y[7] Y[6] Y[5]
+ Y[4] Y[3] Y[2] Y[1] Y[0] VSS VDD_1V8 IN0 IN1 IN2 IN3
Xgenblk4_28__inst_buffer_s x_0__27_ x_0__26_ x_0__25_ x_0__24_ x_0__23_ x_0__22_
+ x_0__21_ x_0__20_ x_0__19_ x_0__18_ x_0__17_ x_0__16_ x_0__15_ x_0__14_ x_0__13_
+ x_0__12_ x_0__11_ x_0__10_ x_0__9_ x_0__8_ x_0__7_ x_0__6_ x_0__5_ x_0__4_ x_0__3_
+ x_0__2_ x_0__1_ x_0__0_ x_0__31_ x_0__30_ x_0__29_ x_0__28_ N318 out_x_0__31_
+ out_x_0__30_ out_x_0__29_ out_x_0__28_ out_x_0__27_ out_x_0__26_ out_x_0__25_
+ out_x_0__24_ out_x_0__23_ out_x_0__22_ out_x_0__21_ out_x_0__20_ out_x_0__19_
+ out_x_0__18_ out_x_0__17_ out_x_0__16_ out_x_0__15_ out_x_0__14_ out_x_0__13_
+ out_x_0__12_ out_x_0__11_ out_x_0__10_ out_x_0__9_ out_x_0__8_ out_x_0__7_ out_x_0__6_
+ out_x_0__5_ out_x_0__4_ out_x_0__3_ out_x_0__2_ out_x_0__1_ out_x_0__0_ VSS VDD_1V8 tristate_buffer_0
Xgenblk4_24__inst_buffer_s x_0__23_ x_0__22_ x_0__21_ x_0__20_ x_0__19_ x_0__18_
+ x_0__17_ x_0__16_ x_0__15_ x_0__14_ x_0__13_ x_0__12_ x_0__11_ x_0__10_ x_0__9_
+ x_0__8_ x_0__7_ x_0__6_ x_0__5_ x_0__4_ x_0__3_ x_0__2_ x_0__1_ x_0__0_ x_0__31_
+ x_0__30_ x_0__29_ x_0__28_ x_0__27_ x_0__26_ x_0__25_ x_0__24_ n135 out_x_0__31_
+ out_x_0__30_ out_x_0__29_ out_x_0__28_ out_x_0__27_ out_x_0__26_ out_x_0__25_
+ out_x_0__24_ out_x_0__23_ out_x_0__22_ out_x_0__21_ out_x_0__20_ out_x_0__19_
+ out_x_0__18_ out_x_0__17_ out_x_0__16_ out_x_0__15_ out_x_0__14_ out_x_0__13_
+ out_x_0__12_ out_x_0__11_ out_x_0__10_ out_x_0__9_ out_x_0__8_ out_x_0__7_ out_x_0__6_
+ out_x_0__5_ out_x_0__4_ out_x_0__3_ out_x_0__2_ out_x_0__1_ out_x_0__0_ VSS VDD_1V8 tristate_buffer_1
Xgenblk4_20__inst_buffer_s x_0__19_ x_0__18_ x_0__17_ x_0__16_ x_0__15_ x_0__14_
+ x_0__13_ x_0__12_ x_0__11_ x_0__10_ x_0__9_ x_0__8_ x_0__7_ x_0__6_ x_0__5_ x_0__4_
+ x_0__3_ x_0__2_ x_0__1_ x_0__0_ x_0__31_ x_0__30_ x_0__29_ x_0__28_ x_0__27_ x_0__26_
+ x_0__25_ x_0__24_ x_0__23_ x_0__22_ x_0__21_ x_0__20_ n136 out_x_0__31_ out_x_0__30_
+ out_x_0__29_ out_x_0__28_ out_x_0__27_ out_x_0__26_ out_x_0__25_ out_x_0__24_
+ out_x_0__23_ out_x_0__22_ out_x_0__21_ out_x_0__20_ out_x_0__19_ out_x_0__18_
+ out_x_0__17_ out_x_0__16_ out_x_0__15_ out_x_0__14_ out_x_0__13_ out_x_0__12_
+ out_x_0__11_ out_x_0__10_ out_x_0__9_ out_x_0__8_ out_x_0__7_ out_x_0__6_ out_x_0__5_
+ out_x_0__4_ out_x_0__3_ out_x_0__2_ out_x_0__1_ out_x_0__0_ VSS VDD_1V8 tristate_buffer_2
Xgenblk4_16__inst_buffer_s x_0__15_ x_0__14_ x_0__13_ x_0__12_ x_0__11_ x_0__10_
+ x_0__9_ x_0__8_ x_0__7_ x_0__6_ x_0__5_ x_0__4_ x_0__3_ x_0__2_ x_0__1_ x_0__0_
+ x_0__31_ x_0__30_ x_0__29_ x_0__28_ x_0__27_ x_0__26_ x_0__25_ x_0__24_ x_0__23_
+ x_0__22_ x_0__21_ x_0__20_ x_0__19_ x_0__18_ x_0__17_ x_0__16_ n137 out_x_0__31_
+ out_x_0__30_ out_x_0__29_ out_x_0__28_ out_x_0__27_ out_x_0__26_ out_x_0__25_
+ out_x_0__24_ out_x_0__23_ out_x_0__22_ out_x_0__21_ out_x_0__20_ out_x_0__19_
+ out_x_0__18_ out_x_0__17_ out_x_0__16_ out_x_0__15_ out_x_0__14_ out_x_0__13_
+ out_x_0__12_ out_x_0__11_ out_x_0__10_ out_x_0__9_ out_x_0__8_ out_x_0__7_ out_x_0__6_
+ out_x_0__5_ out_x_0__4_ out_x_0__3_ out_x_0__2_ out_x_0__1_ out_x_0__0_ VSS VDD_1V8 tristate_buffer_3
Xgenblk4_12__inst_buffer_s x_0__11_ x_0__10_ x_0__9_ x_0__8_ x_0__7_ x_0__6_ x_0__5_
+ x_0__4_ x_0__3_ x_0__2_ x_0__1_ x_0__0_ x_0__31_ x_0__30_ x_0__29_ x_0__28_ x_0__27_
+ x_0__26_ x_0__25_ x_0__24_ x_0__23_ x_0__22_ x_0__21_ x_0__20_ x_0__19_ x_0__18_
+ x_0__17_ x_0__16_ x_0__15_ x_0__14_ x_0__13_ x_0__12_ n138 out_x_0__31_ out_x_0__30_
+ out_x_0__29_ out_x_0__28_ out_x_0__27_ out_x_0__26_ out_x_0__25_ out_x_0__24_
+ out_x_0__23_ out_x_0__22_ out_x_0__21_ out_x_0__20_ out_x_0__19_ out_x_0__18_
+ out_x_0__17_ out_x_0__16_ out_x_0__15_ out_x_0__14_ out_x_0__13_ out_x_0__12_
+ out_x_0__11_ out_x_0__10_ out_x_0__9_ out_x_0__8_ out_x_0__7_ out_x_0__6_ out_x_0__5_
+ out_x_0__4_ out_x_0__3_ out_x_0__2_ out_x_0__1_ out_x_0__0_ VSS VDD_1V8 tristate_buffer_4
Xgenblk4_8__inst_buffer_s x_0__7_ x_0__6_ x_0__5_ x_0__4_ x_0__3_ x_0__2_ x_0__1_
+ x_0__0_ x_0__31_ x_0__30_ x_0__29_ x_0__28_ x_0__27_ x_0__26_ x_0__25_ x_0__24_
+ x_0__23_ x_0__22_ x_0__21_ x_0__20_ x_0__19_ x_0__18_ x_0__17_ x_0__16_ x_0__15_
+ x_0__14_ x_0__13_ x_0__12_ x_0__11_ x_0__10_ x_0__9_ x_0__8_ n139 out_x_0__31_
+ out_x_0__30_ out_x_0__29_ out_x_0__28_ out_x_0__27_ out_x_0__26_ out_x_0__25_
+ out_x_0__24_ out_x_0__23_ out_x_0__22_ out_x_0__21_ out_x_0__20_ out_x_0__19_
+ out_x_0__18_ out_x_0__17_ out_x_0__16_ out_x_0__15_ out_x_0__14_ out_x_0__13_
+ out_x_0__12_ out_x_0__11_ out_x_0__10_ out_x_0__9_ out_x_0__8_ out_x_0__7_ out_x_0__6_
+ out_x_0__5_ out_x_0__4_ out_x_0__3_ out_x_0__2_ out_x_0__1_ out_x_0__0_ VSS VDD_1V8 tristate_buffer_5
Xgenblk4_4__inst_buffer_s x_0__3_ x_0__2_ x_0__1_ x_0__0_ x_0__31_ x_0__30_ x_0__29_
+ x_0__28_ x_0__27_ x_0__26_ x_0__25_ x_0__24_ x_0__23_ x_0__22_ x_0__21_ x_0__20_
+ x_0__19_ x_0__18_ x_0__17_ x_0__16_ x_0__15_ x_0__14_ x_0__13_ x_0__12_ x_0__11_
+ x_0__10_ x_0__9_ x_0__8_ x_0__7_ x_0__6_ x_0__5_ x_0__4_ n130 out_x_0__31_ out_x_0__30_
+ out_x_0__29_ out_x_0__28_ out_x_0__27_ out_x_0__26_ out_x_0__25_ out_x_0__24_
+ out_x_0__23_ out_x_0__22_ out_x_0__21_ out_x_0__20_ out_x_0__19_ out_x_0__18_
+ out_x_0__17_ out_x_0__16_ out_x_0__15_ out_x_0__14_ out_x_0__13_ out_x_0__12_
+ out_x_0__11_ out_x_0__10_ out_x_0__9_ out_x_0__8_ out_x_0__7_ out_x_0__6_ out_x_0__5_
+ out_x_0__4_ out_x_0__3_ out_x_0__2_ out_x_0__1_ out_x_0__0_ VSS VDD_1V8 tristate_buffer_6
Xgenblk4_0__inst_buffer_s x_0__31_ x_0__30_ x_0__29_ x_0__28_ x_0__27_ x_0__26_
+ x_0__25_ x_0__24_ x_0__23_ x_0__22_ x_0__21_ x_0__20_ x_0__19_ x_0__18_ x_0__17_
+ x_0__16_ x_0__15_ x_0__14_ x_0__13_ x_0__12_ x_0__11_ x_0__10_ x_0__9_ x_0__8_
+ x_0__7_ x_0__6_ x_0__5_ x_0__4_ x_0__3_ x_0__2_ x_0__1_ x_0__0_ n129 out_x_0__31_
+ out_x_0__30_ out_x_0__29_ out_x_0__28_ out_x_0__27_ out_x_0__26_ out_x_0__25_
+ out_x_0__24_ out_x_0__23_ out_x_0__22_ out_x_0__21_ out_x_0__20_ out_x_0__19_
+ out_x_0__18_ out_x_0__17_ out_x_0__16_ out_x_0__15_ out_x_0__14_ out_x_0__13_
+ out_x_0__12_ out_x_0__11_ out_x_0__10_ out_x_0__9_ out_x_0__8_ out_x_0__7_ out_x_0__6_
+ out_x_0__5_ out_x_0__4_ out_x_0__3_ out_x_0__2_ out_x_0__1_ out_x_0__0_ VSS VDD_1V8 tristate_buffer_7
Xgenblk3_3__inst_buffer A[2] A[1] A[0] A[31] A[30] A[29] A[28] A[27] A[26] A[25]
+ A[24] A[23] A[22] A[21] A[20] A[19] A[18] A[17] A[16] A[15] A[14] A[13] A[12]
+ A[11] A[10] A[9] A[8] A[7] A[6] A[5] A[4] A[3] N292 x_0__31_ x_0__30_ x_0__29_
+ x_0__28_ x_0__27_ x_0__26_ x_0__25_ x_0__24_ x_0__23_ x_0__22_ x_0__21_ x_0__20_
+ x_0__19_ x_0__18_ x_0__17_ x_0__16_ x_0__15_ x_0__14_ x_0__13_ x_0__12_ x_0__11_
+ x_0__10_ x_0__9_ x_0__8_ x_0__7_ x_0__6_ x_0__5_ x_0__4_ x_0__3_ x_0__2_ x_0__1_
+ x_0__0_ VSS VDD_1V8 tristate_buffer_8
Xgenblk3_2__inst_buffer A[1] A[0] A[31] A[30] A[29] A[28] A[27] A[26] A[25] A[24]
+ A[23] A[22] A[21] A[20] A[19] A[18] A[17] A[16] A[15] A[14] A[13] A[12] A[11]
+ A[10] A[9] A[8] A[7] A[6] A[5] A[4] A[3] A[2] n142 x_0__31_ x_0__30_ x_0__29_
+ x_0__28_ x_0__27_ x_0__26_ x_0__25_ x_0__24_ x_0__23_ x_0__22_ x_0__21_ x_0__20_
+ x_0__19_ x_0__18_ x_0__17_ x_0__16_ x_0__15_ x_0__14_ x_0__13_ x_0__12_ x_0__11_
+ x_0__10_ x_0__9_ x_0__8_ x_0__7_ x_0__6_ x_0__5_ x_0__4_ x_0__3_ x_0__2_ x_0__1_
+ x_0__0_ VSS VDD_1V8 tristate_buffer_9
Xgenblk3_1__inst_buffer A[0] A[31] A[30] A[29] A[28] A[27] A[26] A[25] A[24] A[23]
+ A[22] A[21] A[20] A[19] A[18] A[17] A[16] A[15] A[14] A[13] A[12] A[11] A[10]
+ A[9] A[8] A[7] A[6] A[5] A[4] A[3] A[2] A[1] n143 x_0__31_ x_0__30_ x_0__29_ x_0__28_
+ x_0__27_ x_0__26_ x_0__25_ x_0__24_ x_0__23_ x_0__22_ x_0__21_ x_0__20_ x_0__19_
+ x_0__18_ x_0__17_ x_0__16_ x_0__15_ x_0__14_ x_0__13_ x_0__12_ x_0__11_ x_0__10_
+ x_0__9_ x_0__8_ x_0__7_ x_0__6_ x_0__5_ x_0__4_ x_0__3_ x_0__2_ x_0__1_ x_0__0_
+ VSS VDD_1V8 tristate_buffer_10
Xgenblk3_0__inst_buffer A[31] A[30] A[29] A[28] A[27] A[26] A[25] A[24] A[23] A[22]
+ A[21] A[20] A[19] A[18] A[17] A[16] A[15] A[14] A[13] A[12] A[11] A[10] A[9] A[8]
+ A[7] A[6] A[5] A[4] A[3] A[2] A[1] A[0] n144 x_0__31_ x_0__30_ x_0__29_ x_0__28_
+ x_0__27_ x_0__26_ x_0__25_ x_0__24_ x_0__23_ x_0__22_ x_0__21_ x_0__20_ x_0__19_
+ x_0__18_ x_0__17_ x_0__16_ x_0__15_ x_0__14_ x_0__13_ x_0__12_ x_0__11_ x_0__10_
+ x_0__9_ x_0__8_ x_0__7_ x_0__6_ x_0__5_ x_0__4_ x_0__3_ x_0__2_ x_0__1_ x_0__0_
+ VSS VDD_1V8 tristate_buffer_11
Xbandera_reg bandera VSS VDD_1V8 N12 N11 DLHQHDLLX0
Xaritmetic_reg aritmetic VSS VDD_1V8 N13 N11 DLHQHDLLX0
XU8 VSS n50 B[0] IN1 VDD_1V8 NO2HDLLX0
XU15 n78 VSS VDD_1V8 n50 INHDLLX0
XU16 VSS n53 n78 IN0 VDD_1V8 NO2HDLLX0
XU17 n81 VSS VDD_1V8 n53 INHDLLX0
XU3 VSS N12 Alu_cntrl[0] Alu_cntrl[1] VDD_1V8 NO2HDLLX0
XU25 VSS n78 IN0 VDD_1V8 n63 NA2HDLLX0
XU18 VSS n1 IN2 n81 VDD_1V8 NO2HDLLX0
XU4 VSS Alu_cntrl[0] Alu_cntrl[1] VDD_1V8 N11 NA2HDLLX0
XU5 n2 VSS VDD_1V8 N12 INHDLLX0
XU9 VSS B[0] IN1 VDD_1V8 n89 NA2HDLLX0
XU26 n93 VSS VDD_1V8 n63 INHDLLX0
XU22 VSS n1 B[4] VDD_1V8 n111 NA2HDLLX0
XU6 VSS n2 N11 VDD_1V8 n3 NA2HDLLX0
Xplace3 n7 VSS VDD_1V8 bandera INHDLLX0
XU7 n4 VSS VDD_1V8 n3 INHDLLX0
XU10 n105 VSS VDD_1V8 n89 INHDLLX0
XU76 VSS n46 n7 IN3 VDD_1V8 NO2HDLLX0
XU19 n81 VSS n1 IN2 VDD_1V8 n67 AN21HDLLX0
XU23 VSS n5 VDD_1V8 n111 B[4] n1 ON21HDLLX0
XU27 VSS n77 n53 n93 VDD_1V8 NO2HDLLX0
XU38 VSS n80 bandera n5 VDD_1V8 NO2HDLLX0
XU77 n48 VSS VDD_1V8 n46 INHDLLX0
XU28 VSS VDD_1V8 n117 n77 n4 IN0 N12 AN22HDLLX0
XU11 VSS n83 n50 n105 VDD_1V8 NO2HDLLX0
XU20 VSS VDD_1V8 n123 n67 n4 IN2 N12 AN22HDLLX0
XU29 n121 VSS VDD_1V8 n117 INHDLLX0
XU44 VSS n75 IN2 n7 VDD_1V8 NO2HDLLX0
XU36 n14 VSS VDD_1V8 n67 INHDLLX0
XU35 n26 VSS VDD_1V8 n77 INHDLLX0
XU13 VSS B[0] N11 VDD_1V8 n115 NA2HDLLX0
XU12 VSS VDD_1V8 n116 n83 n4 IN1 N12 AN22HDLLX0
XU24 n118 VSS VDD_1V8 n5 n2 n3 B[4] ON22HDLLX0
XU105 VSS n111 n48 VDD_1V8 n74 NA2HDLLX0
XU45 VSS n75 B[4] VDD_1V8 n27 NA2HDLLX0
XU30 VSS n118 n121 VDD_1V8 n119 NA2HDLLX0
XU37 VSS n26 n14 VDD_1V8 n51 NA2HDLLX0
XU161 VSS VDD_1V8 n143 n116 n115 NO2I1HDLLX1
XU14 VSS N292 n116 n115 VDD_1V8 NO2HDLLX1
XU162 B[0] IN1 VSS VDD_1V8 n142 N11 NO3I2HDLLX1
XU78 VSS n67 n7 VDD_1V8 n43 NA2HDLLX0
XU40 VSS n111 n126 VDD_1V8 n15 NA2HDLLX0
XU169 VSS n118 n117 VDD_1V8 n130 n123 NA3I2HDLLX0
XU165 VSS n118 n131 VDD_1V8 n129 n117 NA3I2HDLLX0
XU124 VSS n80 n67 VDD_1V8 n103 NA2HDLLX0
XU133 VSS n101 n75 n74 VDD_1V8 NO2HDLLX0
XU134 n106 VSS VDD_1V8 n101 INHDLLX0
XU174 VSS n118 n117 n137 VDD_1V8 n123 AND3HDLLX1
XU109 n65 VSS VDD_1V8 n74 INHDLLX0
XU125 n108 VSS VDD_1V8 n103 INHDLLX0
XU79 VSS n41 n26 n43 VDD_1V8 NO2HDLLX0
XU80 n35 VSS n126 n27 VDD_1V8 n111 NA3HDLLX0
XU54 VSS B[0] B[1] VDD_1V8 n87 NA2HDLLX0
XU31 VSS N318 n123 n119 VDD_1V8 NO2HDLLX1
XU170 VSS n136 n131 n119 VDD_1V8 NO2HDLLX1
XU83 n37 VSS n7 n78 VDD_1V8 B[3] NA3HDLLX0
XU166 n121 n139 VSS VDD_1V8 n118 n123 NO3HDLLX2
XU65 n23 n81 IN3 VSS VDD_1V8 IN2 bandera AN31HDLLX0
XU32 VSS A[31] aritmetic VDD_1V8 n96 NA2HDLLX0
XU41 n51 VSS n15 n7 VDD_1V8 n12 AN21HDLLX0
XU167 n118 n138 VSS VDD_1V8 n117 n123 NO3HDLLX2
XU46 n24 VSS VDD_1V8 n27 INHDLLX0
XU81 VSS n32 n41 n35 VDD_1V8 NO2HDLLX0
Xplace4 n125 VSS VDD_1V8 n96 INHDLLX0
XU138 n94 VSS B[3] n78 VDD_1V8 n80 NA3HDLLX0
XU137 n108 VSS n106 n77 VDD_1V8 n91 AN21HDLLX0
XU66 B[2] VSS n23 n24 VDD_1V8 n20 AN21HDLLX0
XU93 B[2] VSS VDD_1V8 n35 n46 n44 AO21HDLLX0
XU126 VSS VDD_1V8 n72 n75 B[2] n108 n74 AN211HDLLX0
XU42 VSS n12 bandera VDD_1V8 n6 NA2HDLLX0
XU96 VSS n38 n93 n37 VDD_1V8 NO2HDLLX0
XU48 n55 VSS VDD_1V8 n83 INHDLLX0
XU47 VSS n84 IN0 IN1 VDD_1V8 NO2HDLLX0
XU110 VSS n51 n80 VDD_1V8 n65 n60 NA22HDLLX0
XU60 VSS n62 VDD_1V8 n14 n50 IN0 ON21HDLLX0
XU70 VSS n109 IN0 n87 VDD_1V8 NO2HDLLX0
XU64 VSS n83 n63 VDD_1V8 n102 NA2HDLLX0
XU141 VSS VDD_1V8 n85 n83 n84 bandera n108 AN22HDLLX0
XU152 VSS n100 VDD_1V8 bandera B[1] B[2] ON21HDLLX0
XU155 n105 VSS n7 IN0 VDD_1V8 n107 AN21HDLLX0
XU90 VSS n33 VDD_1V8 n32 n87 n43 ON21HDLLX0
XU97 VSS VDD_1V8 n39 n46 n50 n38 n44 AN211HDLLX0
XU99 VSS n40 IN1 n48 VDD_1V8 NO2HDLLX0
XU102 n45 VSS VDD_1V8 n43 n87 IN0 NO3HDLLX0
XU84 n37 VSS n48 n81 n32 VDD_1V8 n29 ON211HDLLX0
XU43 VSS Y[0] VDD_1V8 n6 n125 out_x_0__0_ MU2HDLLX0
XU49 VSS n8 VDD_1V8 n12 n55 bandera ON21HDLLX0
XU108 VSS n52 n50 n126 VDD_1V8 NO2HDLLX0
XU55 VSS n10 VDD_1V8 n12 n87 bandera ON21HDLLX0
XU113 VSS n56 n126 n55 VDD_1V8 NO2HDLLX0
XU116 n58 n89 B[2] VSS VDD_1V8 n75 n60 AN31HDLLX0
XU61 VSS n16 n93 n27 VDD_1V8 NO2HDLLX0
XU149 n97 VSS VDD_1V8 n93 n101 n101 n94 n7 AN32HDLLX0
XU121 VSS VDD_1V8 n64 n80 n63 n75 n62 AN22HDLLX0
XU87 VSS n30 VDD_1V8 n32 n55 n43 ON21HDLLX0
XU67 VSS n18 VDD_1V8 n20 n102 bandera ON21HDLLX0
XU144 VSS n88 VDD_1V8 n91 n103 n87 ON21HDLLX0
XU127 VSS n69 VDD_1V8 n72 n102 n126 ON21HDLLX0
XU71 VSS n21 VDD_1V8 n20 n27 n105 ON21HDLLX0
XU130 VSS VDD_1V8 n71 n80 n89 n75 n109 AN22HDLLX0
XU139 n94 VSS n81 n7 n91 VDD_1V8 n82 ON211HDLLX0
XU88 n84 VSS n30 n46 VDD_1V8 n31 AN21HDLLX0
XU142 VSS n91 n85 VDD_1V8 n86 NA2HDLLX0
XU131 VSS n72 n71 VDD_1V8 n73 NA2HDLLX0
XU128 B[1] VSS n69 n75 VDD_1V8 n70 AN21HDLLX0
XU145 n90 n89 B[2] VSS VDD_1V8 bandera n88 AN31HDLLX0
XU122 VSS n65 n64 VDD_1V8 n66 NA2HDLLX0
XU119 B[2] VSS n60 n75 VDD_1V8 n61 AN21HDLLX0
XU117 VSS n59 VDD_1V8 n58 n87 n126 ON21HDLLX0
XU114 VSS VDD_1V8 n57 n84 n75 n56 n60 AN211HDLLX0
XU111 VSS VDD_1V8 n54 n53 n75 n52 n60 AN211HDLLX0
XU106 VSS n49 n80 n74 VDD_1V8 NO2HDLLX0
XU147 VSS n92 VDD_1V8 n91 n7 IN0 ON21HDLLX0
XU103 VSS VDD_1V8 n47 n46 n89 n45 n44 AN211HDLLX0
XU100 VSS VDD_1V8 n42 n83 n41 n40 n44 AN211HDLLX0
XU98 VSS Y[12] VDD_1V8 n39 out_x_0__12_ n125 MU2HDLLX0
XU94 VSS n36 n41 n44 VDD_1V8 NO2HDLLX0
XU91 n34 n89 B[2] VSS VDD_1V8 n46 n33 AN31HDLLX0
XU150 VSS out_x_0__28_ n97 VDD_1V8 n95 NA2HDLLX0
XU153 n100 VSS n103 n102 n101 VDD_1V8 n104 ON211HDLLX0
XU156 VSS VDD_1V8 n110 n109 n108 n107 n106 AN211HDLLX0
XU158 VSS n7 n111 VDD_1V8 n113 NA2HDLLX0
XU50 n84 VSS n8 n24 VDD_1V8 n9 AN21HDLLX0
XU56 n11 n89 B[2] VSS VDD_1V8 n24 n10 AN31HDLLX0
XU58 VSS n13 VDD_1V8 n12 n27 IN0 ON21HDLLX0
XU62 VSS VDD_1V8 n17 n7 n62 n16 n15 AN211HDLLX0
XU68 B[1] VSS n18 n24 VDD_1V8 n19 AN21HDLLX0
XU72 n7 VSS n21 n109 VDD_1V8 n22 AN21HDLLX0
XU135 VSS n76 n108 n106 VDD_1V8 NO2HDLLX0
XU74 VSS n25 n24 n23 VDD_1V8 NO2HDLLX0
XU85 VSS out_x_0__8_ n29 VDD_1V8 n28 NA2HDLLX0
XU75 VSS Y[7] VDD_1V8 n25 out_x_0__7_ n125 MU2HDLLX0
XU86 VSS Y[8] VDD_1V8 n28 n96 n29 ON21HDLLX0
XU89 VSS Y[9] VDD_1V8 n31 out_x_0__9_ n125 MU2HDLLX0
XU73 VSS Y[6] VDD_1V8 n22 out_x_0__6_ n125 MU2HDLLX0
XU69 VSS Y[5] VDD_1V8 n19 out_x_0__5_ n125 MU2HDLLX0
XU63 VSS Y[4] VDD_1V8 n17 out_x_0__4_ n125 MU2HDLLX0
XU59 VSS Y[3] VDD_1V8 n13 n125 out_x_0__3_ MU2HDLLX0
XU57 VSS Y[2] VDD_1V8 n11 out_x_0__2_ n125 MU2HDLLX0
XU51 VSS Y[1] VDD_1V8 n9 out_x_0__1_ n125 MU2HDLLX0
XU159 VSS Y[31] VDD_1V8 n113 n125 out_x_0__31_ MU2HDLLX0
XU157 VSS Y[30] VDD_1V8 n110 out_x_0__30_ n125 MU2HDLLX0
XU154 VSS Y[29] VDD_1V8 n104 n125 out_x_0__29_ MU2HDLLX0
XU151 VSS Y[28] VDD_1V8 n95 n96 n97 ON21HDLLX0
XU148 VSS Y[27] VDD_1V8 n92 n125 out_x_0__27_ MU2HDLLX0
XU92 VSS Y[10] VDD_1V8 n34 out_x_0__10_ n125 MU2HDLLX0
XU95 VSS Y[11] VDD_1V8 n36 out_x_0__11_ n125 MU2HDLLX0
XU101 VSS Y[13] VDD_1V8 n42 out_x_0__13_ n125 MU2HDLLX0
XU104 VSS Y[14] VDD_1V8 n47 out_x_0__14_ n125 MU2HDLLX0
XU107 VSS Y[15] VDD_1V8 n49 out_x_0__15_ n125 MU2HDLLX0
XU146 VSS Y[26] VDD_1V8 n90 out_x_0__26_ n125 MU2HDLLX0
XU112 VSS Y[16] VDD_1V8 n54 out_x_0__16_ n125 MU2HDLLX0
XU115 VSS Y[17] VDD_1V8 n57 out_x_0__17_ n125 MU2HDLLX0
XU118 VSS Y[18] VDD_1V8 n59 n125 out_x_0__18_ MU2HDLLX0
XU120 VSS Y[19] VDD_1V8 n61 out_x_0__19_ n125 MU2HDLLX0
XU123 VSS Y[20] VDD_1V8 n66 n125 out_x_0__20_ MU2HDLLX0
XU129 VSS Y[21] VDD_1V8 n70 out_x_0__21_ n125 MU2HDLLX0
XU132 VSS Y[22] VDD_1V8 n73 n125 out_x_0__22_ MU2HDLLX0
XU143 VSS Y[25] VDD_1V8 n86 n125 out_x_0__25_ MU2HDLLX0
XU136 VSS Y[23] VDD_1V8 n76 out_x_0__23_ n125 MU2HDLLX0
XU140 VSS Y[24] VDD_1V8 n82 n125 out_x_0__24_ MU2HDLLX0
XU172 VSS VDD_1V8 N13 Alu_cntrl[1] Alu_cntrl[0] NO2I1HDLLX0
Xplace5 n126 VSS VDD_1V8 n80 INHDLLX0
XU173 VSS n135 n117 n118 VDD_1V8 n131 AND3HDLLX0
XU171 n131 VSS VDD_1V8 n123 INHDLLX0
XU160 VSS n116 n115 VDD_1V8 n144 AND2HDLLX0
.ENDS

.SUBCKT Reg_32_bit_width32_number_reg32 Din[31] Din[30] Din[29] Din[28] Din[27] Din[26]
+ Din[25] Din[24] Din[23] Din[22] Din[21] Din[20] Din[19] Din[18] Din[17] Din[16]
+ Din[15] Din[14] Din[13] Din[12] Din[11] Din[10] Din[9] Din[8] Din[7] Din[6] Din[5]
+ Din[4] Din[3] Din[2] Din[1] Din[0] Dout1[31] Dout1[30] Dout1[29] Dout1[28] Dout1[27]
+ Dout1[26] Dout1[25] Dout1[24] Dout1[23] Dout1[22] Dout1[21] Dout1[20] Dout1[19]
+ Dout1[18] Dout1[17] Dout1[16] Dout1[15] Dout1[14] Dout1[13] Dout1[12] Dout1[11]
+ Dout1[10] Dout1[9] Dout1[8] Dout1[7] Dout1[6] Dout1[5] Dout1[4] Dout1[3] Dout1[2]
+ Dout1[1] Dout1[0] Dout2[31] Dout2[30] Dout2[29] Dout2[28] Dout2[27] Dout2[26]
+ Dout2[25] Dout2[24] Dout2[23] Dout2[22] Dout2[21] Dout2[20] Dout2[19] Dout2[18]
+ Dout2[17] Dout2[16] Dout2[15] Dout2[14] Dout2[13] Dout2[12] Dout2[11] Dout2[10]
+ Dout2[9] Dout2[8] Dout2[7] Dout2[6] Dout2[5] Dout2[4] Dout2[3] Dout2[2] Dout2[1]
+ Dout2[0] addres1[4] addres1[3] addres1[2] addres1[1] addres1[0] addres2[4] addres2[3]
+ addres2[2] addres2[1] addres2[0] addres3[4] addres3[3] addres3[2] addres3[1] addres3[0]
+ Write_en clk rst VSS VDD_1V8 IN0 IN1 IN2 IN3 IN4 IN5 IN6 IN7 IN8 IN9 IN10 IN11
+ IN12 IN13 IN14 IN15 IN16 IN17 IN18 IN19 IN20 IN21 IN22 IN23 IN24 IN25 IN26 IN27
+ IN28 IN29 IN30 IN31 IN32 IN33 IN34 IN35 IN36 IN37 IN38 IN39 IN40 IN41 IN42 IN43
+ IN44 IN45 IN46 IN47 IN48 IN49 IN50 IN51 IN52 IN53 IN54 IN55 IN56 IN57 IN58 IN59
+ IN60 IN61 IN62 IN63 IN64 IN65 IN66 IN67 IN68 IN69 IN70 IN71 IN72 IN73 IN74 IN75
+ IN76 IN77 IN78 IN79 IN80 IN81 IN82 IN83 IN84 IN85 IN86 IN87 IN88 IN89 IN90 IN91
+ IN92 IN93 IN94 IN95 IN96 IN97 IN98 IN99 IN100 IN101 IN102 IN103 IN104 IN105 IN106
+ IN107 IN108 IN109 IN110 IN111 IN112 IN113 IN114 IN115 IN116 IN117 IN118 IN119
+ IN120 IN121 IN122 IN123 IN124 IN125 IN126 IN127 IN128 IN129 IN130 IN131 IN132
+ IN133 IN134 IN135 IN136 IN137 IN138 IN139 IN140 IN141 IN142 IN143 IN144 IN145
+ IN146 IN147 IN148 IN149 IN150 IN151 IN152 IN153 IN154 IN155 IN156 IN157 IN158
+ IN159 IN160 IN161 IN162 IN163 IN164 IN165 IN166 IN167 IN168 IN169 IN170 IN171
+ IN172 IN173 IN174 IN175 IN176 IN177 IN178 IN179 IN180 IN181 IN182 IN183 IN184
+ IN185 IN186 IN187 IN188 IN189 IN190 IN191 IN192 IN193 IN194 IN195 IN196 IN197
+ IN198 IN199
XRegsitros_Zero_31__tristategate_zero2 VSS conect_deco_latch2[0] Dout2[31] VSS VDD_1V8 tristategate_384
XRegsitros_Zero_31__tristategate_zero1 VSS conect_deco_latch1[0] Dout1[31] VSS VDD_1V8 tristategate_385
XRegsitros_Zero_30__tristategate_zero2 VSS conect_deco_latch2[0] Dout2[30] VSS VDD_1V8 tristategate_386
XRegsitros_Zero_30__tristategate_zero1 VSS conect_deco_latch1[0] Dout1[30] VSS VDD_1V8 tristategate_387
XRegsitros_Zero_29__tristategate_zero2 VSS conect_deco_latch2[0] Dout2[29] VSS VDD_1V8 tristategate_388
XRegsitros_Zero_29__tristategate_zero1 VSS conect_deco_latch1[0] Dout1[29] VSS VDD_1V8 tristategate_389
XRegsitros_Zero_28__tristategate_zero2 VSS conect_deco_latch2[0] Dout2[28] VSS VDD_1V8 tristategate_390
XRegsitros_Zero_28__tristategate_zero1 VSS conect_deco_latch1[0] Dout1[28] VSS VDD_1V8 tristategate_391
XRegsitros_Zero_27__tristategate_zero2 VSS conect_deco_latch2[0] Dout2[27] VSS VDD_1V8 tristategate_392
XRegsitros_Zero_27__tristategate_zero1 VSS conect_deco_latch1[0] Dout1[27] VSS VDD_1V8 tristategate_393
XRegsitros_Zero_26__tristategate_zero2 VSS conect_deco_latch2[0] Dout2[26] VSS VDD_1V8 tristategate_394
XRegsitros_Zero_26__tristategate_zero1 VSS conect_deco_latch1[0] Dout1[26] VSS VDD_1V8 tristategate_395
XRegsitros_Zero_25__tristategate_zero2 VSS conect_deco_latch2[0] Dout2[25] VSS VDD_1V8 tristategate_396
XRegsitros_Zero_25__tristategate_zero1 VSS conect_deco_latch1[0] Dout1[25] VSS VDD_1V8 tristategate_397
XRegsitros_Zero_24__tristategate_zero2 VSS conect_deco_latch2[0] Dout2[24] VSS VDD_1V8 tristategate_398
XRegsitros_Zero_24__tristategate_zero1 VSS conect_deco_latch1[0] Dout1[24] VSS VDD_1V8 tristategate_399
XRegsitros_Zero_23__tristategate_zero2 VSS conect_deco_latch2[0] Dout2[23] VSS VDD_1V8 tristategate_400
XRegsitros_Zero_23__tristategate_zero1 VSS conect_deco_latch1[0] Dout1[23] VSS VDD_1V8 tristategate_401
XRegsitros_Zero_22__tristategate_zero2 VSS conect_deco_latch2[0] Dout2[22] VSS VDD_1V8 tristategate_402
XRegsitros_Zero_22__tristategate_zero1 VSS conect_deco_latch1[0] Dout1[22] VSS VDD_1V8 tristategate_403
XRegsitros_Zero_21__tristategate_zero2 VSS conect_deco_latch2[0] Dout2[21] VSS VDD_1V8 tristategate_404
XRegsitros_Zero_21__tristategate_zero1 VSS conect_deco_latch1[0] Dout1[21] VSS VDD_1V8 tristategate_405
XRegsitros_Zero_20__tristategate_zero2 VSS conect_deco_latch2[0] Dout2[20] VSS VDD_1V8 tristategate_406
XRegsitros_Zero_20__tristategate_zero1 VSS conect_deco_latch1[0] Dout1[20] VSS VDD_1V8 tristategate_407
XRegsitros_Zero_19__tristategate_zero2 VSS conect_deco_latch2[0] Dout2[19] VSS VDD_1V8 tristategate_408
XRegsitros_Zero_19__tristategate_zero1 VSS conect_deco_latch1[0] Dout1[19] VSS VDD_1V8 tristategate_409
XRegsitros_Zero_18__tristategate_zero2 VSS conect_deco_latch2[0] Dout2[18] VSS VDD_1V8 tristategate_410
XRegsitros_Zero_18__tristategate_zero1 VSS conect_deco_latch1[0] Dout1[18] VSS VDD_1V8 tristategate_411
XRegsitros_Zero_17__tristategate_zero2 VSS conect_deco_latch2[0] Dout2[17] VSS VDD_1V8 tristategate_412
XRegsitros_Zero_17__tristategate_zero1 VSS conect_deco_latch1[0] Dout1[17] VSS VDD_1V8 tristategate_413
XRegsitros_Zero_16__tristategate_zero2 VSS conect_deco_latch2[0] Dout2[16] VSS VDD_1V8 tristategate_414
XRegsitros_Zero_16__tristategate_zero1 VSS conect_deco_latch1[0] Dout1[16] VSS VDD_1V8 tristategate_415
XRegsitros_Zero_15__tristategate_zero2 VSS conect_deco_latch2[0] Dout2[15] VSS VDD_1V8 tristategate_416
XRegsitros_Zero_15__tristategate_zero1 VSS conect_deco_latch1[0] Dout1[15] VSS VDD_1V8 tristategate_417
XRegsitros_Zero_14__tristategate_zero2 VSS conect_deco_latch2[0] Dout2[14] VSS VDD_1V8 tristategate_418
XRegsitros_Zero_14__tristategate_zero1 VSS conect_deco_latch1[0] Dout1[14] VSS VDD_1V8 tristategate_419
XRegsitros_Zero_13__tristategate_zero2 VSS conect_deco_latch2[0] Dout2[13] VSS VDD_1V8 tristategate_420
XRegsitros_Zero_13__tristategate_zero1 VSS conect_deco_latch1[0] Dout1[13] VSS VDD_1V8 tristategate_421
XRegsitros_Zero_12__tristategate_zero2 VSS conect_deco_latch2[0] Dout2[12] VSS VDD_1V8 tristategate_422
XRegsitros_Zero_12__tristategate_zero1 VSS conect_deco_latch1[0] Dout1[12] VSS VDD_1V8 tristategate_423
XRegsitros_Zero_11__tristategate_zero2 VSS conect_deco_latch2[0] Dout2[11] VSS VDD_1V8 tristategate_424
XRegsitros_Zero_11__tristategate_zero1 VSS conect_deco_latch1[0] Dout1[11] VSS VDD_1V8 tristategate_425
XRegsitros_Zero_10__tristategate_zero2 VSS conect_deco_latch2[0] Dout2[10] VSS VDD_1V8 tristategate_426
XRegsitros_Zero_10__tristategate_zero1 VSS conect_deco_latch1[0] Dout1[10] VSS VDD_1V8 tristategate_427
XRegsitros_Zero_9__tristategate_zero2 VSS conect_deco_latch2[0] Dout2[9] VSS VDD_1V8 tristategate_428
XRegsitros_Zero_9__tristategate_zero1 VSS conect_deco_latch1[0] Dout1[9] VSS VDD_1V8 tristategate_429
XRegsitros_Zero_8__tristategate_zero2 VSS conect_deco_latch2[0] Dout2[8] VSS VDD_1V8 tristategate_430
XRegsitros_Zero_8__tristategate_zero1 VSS conect_deco_latch1[0] Dout1[8] VSS VDD_1V8 tristategate_431
XRegsitros_Zero_7__tristategate_zero2 VSS conect_deco_latch2[0] Dout2[7] VSS VDD_1V8 tristategate_432
XRegsitros_Zero_7__tristategate_zero1 VSS conect_deco_latch1[0] Dout1[7] VSS VDD_1V8 tristategate_433
XRegsitros_Zero_6__tristategate_zero2 VSS conect_deco_latch2[0] Dout2[6] VSS VDD_1V8 tristategate_434
XRegsitros_Zero_6__tristategate_zero1 VSS conect_deco_latch1[0] Dout1[6] VSS VDD_1V8 tristategate_435
XRegsitros_Zero_5__tristategate_zero2 VSS conect_deco_latch2[0] Dout2[5] VSS VDD_1V8 tristategate_436
XRegsitros_Zero_5__tristategate_zero1 VSS conect_deco_latch1[0] Dout1[5] VSS VDD_1V8 tristategate_437
XRegsitros_Zero_4__tristategate_zero2 VSS conect_deco_latch2[0] Dout2[4] VSS VDD_1V8 tristategate_438
XRegsitros_Zero_4__tristategate_zero1 VSS conect_deco_latch1[0] Dout1[4] VSS VDD_1V8 tristategate_439
XRegsitros_Zero_3__tristategate_zero2 VSS conect_deco_latch2[0] Dout2[3] VSS VDD_1V8 tristategate_440
XRegsitros_Zero_3__tristategate_zero1 VSS conect_deco_latch1[0] Dout1[3] VSS VDD_1V8 tristategate_441
XRegsitros_Zero_2__tristategate_zero2 VSS conect_deco_latch2[0] Dout2[2] VSS VDD_1V8 tristategate_442
XRegsitros_Zero_2__tristategate_zero1 VSS conect_deco_latch1[0] Dout1[2] VSS VDD_1V8 tristategate_443
XRegsitros_Zero_1__tristategate_zero2 VSS conect_deco_latch2[0] Dout2[1] VSS VDD_1V8 tristategate_444
XRegsitros_Zero_1__tristategate_zero1 VSS conect_deco_latch1[0] Dout1[1] VSS VDD_1V8 tristategate_445
XRegsitros_Zero_0__tristategate_zero2 VSS conect_deco_latch2[0] Dout2[0] VSS VDD_1V8 tristategate_446
XRegsitros_Zero_0__tristategate_zero1 VSS conect_deco_latch1[0] Dout1[0] VSS VDD_1V8 tristategate_447
Xlatches1_31__latches2_31__latchesa Din[31] Dout1[31] Dout2[31] n253 n252 Sal_and_write[31]
+ n128 VSS VDD_1V8 latchtriestado_0
Xlatches1_31__latches2_30__latchesa Din[30] Dout1[30] Dout2[30] n253 n252 Sal_and_write[31]
+ n29 VSS VDD_1V8 latchtriestado_1
Xlatches1_31__latches2_29__latchesa Din[29] Dout1[29] Dout2[29] n253 n252 Sal_and_write[31]
+ n128 VSS VDD_1V8 latchtriestado_2
Xlatches1_31__latches2_28__latchesa Din[28] Dout1[28] Dout2[28] n253 n252 Sal_and_write[31]
+ IN121 VSS VDD_1V8 latchtriestado_3
Xlatches1_31__latches2_27__latchesa Din[27] Dout1[27] Dout2[27] n253 n252 Sal_and_write[31]
+ n96 VSS VDD_1V8 latchtriestado_4
Xlatches1_31__latches2_26__latchesa Din[26] Dout1[26] Dout2[26] n253 n252 Sal_and_write[31]
+ n93 VSS VDD_1V8 latchtriestado_5
Xlatches1_31__latches2_25__latchesa Din[25] Dout1[25] Dout2[25] n253 n252 Sal_and_write[31]
+ IN87 VSS VDD_1V8 latchtriestado_6
Xlatches1_31__latches2_24__latchesa Din[24] Dout1[24] Dout2[24] n253 n252 Sal_and_write[31]
+ n128 VSS VDD_1V8 latchtriestado_7
Xlatches1_31__latches2_23__latchesa Din[23] Dout1[23] Dout2[23] n253 n252 Sal_and_write[31]
+ n128 VSS VDD_1V8 latchtriestado_8
Xlatches1_31__latches2_22__latchesa Din[22] Dout1[22] Dout2[22] n253 n252 Sal_and_write[31]
+ n96 VSS VDD_1V8 latchtriestado_9
Xlatches1_31__latches2_21__latchesa Din[21] Dout1[21] Dout2[21] n253 n252 Sal_and_write[31]
+ n128 VSS VDD_1V8 latchtriestado_10
Xlatches1_31__latches2_20__latchesa Din[20] Dout1[20] Dout2[20] n253 n252 Sal_and_write[31]
+ n95 VSS VDD_1V8 latchtriestado_11
Xlatches1_31__latches2_19__latchesa Din[19] Dout1[19] Dout2[19] n253 n252 Sal_and_write[31]
+ n93 VSS VDD_1V8 latchtriestado_12
Xlatches1_31__latches2_18__latchesa Din[18] Dout1[18] Dout2[18] n253 n252 Sal_and_write[31]
+ IN89 VSS VDD_1V8 latchtriestado_13
Xlatches1_31__latches2_17__latchesa Din[17] Dout1[17] Dout2[17] n253 n252 Sal_and_write[31]
+ IN130 VSS VDD_1V8 latchtriestado_14
Xlatches1_31__latches2_16__latchesa Din[16] Dout1[16] Dout2[16] n253 n252 Sal_and_write[31]
+ IN109 VSS VDD_1V8 latchtriestado_15
Xlatches1_31__latches2_15__latchesa Din[15] Dout1[15] Dout2[15] n253 n252 Sal_and_write[31]
+ IN115 VSS VDD_1V8 latchtriestado_16
Xlatches1_31__latches2_14__latchesa Din[14] Dout1[14] Dout2[14] n253 n252 Sal_and_write[31]
+ n4 VSS VDD_1V8 latchtriestado_17
Xlatches1_31__latches2_13__latchesa Din[13] Dout1[13] Dout2[13] n253 n252 Sal_and_write[31]
+ n29 VSS VDD_1V8 latchtriestado_18
Xlatches1_31__latches2_12__latchesa Din[12] Dout1[12] Dout2[12] n253 n252 Sal_and_write[31]
+ n130 VSS VDD_1V8 latchtriestado_19
Xlatches1_31__latches2_11__latchesa Din[11] Dout1[11] Dout2[11] n253 n252 Sal_and_write[31]
+ n30 VSS VDD_1V8 latchtriestado_20
Xlatches1_31__latches2_10__latchesa Din[10] Dout1[10] Dout2[10] n253 n252 Sal_and_write[31]
+ IN9 VSS VDD_1V8 latchtriestado_21
Xlatches1_31__latches2_9__latchesa Din[9] Dout1[9] Dout2[9] n253 n252 Sal_and_write[31]
+ n129 VSS VDD_1V8 latchtriestado_22
Xlatches1_31__latches2_8__latchesa Din[8] Dout1[8] Dout2[8] n253 n252 Sal_and_write[31]
+ n130 VSS VDD_1V8 latchtriestado_23
Xlatches1_31__latches2_7__latchesa Din[7] Dout1[7] Dout2[7] n253 n252 Sal_and_write[31]
+ n30 VSS VDD_1V8 latchtriestado_24
Xlatches1_31__latches2_6__latchesa Din[6] Dout1[6] Dout2[6] n253 n252 Sal_and_write[31]
+ n30 VSS VDD_1V8 latchtriestado_25
Xlatches1_31__latches2_5__latchesa Din[5] Dout1[5] Dout2[5] n253 n252 Sal_and_write[31]
+ n30 VSS VDD_1V8 latchtriestado_26
Xlatches1_31__latches2_4__latchesa Din[4] Dout1[4] Dout2[4] n253 n252 Sal_and_write[31]
+ n29 VSS VDD_1V8 latchtriestado_27
Xlatches1_31__latches2_3__latchesa Din[3] Dout1[3] Dout2[3] n253 n252 Sal_and_write[31]
+ n30 VSS VDD_1V8 latchtriestado_28
Xlatches1_31__latches2_2__latchesa Din[2] Dout1[2] Dout2[2] n253 n252 Sal_and_write[31]
+ n129 VSS VDD_1V8 latchtriestado_29
Xlatches1_31__latches2_1__latchesa Din[1] Dout1[1] Dout2[1] n253 n252 Sal_and_write[31]
+ n30 VSS VDD_1V8 latchtriestado_30
Xlatches1_31__latches2_0__latchesa Din[0] Dout1[0] Dout2[0] n253 n252 Sal_and_write[31]
+ IN105 VSS VDD_1V8 latchtriestado_31
Xlatches1_30__latches2_31__latchesa Din[31] Dout1[31] Dout2[31] n291 n259 CTS_CLK_CTO_delay221
+ n94 VSS VDD_1V8 latchtriestado_32
Xlatches1_30__latches2_30__latchesa Din[30] Dout1[30] Dout2[30] n291 n259 CTS_CLK_CTO_delay221
+ n126 VSS VDD_1V8 latchtriestado_33
Xlatches1_30__latches2_29__latchesa Din[29] Dout1[29] Dout2[29] n291 n259 CTS_CLK_CTO_delay221
+ n74 VSS VDD_1V8 latchtriestado_34
Xlatches1_30__latches2_28__latchesa Din[28] Dout1[28] Dout2[28] n291 n259 CTS_CLK_CTO_delay221
+ n96 VSS VDD_1V8 latchtriestado_35
Xlatches1_30__latches2_27__latchesa Din[27] Dout1[27] Dout2[27] n291 n259 CTS_CLK_CTO_delay221
+ n74 VSS VDD_1V8 latchtriestado_36
Xlatches1_30__latches2_26__latchesa Din[26] Dout1[26] Dout2[26] n291 n259 CTS_CLK_CTO_delay221
+ n96 VSS VDD_1V8 latchtriestado_37
Xlatches1_30__latches2_25__latchesa Din[25] Dout1[25] Dout2[25] n291 n259 CTS_CLK_CTO_delay221
+ n93 VSS VDD_1V8 latchtriestado_38
Xlatches1_30__latches2_24__latchesa Din[24] Dout1[24] Dout2[24] n291 n259 CTS_CLK_CTO_delay221
+ n96 VSS VDD_1V8 latchtriestado_39
Xlatches1_30__latches2_23__latchesa Din[23] Dout1[23] Dout2[23] n291 n259 CTS_CLK_CTO_delay221
+ n74 VSS VDD_1V8 latchtriestado_40
Xlatches1_30__latches2_22__latchesa Din[22] Dout1[22] Dout2[22] n291 n259 CTS_CLK_CTO_delay221
+ n74 VSS VDD_1V8 latchtriestado_41
Xlatches1_30__latches2_21__latchesa Din[21] Dout1[21] Dout2[21] n291 n259 CTS_CLK_CTO_delay221
+ IN122 VSS VDD_1V8 latchtriestado_42
Xlatches1_30__latches2_20__latchesa Din[20] Dout1[20] Dout2[20] n291 n259 CTS_CLK_CTO_delay221
+ n94 VSS VDD_1V8 latchtriestado_43
Xlatches1_30__latches2_19__latchesa Din[19] Dout1[19] Dout2[19] n291 n259 CTS_CLK_CTO_delay221
+ IN127 VSS VDD_1V8 latchtriestado_44
Xlatches1_30__latches2_18__latchesa Din[18] Dout1[18] Dout2[18] n291 n259 CTS_CLK_CTO_delay221
+ n127 VSS VDD_1V8 latchtriestado_45
Xlatches1_30__latches2_17__latchesa Din[17] Dout1[17] Dout2[17] n291 n259 CTS_CLK_CTO_delay221
+ n127 VSS VDD_1V8 latchtriestado_46
Xlatches1_30__latches2_16__latchesa Din[16] Dout1[16] Dout2[16] n291 n259 CTS_CLK_CTO_delay221
+ n94 VSS VDD_1V8 latchtriestado_47
Xlatches1_30__latches2_15__latchesa Din[15] Dout1[15] Dout2[15] n291 n259 CTS_CLK_CTO_delay221
+ n4 VSS VDD_1V8 latchtriestado_48
Xlatches1_30__latches2_14__latchesa Din[14] Dout1[14] Dout2[14] n291 n259 CTS_CLK_CTO_delay221
+ n4 VSS VDD_1V8 latchtriestado_49
Xlatches1_30__latches2_13__latchesa Din[13] Dout1[13] Dout2[13] conect_deco_latch1[30]
+ conect_deco_latch2[30] CTS_CLK_CTO_delay221 n4 VSS VDD_1V8 latchtriestado_50
Xlatches1_30__latches2_12__latchesa Din[12] Dout1[12] Dout2[12] n291 n259 CTS_CLK_CTO_delay221
+ n30 VSS VDD_1V8 latchtriestado_51
Xlatches1_30__latches2_11__latchesa Din[11] Dout1[11] Dout2[11] n291 n259 CTS_CLK_CTO_delay221
+ n30 VSS VDD_1V8 latchtriestado_52
Xlatches1_30__latches2_10__latchesa Din[10] Dout1[10] Dout2[10] n291 n259 CTS_CLK_CTO_delay221
+ n30 VSS VDD_1V8 latchtriestado_53
Xlatches1_30__latches2_9__latchesa Din[9] Dout1[9] Dout2[9] n291 n259 CTS_CLK_CTO_delay221
+ n75 VSS VDD_1V8 latchtriestado_54
Xlatches1_30__latches2_8__latchesa Din[8] Dout1[8] Dout2[8] n291 n259 CTS_CLK_CTO_delay221
+ n130 VSS VDD_1V8 latchtriestado_55
Xlatches1_30__latches2_7__latchesa Din[7] Dout1[7] Dout2[7] n291 n259 CTS_CLK_CTO_delay221
+ n130 VSS VDD_1V8 latchtriestado_56
Xlatches1_30__latches2_6__latchesa Din[6] Dout1[6] Dout2[6] n291 n259 CTS_CLK_CTO_delay221
+ n130 VSS VDD_1V8 latchtriestado_57
Xlatches1_30__latches2_5__latchesa Din[5] Dout1[5] Dout2[5] n291 n259 CTS_CLK_CTO_delay221
+ n130 VSS VDD_1V8 latchtriestado_58
Xlatches1_30__latches2_4__latchesa Din[4] Dout1[4] Dout2[4] n291 n259 CTS_CLK_CTO_delay221
+ n75 VSS VDD_1V8 latchtriestado_59
Xlatches1_30__latches2_3__latchesa Din[3] Dout1[3] Dout2[3] n291 n259 CTS_CLK_CTO_delay221
+ n30 VSS VDD_1V8 latchtriestado_60
Xlatches1_30__latches2_2__latchesa Din[2] Dout1[2] Dout2[2] n291 n259 CTS_CLK_CTO_delay221
+ IN79 VSS VDD_1V8 latchtriestado_61
Xlatches1_30__latches2_1__latchesa Din[1] Dout1[1] Dout2[1] n291 n259 CTS_CLK_CTO_delay221
+ n130 VSS VDD_1V8 latchtriestado_62
Xlatches1_30__latches2_0__latchesa Din[0] Dout1[0] Dout2[0] n291 n259 CTS_CLK_CTO_delay221
+ n126 VSS VDD_1V8 latchtriestado_63
Xlatches1_29__latches2_31__latchesa Din[31] Dout1[31] Dout2[31] n293 n258 Sal_and_write_G5B2I1_29_
+ n126 VSS VDD_1V8 latchtriestado_64
Xlatches1_29__latches2_30__latchesa Din[30] Dout1[30] Dout2[30] n293 n258 Sal_and_write_G5B2I1_29_
+ n75 VSS VDD_1V8 latchtriestado_65
Xlatches1_29__latches2_29__latchesa Din[29] Dout1[29] Dout2[29] n293 n258 Sal_and_write_G5B2I1_29_
+ n128 VSS VDD_1V8 latchtriestado_66
Xlatches1_29__latches2_28__latchesa Din[28] Dout1[28] Dout2[28] n293 n258 Sal_and_write_G5B2I1_29_
+ n73 VSS VDD_1V8 latchtriestado_67
Xlatches1_29__latches2_27__latchesa Din[27] Dout1[27] Dout2[27] n293 n258 Sal_and_write_G5B2I1_29_
+ n74 VSS VDD_1V8 latchtriestado_68
Xlatches1_29__latches2_26__latchesa Din[26] Dout1[26] Dout2[26] n293 n258 Sal_and_write_G5B2I1_29_
+ n73 VSS VDD_1V8 latchtriestado_69
Xlatches1_29__latches2_25__latchesa Din[25] Dout1[25] Dout2[25] n293 n258 Sal_and_write_G5B2I1_29_
+ n128 VSS VDD_1V8 latchtriestado_70
Xlatches1_29__latches2_24__latchesa Din[24] Dout1[24] Dout2[24] n293 n258 Sal_and_write_G5B2I1_29_
+ n74 VSS VDD_1V8 latchtriestado_71
Xlatches1_29__latches2_23__latchesa Din[23] Dout1[23] Dout2[23] n293 n258 Sal_and_write_G5B2I1_29_
+ n74 VSS VDD_1V8 latchtriestado_72
Xlatches1_29__latches2_22__latchesa Din[22] Dout1[22] Dout2[22] n293 n258 Sal_and_write_G5B2I1_29_
+ n74 VSS VDD_1V8 latchtriestado_73
Xlatches1_29__latches2_21__latchesa Din[21] Dout1[21] Dout2[21] n293 n258 Sal_and_write_G5B2I1_29_
+ n74 VSS VDD_1V8 latchtriestado_74
Xlatches1_29__latches2_20__latchesa Din[20] Dout1[20] Dout2[20] n293 n258 Sal_and_write_G5B2I1_29_
+ n5 VSS VDD_1V8 latchtriestado_75
Xlatches1_29__latches2_19__latchesa Din[19] Dout1[19] Dout2[19] n293 n258 Sal_and_write_G5B2I1_29_
+ n74 VSS VDD_1V8 latchtriestado_76
Xlatches1_29__latches2_18__latchesa Din[18] Dout1[18] Dout2[18] n293 n258 Sal_and_write_G5B2I1_29_
+ n127 VSS VDD_1V8 latchtriestado_77
Xlatches1_29__latches2_17__latchesa Din[17] Dout1[17] Dout2[17] n293 n258 Sal_and_write_G5B2I1_29_
+ n5 VSS VDD_1V8 latchtriestado_78
Xlatches1_29__latches2_16__latchesa Din[16] Dout1[16] Dout2[16] n293 n258 Sal_and_write_G5B2I1_29_
+ n95 VSS VDD_1V8 latchtriestado_79
Xlatches1_29__latches2_15__latchesa Din[15] Dout1[15] Dout2[15] n293 n258 Sal_and_write_G5B2I1_29_
+ n29 VSS VDD_1V8 latchtriestado_80
Xlatches1_29__latches2_14__latchesa Din[14] Dout1[14] Dout2[14] n293 n258 Sal_and_write_G5B2I1_29_
+ n29 VSS VDD_1V8 latchtriestado_81
Xlatches1_29__latches2_13__latchesa Din[13] Dout1[13] Dout2[13] n293 n258 Sal_and_write_G5B2I1_29_
+ n29 VSS VDD_1V8 latchtriestado_82
Xlatches1_29__latches2_12__latchesa Din[12] Dout1[12] Dout2[12] n293 n258 Sal_and_write_G5B2I1_29_
+ n129 VSS VDD_1V8 latchtriestado_83
Xlatches1_29__latches2_11__latchesa Din[11] Dout1[11] Dout2[11] n293 n258 Sal_and_write_G5B2I1_29_
+ IN147 VSS VDD_1V8 latchtriestado_84
Xlatches1_29__latches2_10__latchesa Din[10] Dout1[10] Dout2[10] n293 n258 Sal_and_write_G5B2I1_29_
+ IN142 VSS VDD_1V8 latchtriestado_85
Xlatches1_29__latches2_9__latchesa Din[9] Dout1[9] Dout2[9] n293 n258 Sal_and_write_G5B2I1_29_
+ n130 VSS VDD_1V8 latchtriestado_86
Xlatches1_29__latches2_8__latchesa Din[8] Dout1[8] Dout2[8] n293 n258 Sal_and_write_G5B2I1_29_
+ n130 VSS VDD_1V8 latchtriestado_87
Xlatches1_29__latches2_7__latchesa Din[7] Dout1[7] Dout2[7] n293 n258 Sal_and_write_G5B2I1_29_
+ n129 VSS VDD_1V8 latchtriestado_88
Xlatches1_29__latches2_6__latchesa Din[6] Dout1[6] Dout2[6] n293 n258 Sal_and_write_G5B2I1_29_
+ n129 VSS VDD_1V8 latchtriestado_89
Xlatches1_29__latches2_5__latchesa Din[5] Dout1[5] Dout2[5] n293 n258 Sal_and_write_G5B2I1_29_
+ n129 VSS VDD_1V8 latchtriestado_90
Xlatches1_29__latches2_4__latchesa Din[4] Dout1[4] Dout2[4] n293 n258 Sal_and_write_G5B2I1_29_
+ n75 VSS VDD_1V8 latchtriestado_91
Xlatches1_29__latches2_3__latchesa Din[3] Dout1[3] Dout2[3] n293 n258 Sal_and_write_G5B2I1_29_
+ n128 VSS VDD_1V8 latchtriestado_92
Xlatches1_29__latches2_2__latchesa Din[2] Dout1[2] Dout2[2] n293 n258 Sal_and_write_G5B2I1_29_
+ n75 VSS VDD_1V8 latchtriestado_93
Xlatches1_29__latches2_1__latchesa Din[1] Dout1[1] Dout2[1] n293 n258 Sal_and_write_G5B2I1_29_
+ n75 VSS VDD_1V8 latchtriestado_94
Xlatches1_29__latches2_0__latchesa Din[0] Dout1[0] Dout2[0] n293 n258 Sal_and_write_G5B2I1_29_
+ n75 VSS VDD_1V8 latchtriestado_95
Xlatches1_28__latches2_31__latchesa Din[31] Dout1[31] Dout2[31] conect_deco_latch1[28]
+ conect_deco_latch2[28] Sal_and_write[28] n4 VSS VDD_1V8 latchtriestado_96
Xlatches1_28__latches2_30__latchesa Din[30] Dout1[30] Dout2[30] conect_deco_latch1[28]
+ conect_deco_latch2[28] Sal_and_write[28] n29 VSS VDD_1V8 latchtriestado_97
Xlatches1_28__latches2_29__latchesa Din[29] Dout1[29] Dout2[29] conect_deco_latch1[28]
+ conect_deco_latch2[28] Sal_and_write[28] n4 VSS VDD_1V8 latchtriestado_98
Xlatches1_28__latches2_28__latchesa Din[28] Dout1[28] Dout2[28] conect_deco_latch1[28]
+ conect_deco_latch2[28] Sal_and_write[28] IN49 VSS VDD_1V8 latchtriestado_99
Xlatches1_28__latches2_27__latchesa Din[27] Dout1[27] Dout2[27] conect_deco_latch1[28]
+ conect_deco_latch2[28] Sal_and_write[28] n94 VSS VDD_1V8 latchtriestado_100
Xlatches1_28__latches2_26__latchesa Din[26] Dout1[26] Dout2[26] conect_deco_latch1[28]
+ conect_deco_latch2[28] Sal_and_write[28] n94 VSS VDD_1V8 latchtriestado_101
Xlatches1_28__latches2_25__latchesa Din[25] Dout1[25] Dout2[25] conect_deco_latch1[28]
+ conect_deco_latch2[28] Sal_and_write[28] n95 VSS VDD_1V8 latchtriestado_102
Xlatches1_28__latches2_24__latchesa Din[24] Dout1[24] Dout2[24] conect_deco_latch1[28]
+ conect_deco_latch2[28] Sal_and_write[28] n95 VSS VDD_1V8 latchtriestado_103
Xlatches1_28__latches2_23__latchesa Din[23] Dout1[23] Dout2[23] conect_deco_latch1[28]
+ conect_deco_latch2[28] Sal_and_write[28] n95 VSS VDD_1V8 latchtriestado_104
Xlatches1_28__latches2_22__latchesa Din[22] Dout1[22] Dout2[22] conect_deco_latch1[28]
+ conect_deco_latch2[28] Sal_and_write[28] n95 VSS VDD_1V8 latchtriestado_105
Xlatches1_28__latches2_21__latchesa Din[21] Dout1[21] Dout2[21] conect_deco_latch1[28]
+ conect_deco_latch2[28] Sal_and_write[28] n95 VSS VDD_1V8 latchtriestado_106
Xlatches1_28__latches2_20__latchesa Din[20] Dout1[20] Dout2[20] conect_deco_latch1[28]
+ conect_deco_latch2[28] Sal_and_write[28] n94 VSS VDD_1V8 latchtriestado_107
Xlatches1_28__latches2_19__latchesa Din[19] Dout1[19] Dout2[19] conect_deco_latch1[28]
+ conect_deco_latch2[28] Sal_and_write[28] n95 VSS VDD_1V8 latchtriestado_108
Xlatches1_28__latches2_18__latchesa Din[18] Dout1[18] Dout2[18] conect_deco_latch1[28]
+ conect_deco_latch2[28] Sal_and_write[28] n94 VSS VDD_1V8 latchtriestado_109
Xlatches1_28__latches2_17__latchesa Din[17] Dout1[17] Dout2[17] conect_deco_latch1[28]
+ conect_deco_latch2[28] Sal_and_write[28] n94 VSS VDD_1V8 latchtriestado_110
Xlatches1_28__latches2_16__latchesa Din[16] Dout1[16] Dout2[16] conect_deco_latch1[28]
+ conect_deco_latch2[28] Sal_and_write[28] n4 VSS VDD_1V8 latchtriestado_111
Xlatches1_28__latches2_15__latchesa Din[15] Dout1[15] Dout2[15] conect_deco_latch1[28]
+ conect_deco_latch2[28] Sal_and_write[28] IN67 VSS VDD_1V8 latchtriestado_112
Xlatches1_28__latches2_14__latchesa Din[14] Dout1[14] Dout2[14] conect_deco_latch1[28]
+ conect_deco_latch2[28] Sal_and_write[28] IN50 VSS VDD_1V8 latchtriestado_113
Xlatches1_28__latches2_13__latchesa Din[13] Dout1[13] Dout2[13] conect_deco_latch1[28]
+ conect_deco_latch2[28] Sal_and_write[28] IN51 VSS VDD_1V8 latchtriestado_114
Xlatches1_28__latches2_12__latchesa Din[12] Dout1[12] Dout2[12] conect_deco_latch1[28]
+ conect_deco_latch2[28] Sal_and_write[28] IN181 VSS VDD_1V8 latchtriestado_115
Xlatches1_28__latches2_11__latchesa Din[11] Dout1[11] Dout2[11] conect_deco_latch1[28]
+ conect_deco_latch2[28] Sal_and_write[28] IN31 VSS VDD_1V8 latchtriestado_116
Xlatches1_28__latches2_10__latchesa Din[10] Dout1[10] Dout2[10] conect_deco_latch1[28]
+ conect_deco_latch2[28] Sal_and_write[28] IN176 VSS VDD_1V8 latchtriestado_117
Xlatches1_28__latches2_9__latchesa Din[9] Dout1[9] Dout2[9] conect_deco_latch1[28]
+ conect_deco_latch2[28] Sal_and_write[28] n29 VSS VDD_1V8 latchtriestado_118
Xlatches1_28__latches2_8__latchesa Din[8] Dout1[8] Dout2[8] conect_deco_latch1[28]
+ conect_deco_latch2[28] Sal_and_write[28] IN183 VSS VDD_1V8 latchtriestado_119
Xlatches1_28__latches2_7__latchesa Din[7] Dout1[7] Dout2[7] conect_deco_latch1[28]
+ conect_deco_latch2[28] Sal_and_write[28] IN187 VSS VDD_1V8 latchtriestado_120
Xlatches1_28__latches2_6__latchesa Din[6] Dout1[6] Dout2[6] conect_deco_latch1[28]
+ conect_deco_latch2[28] Sal_and_write[28] IN178 VSS VDD_1V8 latchtriestado_121
Xlatches1_28__latches2_5__latchesa Din[5] Dout1[5] Dout2[5] conect_deco_latch1[28]
+ conect_deco_latch2[28] Sal_and_write[28] IN185 VSS VDD_1V8 latchtriestado_122
Xlatches1_28__latches2_4__latchesa Din[4] Dout1[4] Dout2[4] conect_deco_latch1[28]
+ conect_deco_latch2[28] Sal_and_write[28] IN46 VSS VDD_1V8 latchtriestado_123
Xlatches1_28__latches2_3__latchesa Din[3] Dout1[3] Dout2[3] conect_deco_latch1[28]
+ conect_deco_latch2[28] Sal_and_write[28] n95 VSS VDD_1V8 latchtriestado_124
Xlatches1_28__latches2_2__latchesa Din[2] Dout1[2] Dout2[2] conect_deco_latch1[28]
+ conect_deco_latch2[28] Sal_and_write[28] IN71 VSS VDD_1V8 latchtriestado_125
Xlatches1_28__latches2_1__latchesa Din[1] Dout1[1] Dout2[1] conect_deco_latch1[28]
+ conect_deco_latch2[28] Sal_and_write[28] IN179 VSS VDD_1V8 latchtriestado_126
Xlatches1_28__latches2_0__latchesa Din[0] Dout1[0] Dout2[0] conect_deco_latch1[28]
+ conect_deco_latch2[28] Sal_and_write[28] IN52 VSS VDD_1V8 latchtriestado_127
Xlatches1_27__latches2_31__latchesa Din[31] Dout1[31] Dout2[31] n290 n255 CTS_CLK_CTO_delay261
+ n127 VSS VDD_1V8 latchtriestado_128
Xlatches1_27__latches2_30__latchesa Din[30] Dout1[30] Dout2[30] n290 n255 CTS_CLK_CTO_delay261
+ n29 VSS VDD_1V8 latchtriestado_129
Xlatches1_27__latches2_29__latchesa Din[29] Dout1[29] Dout2[29] n290 n255 CTS_CLK_CTO_delay261
+ n93 VSS VDD_1V8 latchtriestado_130
Xlatches1_27__latches2_28__latchesa Din[28] Dout1[28] Dout2[28] n290 n255 CTS_CLK_CTO_delay261
+ n93 VSS VDD_1V8 latchtriestado_131
Xlatches1_27__latches2_27__latchesa Din[27] Dout1[27] Dout2[27] n290 n255 CTS_CLK_CTO_delay261
+ n73 VSS VDD_1V8 latchtriestado_132
Xlatches1_27__latches2_26__latchesa Din[26] Dout1[26] Dout2[26] n290 n255 CTS_CLK_CTO_delay261
+ n73 VSS VDD_1V8 latchtriestado_133
Xlatches1_27__latches2_25__latchesa Din[25] Dout1[25] Dout2[25] n290 n255 CTS_CLK_CTO_delay261
+ n127 VSS VDD_1V8 latchtriestado_134
Xlatches1_27__latches2_24__latchesa Din[24] Dout1[24] Dout2[24] n290 n255 CTS_CLK_CTO_delay261
+ n127 VSS VDD_1V8 latchtriestado_135
Xlatches1_27__latches2_23__latchesa Din[23] Dout1[23] Dout2[23] n290 n255 CTS_CLK_CTO_delay261
+ n128 VSS VDD_1V8 latchtriestado_136
Xlatches1_27__latches2_22__latchesa Din[22] Dout1[22] Dout2[22] n290 n255 CTS_CLK_CTO_delay261
+ n73 VSS VDD_1V8 latchtriestado_137
Xlatches1_27__latches2_21__latchesa Din[21] Dout1[21] Dout2[21] n290 n255 CTS_CLK_CTO_delay261
+ n73 VSS VDD_1V8 latchtriestado_138
Xlatches1_27__latches2_20__latchesa Din[20] Dout1[20] Dout2[20] n290 n255 CTS_CLK_CTO_delay261
+ n95 VSS VDD_1V8 latchtriestado_139
Xlatches1_27__latches2_19__latchesa Din[19] Dout1[19] Dout2[19] n290 n255 CTS_CLK_CTO_delay261
+ n128 VSS VDD_1V8 latchtriestado_140
Xlatches1_27__latches2_18__latchesa Din[18] Dout1[18] Dout2[18] n290 n255 CTS_CLK_CTO_delay261
+ n5 VSS VDD_1V8 latchtriestado_141
Xlatches1_27__latches2_17__latchesa Din[17] Dout1[17] Dout2[17] n290 n255 CTS_CLK_CTO_delay261
+ n127 VSS VDD_1V8 latchtriestado_142
Xlatches1_27__latches2_16__latchesa Din[16] Dout1[16] Dout2[16] n290 n255 CTS_CLK_CTO_delay261
+ n95 VSS VDD_1V8 latchtriestado_143
Xlatches1_27__latches2_15__latchesa Din[15] Dout1[15] Dout2[15] n290 n255 CTS_CLK_CTO_delay261
+ n29 VSS VDD_1V8 latchtriestado_144
Xlatches1_27__latches2_14__latchesa Din[14] Dout1[14] Dout2[14] n290 n255 CTS_CLK_CTO_delay261
+ IN62 VSS VDD_1V8 latchtriestado_145
Xlatches1_27__latches2_13__latchesa Din[13] Dout1[13] Dout2[13] n290 n255 CTS_CLK_CTO_delay261
+ IN59 VSS VDD_1V8 latchtriestado_146
Xlatches1_27__latches2_12__latchesa Din[12] Dout1[12] Dout2[12] n290 n255 CTS_CLK_CTO_delay261
+ n130 VSS VDD_1V8 latchtriestado_147
Xlatches1_27__latches2_11__latchesa Din[11] Dout1[11] Dout2[11] n290 n255 CTS_CLK_CTO_delay261
+ IN1 VSS VDD_1V8 latchtriestado_148
Xlatches1_27__latches2_10__latchesa Din[10] Dout1[10] Dout2[10] n290 n255 CTS_CLK_CTO_delay261
+ IN0 VSS VDD_1V8 latchtriestado_149
Xlatches1_27__latches2_9__latchesa Din[9] Dout1[9] Dout2[9] n290 n255 CTS_CLK_CTO_delay261
+ n30 VSS VDD_1V8 latchtriestado_150
Xlatches1_27__latches2_8__latchesa Din[8] Dout1[8] Dout2[8] n290 n255 CTS_CLK_CTO_delay261
+ IN17 VSS VDD_1V8 latchtriestado_151
Xlatches1_27__latches2_7__latchesa Din[7] Dout1[7] Dout2[7] n290 n255 CTS_CLK_CTO_delay261
+ n130 VSS VDD_1V8 latchtriestado_152
Xlatches1_27__latches2_6__latchesa Din[6] Dout1[6] Dout2[6] n290 n255 CTS_CLK_CTO_delay261
+ n130 VSS VDD_1V8 latchtriestado_153
Xlatches1_27__latches2_5__latchesa Din[5] Dout1[5] Dout2[5] n290 n255 CTS_CLK_CTO_delay261
+ n30 VSS VDD_1V8 latchtriestado_154
Xlatches1_27__latches2_4__latchesa Din[4] Dout1[4] Dout2[4] n290 n255 CTS_CLK_CTO_delay261
+ n29 VSS VDD_1V8 latchtriestado_155
Xlatches1_27__latches2_3__latchesa Din[3] Dout1[3] Dout2[3] n290 n255 CTS_CLK_CTO_delay261
+ n218 VSS VDD_1V8 latchtriestado_156
Xlatches1_27__latches2_2__latchesa Din[2] Dout1[2] Dout2[2] n290 n255 CTS_CLK_CTO_delay261
+ n218 VSS VDD_1V8 latchtriestado_157
Xlatches1_27__latches2_1__latchesa Din[1] Dout1[1] Dout2[1] n290 n255 CTS_CLK_CTO_delay261
+ n218 VSS VDD_1V8 latchtriestado_158
Xlatches1_27__latches2_0__latchesa Din[0] Dout1[0] Dout2[0] n290 n255 CTS_CLK_CTO_delay261
+ IN53 VSS VDD_1V8 latchtriestado_159
Xlatches1_26__latches2_31__latchesa Din[31] Dout1[31] Dout2[31] n289 n256 CTS_CLK_CTO_delay201
+ n5 VSS VDD_1V8 latchtriestado_160
Xlatches1_26__latches2_30__latchesa Din[30] Dout1[30] Dout2[30] n289 n256 CTS_CLK_CTO_delay201
+ n75 VSS VDD_1V8 latchtriestado_161
Xlatches1_26__latches2_29__latchesa Din[29] Dout1[29] Dout2[29] n289 n256 CTS_CLK_CTO_delay201
+ n128 VSS VDD_1V8 latchtriestado_162
Xlatches1_26__latches2_28__latchesa Din[28] Dout1[28] Dout2[28] n289 n256 CTS_CLK_CTO_delay201
+ n73 VSS VDD_1V8 latchtriestado_163
Xlatches1_26__latches2_27__latchesa Din[27] Dout1[27] Dout2[27] n289 n256 CTS_CLK_CTO_delay201
+ n74 VSS VDD_1V8 latchtriestado_164
Xlatches1_26__latches2_26__latchesa Din[26] Dout1[26] Dout2[26] n289 n256 CTS_CLK_CTO_delay201
+ n73 VSS VDD_1V8 latchtriestado_165
Xlatches1_26__latches2_25__latchesa Din[25] Dout1[25] Dout2[25] n289 n256 CTS_CLK_CTO_delay201
+ n74 VSS VDD_1V8 latchtriestado_166
Xlatches1_26__latches2_24__latchesa Din[24] Dout1[24] Dout2[24] n289 n256 CTS_CLK_CTO_delay201
+ n128 VSS VDD_1V8 latchtriestado_167
Xlatches1_26__latches2_23__latchesa Din[23] Dout1[23] Dout2[23] n289 n256 CTS_CLK_CTO_delay201
+ n74 VSS VDD_1V8 latchtriestado_168
Xlatches1_26__latches2_22__latchesa Din[22] Dout1[22] Dout2[22] n289 n256 CTS_CLK_CTO_delay201
+ n74 VSS VDD_1V8 latchtriestado_169
Xlatches1_26__latches2_21__latchesa Din[21] Dout1[21] Dout2[21] n289 n256 CTS_CLK_CTO_delay201
+ n74 VSS VDD_1V8 latchtriestado_170
Xlatches1_26__latches2_20__latchesa Din[20] Dout1[20] Dout2[20] n289 n256 CTS_CLK_CTO_delay201
+ n5 VSS VDD_1V8 latchtriestado_171
Xlatches1_26__latches2_19__latchesa Din[19] Dout1[19] Dout2[19] n289 n256 CTS_CLK_CTO_delay201
+ n128 VSS VDD_1V8 latchtriestado_172
Xlatches1_26__latches2_18__latchesa Din[18] Dout1[18] Dout2[18] n289 n256 CTS_CLK_CTO_delay201
+ n5 VSS VDD_1V8 latchtriestado_173
Xlatches1_26__latches2_17__latchesa Din[17] Dout1[17] Dout2[17] n289 n256 CTS_CLK_CTO_delay201
+ n127 VSS VDD_1V8 latchtriestado_174
Xlatches1_26__latches2_16__latchesa Din[16] Dout1[16] Dout2[16] n289 n256 CTS_CLK_CTO_delay201
+ n5 VSS VDD_1V8 latchtriestado_175
Xlatches1_26__latches2_15__latchesa Din[15] Dout1[15] Dout2[15] n289 n256 CTS_CLK_CTO_delay201
+ n218 VSS VDD_1V8 latchtriestado_176
Xlatches1_26__latches2_14__latchesa Din[14] Dout1[14] Dout2[14] n289 n256 CTS_CLK_CTO_delay201
+ n218 VSS VDD_1V8 latchtriestado_177
Xlatches1_26__latches2_13__latchesa Din[13] Dout1[13] Dout2[13] n289 n256 CTS_CLK_CTO_delay201
+ n218 VSS VDD_1V8 latchtriestado_178
Xlatches1_26__latches2_12__latchesa Din[12] Dout1[12] Dout2[12] n289 n256 CTS_CLK_CTO_delay201
+ n130 VSS VDD_1V8 latchtriestado_179
Xlatches1_26__latches2_11__latchesa Din[11] Dout1[11] Dout2[11] n289 n256 CTS_CLK_CTO_delay201
+ n30 VSS VDD_1V8 latchtriestado_180
Xlatches1_26__latches2_10__latchesa Din[10] Dout1[10] Dout2[10] n289 n256 CTS_CLK_CTO_delay201
+ n30 VSS VDD_1V8 latchtriestado_181
Xlatches1_26__latches2_9__latchesa Din[9] Dout1[9] Dout2[9] n289 n256 CTS_CLK_CTO_delay201
+ n130 VSS VDD_1V8 latchtriestado_182
Xlatches1_26__latches2_8__latchesa Din[8] Dout1[8] Dout2[8] n289 n256 CTS_CLK_CTO_delay201
+ n130 VSS VDD_1V8 latchtriestado_183
Xlatches1_26__latches2_7__latchesa Din[7] Dout1[7] Dout2[7] n289 n256 CTS_CLK_CTO_delay201
+ n130 VSS VDD_1V8 latchtriestado_184
Xlatches1_26__latches2_6__latchesa Din[6] Dout1[6] Dout2[6] n289 n256 CTS_CLK_CTO_delay201
+ n130 VSS VDD_1V8 latchtriestado_185
Xlatches1_26__latches2_5__latchesa Din[5] Dout1[5] Dout2[5] n289 n256 CTS_CLK_CTO_delay201
+ n30 VSS VDD_1V8 latchtriestado_186
Xlatches1_26__latches2_4__latchesa Din[4] Dout1[4] Dout2[4] n289 n256 CTS_CLK_CTO_delay201
+ n75 VSS VDD_1V8 latchtriestado_187
Xlatches1_26__latches2_3__latchesa Din[3] Dout1[3] Dout2[3] n289 n256 CTS_CLK_CTO_delay201
+ n128 VSS VDD_1V8 latchtriestado_188
Xlatches1_26__latches2_2__latchesa Din[2] Dout1[2] Dout2[2] n289 n256 CTS_CLK_CTO_delay201
+ n75 VSS VDD_1V8 latchtriestado_189
Xlatches1_26__latches2_1__latchesa Din[1] Dout1[1] Dout2[1] n289 n256 CTS_CLK_CTO_delay201
+ n75 VSS VDD_1V8 latchtriestado_190
Xlatches1_26__latches2_0__latchesa Din[0] Dout1[0] Dout2[0] n289 n256 CTS_CLK_CTO_delay201
+ n126 VSS VDD_1V8 latchtriestado_191
Xlatches1_25__latches2_31__latchesa Din[31] Dout1[31] Dout2[31] n288 n254 Sal_and_write[25]
+ n5 VSS VDD_1V8 latchtriestado_192
Xlatches1_25__latches2_30__latchesa Din[30] Dout1[30] Dout2[30] n288 n254 Sal_and_write[25]
+ IN73 VSS VDD_1V8 latchtriestado_193
Xlatches1_25__latches2_29__latchesa Din[29] Dout1[29] Dout2[29] n288 n254 Sal_and_write[25]
+ n96 VSS VDD_1V8 latchtriestado_194
Xlatches1_25__latches2_28__latchesa Din[28] Dout1[28] Dout2[28] n288 n254 Sal_and_write[25]
+ n96 VSS VDD_1V8 latchtriestado_195
Xlatches1_25__latches2_27__latchesa Din[27] Dout1[27] Dout2[27] n288 n254 Sal_and_write[25]
+ n73 VSS VDD_1V8 latchtriestado_196
Xlatches1_25__latches2_26__latchesa Din[26] Dout1[26] Dout2[26] n288 n254 Sal_and_write[25]
+ n93 VSS VDD_1V8 latchtriestado_197
Xlatches1_25__latches2_25__latchesa Din[25] Dout1[25] Dout2[25] n288 n254 Sal_and_write[25]
+ n96 VSS VDD_1V8 latchtriestado_198
Xlatches1_25__latches2_24__latchesa Din[24] Dout1[24] Dout2[24] n288 n254 Sal_and_write[25]
+ n96 VSS VDD_1V8 latchtriestado_199
Xlatches1_25__latches2_23__latchesa Din[23] Dout1[23] Dout2[23] n288 n254 Sal_and_write[25]
+ n73 VSS VDD_1V8 latchtriestado_200
Xlatches1_25__latches2_22__latchesa Din[22] Dout1[22] Dout2[22] n288 n254 Sal_and_write[25]
+ n96 VSS VDD_1V8 latchtriestado_201
Xlatches1_25__latches2_21__latchesa Din[21] Dout1[21] Dout2[21] n288 n254 Sal_and_write[25]
+ n73 VSS VDD_1V8 latchtriestado_202
Xlatches1_25__latches2_20__latchesa Din[20] Dout1[20] Dout2[20] n288 n254 Sal_and_write[25]
+ IN94 VSS VDD_1V8 latchtriestado_203
Xlatches1_25__latches2_19__latchesa Din[19] Dout1[19] Dout2[19] n288 n254 Sal_and_write[25]
+ n93 VSS VDD_1V8 latchtriestado_204
Xlatches1_25__latches2_18__latchesa Din[18] Dout1[18] Dout2[18] n288 n254 Sal_and_write[25]
+ n94 VSS VDD_1V8 latchtriestado_205
Xlatches1_25__latches2_17__latchesa Din[17] Dout1[17] Dout2[17] n288 n254 Sal_and_write[25]
+ n5 VSS VDD_1V8 latchtriestado_206
Xlatches1_25__latches2_16__latchesa Din[16] Dout1[16] Dout2[16] n288 n254 Sal_and_write[25]
+ IN96 VSS VDD_1V8 latchtriestado_207
Xlatches1_25__latches2_15__latchesa Din[15] Dout1[15] Dout2[15] n288 n254 Sal_and_write[25]
+ n4 VSS VDD_1V8 latchtriestado_208
Xlatches1_25__latches2_14__latchesa Din[14] Dout1[14] Dout2[14] n288 n254 Sal_and_write[25]
+ n4 VSS VDD_1V8 latchtriestado_209
Xlatches1_25__latches2_13__latchesa Din[13] Dout1[13] Dout2[13] n288 n254 Sal_and_write[25]
+ IN66 VSS VDD_1V8 latchtriestado_210
Xlatches1_25__latches2_12__latchesa Din[12] Dout1[12] Dout2[12] n288 n254 Sal_and_write[25]
+ IN137 VSS VDD_1V8 latchtriestado_211
Xlatches1_25__latches2_11__latchesa Din[11] Dout1[11] Dout2[11] n288 n254 Sal_and_write[25]
+ IN16 VSS VDD_1V8 latchtriestado_212
Xlatches1_25__latches2_10__latchesa Din[10] Dout1[10] Dout2[10] n288 n254 Sal_and_write[25]
+ IN12 VSS VDD_1V8 latchtriestado_213
Xlatches1_25__latches2_9__latchesa Din[9] Dout1[9] Dout2[9] n288 n254 Sal_and_write[25]
+ IN24 VSS VDD_1V8 latchtriestado_214
Xlatches1_25__latches2_8__latchesa Din[8] Dout1[8] Dout2[8] n288 n254 Sal_and_write[25]
+ IN20 VSS VDD_1V8 latchtriestado_215
Xlatches1_25__latches2_7__latchesa Din[7] Dout1[7] Dout2[7] n288 n254 Sal_and_write[25]
+ IN27 VSS VDD_1V8 latchtriestado_216
Xlatches1_25__latches2_6__latchesa Din[6] Dout1[6] Dout2[6] n288 n254 Sal_and_write[25]
+ IN141 VSS VDD_1V8 latchtriestado_217
Xlatches1_25__latches2_5__latchesa Din[5] Dout1[5] Dout2[5] n288 n254 Sal_and_write[25]
+ n30 VSS VDD_1V8 latchtriestado_218
Xlatches1_25__latches2_4__latchesa Din[4] Dout1[4] Dout2[4] n288 n254 Sal_and_write[25]
+ n29 VSS VDD_1V8 latchtriestado_219
Xlatches1_25__latches2_3__latchesa Din[3] Dout1[3] Dout2[3] n288 n254 Sal_and_write[25]
+ n95 VSS VDD_1V8 latchtriestado_220
Xlatches1_25__latches2_2__latchesa Din[2] Dout1[2] Dout2[2] n288 n254 Sal_and_write[25]
+ n29 VSS VDD_1V8 latchtriestado_221
Xlatches1_25__latches2_1__latchesa Din[1] Dout1[1] Dout2[1] n288 n254 Sal_and_write[25]
+ IN75 VSS VDD_1V8 latchtriestado_222
Xlatches1_25__latches2_0__latchesa Din[0] Dout1[0] Dout2[0] n288 n254 Sal_and_write[25]
+ IN107 VSS VDD_1V8 latchtriestado_223
Xlatches1_24__latches2_31__latchesa Din[31] Dout1[31] Dout2[31] conect_deco_latch1[24]
+ conect_deco_latch2[24] CTS_CLK_CTO_delay361 n95 VSS VDD_1V8 latchtriestado_224
Xlatches1_24__latches2_30__latchesa Din[30] Dout1[30] Dout2[30] conect_deco_latch1[24]
+ conect_deco_latch2[24] CTS_CLK_CTO_delay361 IN44 VSS VDD_1V8 latchtriestado_225
Xlatches1_24__latches2_29__latchesa Din[29] Dout1[29] Dout2[29] conect_deco_latch1[24]
+ conect_deco_latch2[24] CTS_CLK_CTO_delay361 n93 VSS VDD_1V8 latchtriestado_226
Xlatches1_24__latches2_28__latchesa Din[28] Dout1[28] Dout2[28] conect_deco_latch1[24]
+ conect_deco_latch2[24] CTS_CLK_CTO_delay361 n93 VSS VDD_1V8 latchtriestado_227
Xlatches1_24__latches2_27__latchesa Din[27] Dout1[27] Dout2[27] conect_deco_latch1[24]
+ conect_deco_latch2[24] CTS_CLK_CTO_delay361 n93 VSS VDD_1V8 latchtriestado_228
Xlatches1_24__latches2_26__latchesa Din[26] Dout1[26] Dout2[26] conect_deco_latch1[24]
+ conect_deco_latch2[24] CTS_CLK_CTO_delay361 n73 VSS VDD_1V8 latchtriestado_229
Xlatches1_24__latches2_25__latchesa Din[25] Dout1[25] Dout2[25] conect_deco_latch1[24]
+ conect_deco_latch2[24] CTS_CLK_CTO_delay361 n73 VSS VDD_1V8 latchtriestado_230
Xlatches1_24__latches2_24__latchesa Din[24] Dout1[24] Dout2[24] conect_deco_latch1[24]
+ conect_deco_latch2[24] CTS_CLK_CTO_delay361 n93 VSS VDD_1V8 latchtriestado_231
Xlatches1_24__latches2_23__latchesa Din[23] Dout1[23] Dout2[23] conect_deco_latch1[24]
+ conect_deco_latch2[24] CTS_CLK_CTO_delay361 n93 VSS VDD_1V8 latchtriestado_232
Xlatches1_24__latches2_22__latchesa Din[22] Dout1[22] Dout2[22] conect_deco_latch1[24]
+ conect_deco_latch2[24] CTS_CLK_CTO_delay361 n73 VSS VDD_1V8 latchtriestado_233
Xlatches1_24__latches2_21__latchesa Din[21] Dout1[21] Dout2[21] conect_deco_latch1[24]
+ conect_deco_latch2[24] CTS_CLK_CTO_delay361 n93 VSS VDD_1V8 latchtriestado_234
Xlatches1_24__latches2_20__latchesa Din[20] Dout1[20] Dout2[20] conect_deco_latch1[24]
+ conect_deco_latch2[24] CTS_CLK_CTO_delay361 n95 VSS VDD_1V8 latchtriestado_235
Xlatches1_24__latches2_19__latchesa Din[19] Dout1[19] Dout2[19] conect_deco_latch1[24]
+ conect_deco_latch2[24] CTS_CLK_CTO_delay361 n93 VSS VDD_1V8 latchtriestado_236
Xlatches1_24__latches2_18__latchesa Din[18] Dout1[18] Dout2[18] conect_deco_latch1[24]
+ conect_deco_latch2[24] CTS_CLK_CTO_delay361 n95 VSS VDD_1V8 latchtriestado_237
Xlatches1_24__latches2_17__latchesa Din[17] Dout1[17] Dout2[17] conect_deco_latch1[24]
+ conect_deco_latch2[24] CTS_CLK_CTO_delay361 n95 VSS VDD_1V8 latchtriestado_238
Xlatches1_24__latches2_16__latchesa Din[16] Dout1[16] Dout2[16] conect_deco_latch1[24]
+ conect_deco_latch2[24] CTS_CLK_CTO_delay361 n95 VSS VDD_1V8 latchtriestado_239
Xlatches1_24__latches2_15__latchesa Din[15] Dout1[15] Dout2[15] conect_deco_latch1[24]
+ conect_deco_latch2[24] CTS_CLK_CTO_delay361 IN63 VSS VDD_1V8 latchtriestado_240
Xlatches1_24__latches2_14__latchesa Din[14] Dout1[14] Dout2[14] conect_deco_latch1[24]
+ conect_deco_latch2[24] CTS_CLK_CTO_delay361 IN55 VSS VDD_1V8 latchtriestado_241
Xlatches1_24__latches2_13__latchesa Din[13] Dout1[13] Dout2[13] conect_deco_latch1[24]
+ conect_deco_latch2[24] CTS_CLK_CTO_delay361 IN60 VSS VDD_1V8 latchtriestado_242
Xlatches1_24__latches2_12__latchesa Din[12] Dout1[12] Dout2[12] conect_deco_latch1[24]
+ conect_deco_latch2[24] CTS_CLK_CTO_delay361 IN11 VSS VDD_1V8 latchtriestado_243
Xlatches1_24__latches2_11__latchesa Din[11] Dout1[11] Dout2[11] conect_deco_latch1[24]
+ conect_deco_latch2[24] CTS_CLK_CTO_delay361 IN83 VSS VDD_1V8 latchtriestado_244
Xlatches1_24__latches2_10__latchesa Din[10] Dout1[10] Dout2[10] conect_deco_latch1[24]
+ conect_deco_latch2[24] CTS_CLK_CTO_delay361 IN82 VSS VDD_1V8 latchtriestado_245
Xlatches1_24__latches2_9__latchesa Din[9] Dout1[9] Dout2[9] conect_deco_latch1[24]
+ conect_deco_latch2[24] CTS_CLK_CTO_delay361 IN4 VSS VDD_1V8 latchtriestado_246
Xlatches1_24__latches2_8__latchesa Din[8] Dout1[8] Dout2[8] conect_deco_latch1[24]
+ conect_deco_latch2[24] CTS_CLK_CTO_delay361 IN21 VSS VDD_1V8 latchtriestado_247
Xlatches1_24__latches2_7__latchesa Din[7] Dout1[7] Dout2[7] conect_deco_latch1[24]
+ conect_deco_latch2[24] CTS_CLK_CTO_delay361 IN25 VSS VDD_1V8 latchtriestado_248
Xlatches1_24__latches2_6__latchesa Din[6] Dout1[6] Dout2[6] conect_deco_latch1[24]
+ conect_deco_latch2[24] CTS_CLK_CTO_delay361 IN22 VSS VDD_1V8 latchtriestado_249
Xlatches1_24__latches2_5__latchesa Din[5] Dout1[5] Dout2[5] conect_deco_latch1[24]
+ conect_deco_latch2[24] CTS_CLK_CTO_delay361 IN19 VSS VDD_1V8 latchtriestado_250
Xlatches1_24__latches2_4__latchesa Din[4] Dout1[4] Dout2[4] conect_deco_latch1[24]
+ conect_deco_latch2[24] CTS_CLK_CTO_delay361 IN45 VSS VDD_1V8 latchtriestado_251
Xlatches1_24__latches2_3__latchesa Din[3] Dout1[3] Dout2[3] conect_deco_latch1[24]
+ conect_deco_latch2[24] CTS_CLK_CTO_delay361 n95 VSS VDD_1V8 latchtriestado_252
Xlatches1_24__latches2_2__latchesa Din[2] Dout1[2] Dout2[2] conect_deco_latch1[24]
+ conect_deco_latch2[24] CTS_CLK_CTO_delay361 IN70 VSS VDD_1V8 latchtriestado_253
Xlatches1_24__latches2_1__latchesa Din[1] Dout1[1] Dout2[1] conect_deco_latch1[24]
+ conect_deco_latch2[24] CTS_CLK_CTO_delay361 IN80 VSS VDD_1V8 latchtriestado_254
Xlatches1_24__latches2_0__latchesa Din[0] Dout1[0] Dout2[0] conect_deco_latch1[24]
+ conect_deco_latch2[24] CTS_CLK_CTO_delay361 n95 VSS VDD_1V8 latchtriestado_255
Xlatches1_23__latches2_31__latchesa Din[31] Dout1[31] Dout2[31] n292 n257 Sal_and_write[23]
+ n95 VSS VDD_1V8 latchtriestado_256
Xlatches1_23__latches2_30__latchesa Din[30] Dout1[30] Dout2[30] n292 n257 Sal_and_write[23]
+ n29 VSS VDD_1V8 latchtriestado_257
Xlatches1_23__latches2_29__latchesa Din[29] Dout1[29] Dout2[29] n292 n257 Sal_and_write[23]
+ n73 VSS VDD_1V8 latchtriestado_258
Xlatches1_23__latches2_28__latchesa Din[28] Dout1[28] Dout2[28] n292 n257 Sal_and_write[23]
+ n73 VSS VDD_1V8 latchtriestado_259
Xlatches1_23__latches2_27__latchesa Din[27] Dout1[27] Dout2[27] n292 n257 Sal_and_write[23]
+ n73 VSS VDD_1V8 latchtriestado_260
Xlatches1_23__latches2_26__latchesa Din[26] Dout1[26] Dout2[26] n292 n257 Sal_and_write[23]
+ n73 VSS VDD_1V8 latchtriestado_261
Xlatches1_23__latches2_25__latchesa Din[25] Dout1[25] Dout2[25] n292 n257 Sal_and_write[23]
+ n73 VSS VDD_1V8 latchtriestado_262
Xlatches1_23__latches2_24__latchesa Din[24] Dout1[24] Dout2[24] n292 n257 Sal_and_write[23]
+ n73 VSS VDD_1V8 latchtriestado_263
Xlatches1_23__latches2_23__latchesa Din[23] Dout1[23] Dout2[23] n292 n257 Sal_and_write[23]
+ n128 VSS VDD_1V8 latchtriestado_264
Xlatches1_23__latches2_22__latchesa Din[22] Dout1[22] Dout2[22] n292 n257 Sal_and_write[23]
+ n73 VSS VDD_1V8 latchtriestado_265
Xlatches1_23__latches2_21__latchesa Din[21] Dout1[21] Dout2[21] n292 n257 Sal_and_write[23]
+ n128 VSS VDD_1V8 latchtriestado_266
Xlatches1_23__latches2_20__latchesa Din[20] Dout1[20] Dout2[20] n292 n257 Sal_and_write[23]
+ n5 VSS VDD_1V8 latchtriestado_267
Xlatches1_23__latches2_19__latchesa Din[19] Dout1[19] Dout2[19] n292 n257 Sal_and_write[23]
+ n128 VSS VDD_1V8 latchtriestado_268
Xlatches1_23__latches2_18__latchesa Din[18] Dout1[18] Dout2[18] n292 n257 Sal_and_write[23]
+ n95 VSS VDD_1V8 latchtriestado_269
Xlatches1_23__latches2_17__latchesa Din[17] Dout1[17] Dout2[17] n292 n257 Sal_and_write[23]
+ n95 VSS VDD_1V8 latchtriestado_270
Xlatches1_23__latches2_16__latchesa Din[16] Dout1[16] Dout2[16] n292 n257 Sal_and_write[23]
+ n95 VSS VDD_1V8 latchtriestado_271
Xlatches1_23__latches2_15__latchesa Din[15] Dout1[15] Dout2[15] n292 n257 Sal_and_write[23]
+ n218 VSS VDD_1V8 latchtriestado_272
Xlatches1_23__latches2_14__latchesa Din[14] Dout1[14] Dout2[14] n292 n257 Sal_and_write[23]
+ n218 VSS VDD_1V8 latchtriestado_273
Xlatches1_23__latches2_13__latchesa Din[13] Dout1[13] Dout2[13] n292 n257 Sal_and_write[23]
+ n218 VSS VDD_1V8 latchtriestado_274
Xlatches1_23__latches2_12__latchesa Din[12] Dout1[12] Dout2[12] n292 n257 Sal_and_write[23]
+ IN6 VSS VDD_1V8 latchtriestado_275
Xlatches1_23__latches2_11__latchesa Din[11] Dout1[11] Dout2[11] n292 n257 Sal_and_write[23]
+ n30 VSS VDD_1V8 latchtriestado_276
Xlatches1_23__latches2_10__latchesa Din[10] Dout1[10] Dout2[10] n292 n257 Sal_and_write[23]
+ n30 VSS VDD_1V8 latchtriestado_277
Xlatches1_23__latches2_9__latchesa Din[9] Dout1[9] Dout2[9] n292 n257 Sal_and_write[23]
+ n218 VSS VDD_1V8 latchtriestado_278
Xlatches1_23__latches2_8__latchesa Din[8] Dout1[8] Dout2[8] n292 n257 Sal_and_write[23]
+ IN14 VSS VDD_1V8 latchtriestado_279
Xlatches1_23__latches2_7__latchesa Din[7] Dout1[7] Dout2[7] n292 n257 Sal_and_write[23]
+ IN18 VSS VDD_1V8 latchtriestado_280
Xlatches1_23__latches2_6__latchesa Din[6] Dout1[6] Dout2[6] n292 n257 Sal_and_write[23]
+ IN7 VSS VDD_1V8 latchtriestado_281
Xlatches1_23__latches2_5__latchesa Din[5] Dout1[5] Dout2[5] n292 n257 Sal_and_write[23]
+ n30 VSS VDD_1V8 latchtriestado_282
Xlatches1_23__latches2_4__latchesa Din[4] Dout1[4] Dout2[4] n292 n257 Sal_and_write[23]
+ n29 VSS VDD_1V8 latchtriestado_283
Xlatches1_23__latches2_3__latchesa Din[3] Dout1[3] Dout2[3] n292 n257 Sal_and_write[23]
+ n73 VSS VDD_1V8 latchtriestado_284
Xlatches1_23__latches2_2__latchesa Din[2] Dout1[2] Dout2[2] n292 n257 Sal_and_write[23]
+ n29 VSS VDD_1V8 latchtriestado_285
Xlatches1_23__latches2_1__latchesa Din[1] Dout1[1] Dout2[1] n292 n257 Sal_and_write[23]
+ n218 VSS VDD_1V8 latchtriestado_286
Xlatches1_23__latches2_0__latchesa Din[0] Dout1[0] Dout2[0] n292 n257 Sal_and_write[23]
+ n218 VSS VDD_1V8 latchtriestado_287
Xlatches1_22__latches2_31__latchesa Din[31] Dout1[31] Dout2[31] n282 n274 Sal_and_write[22]
+ n126 VSS VDD_1V8 latchtriestado_288
Xlatches1_22__latches2_30__latchesa Din[30] Dout1[30] Dout2[30] n282 n274 Sal_and_write[22]
+ n30 VSS VDD_1V8 latchtriestado_289
Xlatches1_22__latches2_29__latchesa Din[29] Dout1[29] Dout2[29] n282 n274 Sal_and_write[22]
+ n94 VSS VDD_1V8 latchtriestado_290
Xlatches1_22__latches2_28__latchesa Din[28] Dout1[28] Dout2[28] n282 n274 Sal_and_write[22]
+ n95 VSS VDD_1V8 latchtriestado_291
Xlatches1_22__latches2_27__latchesa Din[27] Dout1[27] Dout2[27] n282 n274 Sal_and_write[22]
+ n5 VSS VDD_1V8 latchtriestado_292
Xlatches1_22__latches2_26__latchesa Din[26] Dout1[26] Dout2[26] n282 n274 Sal_and_write[22]
+ n94 VSS VDD_1V8 latchtriestado_293
Xlatches1_22__latches2_25__latchesa Din[25] Dout1[25] Dout2[25] n282 n274 Sal_and_write[22]
+ n94 VSS VDD_1V8 latchtriestado_294
Xlatches1_22__latches2_24__latchesa Din[24] Dout1[24] Dout2[24] n282 n274 Sal_and_write[22]
+ n5 VSS VDD_1V8 latchtriestado_295
Xlatches1_22__latches2_23__latchesa Din[23] Dout1[23] Dout2[23] n282 n274 Sal_and_write[22]
+ n127 VSS VDD_1V8 latchtriestado_296
Xlatches1_22__latches2_22__latchesa Din[22] Dout1[22] Dout2[22] n282 n274 Sal_and_write[22]
+ n126 VSS VDD_1V8 latchtriestado_297
Xlatches1_22__latches2_21__latchesa Din[21] Dout1[21] Dout2[21] n282 n274 Sal_and_write[22]
+ n127 VSS VDD_1V8 latchtriestado_298
Xlatches1_22__latches2_20__latchesa Din[20] Dout1[20] Dout2[20] n282 n274 Sal_and_write[22]
+ n5 VSS VDD_1V8 latchtriestado_299
Xlatches1_22__latches2_19__latchesa Din[19] Dout1[19] Dout2[19] n282 n274 Sal_and_write[22]
+ n94 VSS VDD_1V8 latchtriestado_300
Xlatches1_22__latches2_18__latchesa Din[18] Dout1[18] Dout2[18] n282 n274 Sal_and_write[22]
+ n127 VSS VDD_1V8 latchtriestado_301
Xlatches1_22__latches2_17__latchesa Din[17] Dout1[17] Dout2[17] n282 n274 Sal_and_write[22]
+ n127 VSS VDD_1V8 latchtriestado_302
Xlatches1_22__latches2_16__latchesa Din[16] Dout1[16] Dout2[16] n282 n274 Sal_and_write[22]
+ n4 VSS VDD_1V8 latchtriestado_303
Xlatches1_22__latches2_15__latchesa Din[15] Dout1[15] Dout2[15] n282 n274 Sal_and_write[22]
+ n4 VSS VDD_1V8 latchtriestado_304
Xlatches1_22__latches2_14__latchesa Din[14] Dout1[14] Dout2[14] n282 n274 Sal_and_write[22]
+ n29 VSS VDD_1V8 latchtriestado_305
Xlatches1_22__latches2_13__latchesa Din[13] Dout1[13] Dout2[13] n282 n274 Sal_and_write[22]
+ n4 VSS VDD_1V8 latchtriestado_306
Xlatches1_22__latches2_12__latchesa Din[12] Dout1[12] Dout2[12] n282 n274 Sal_and_write[22]
+ n129 VSS VDD_1V8 latchtriestado_307
Xlatches1_22__latches2_11__latchesa Din[11] Dout1[11] Dout2[11] n282 n274 Sal_and_write[22]
+ IN153 VSS VDD_1V8 latchtriestado_308
Xlatches1_22__latches2_10__latchesa Din[10] Dout1[10] Dout2[10] n282 n274 Sal_and_write[22]
+ IN152 VSS VDD_1V8 latchtriestado_309
Xlatches1_22__latches2_9__latchesa Din[9] Dout1[9] Dout2[9] n282 n274 Sal_and_write[22]
+ n30 VSS VDD_1V8 latchtriestado_310
Xlatches1_22__latches2_8__latchesa Din[8] Dout1[8] Dout2[8] n282 n274 Sal_and_write[22]
+ IN160 VSS VDD_1V8 latchtriestado_311
Xlatches1_22__latches2_7__latchesa Din[7] Dout1[7] Dout2[7] n282 n274 Sal_and_write[22]
+ IN167 VSS VDD_1V8 latchtriestado_312
Xlatches1_22__latches2_6__latchesa Din[6] Dout1[6] Dout2[6] n282 n274 Sal_and_write[22]
+ rst VSS VDD_1V8 latchtriestado_313
Xlatches1_22__latches2_5__latchesa Din[5] Dout1[5] Dout2[5] n282 n274 Sal_and_write[22]
+ n129 VSS VDD_1V8 latchtriestado_314
Xlatches1_22__latches2_4__latchesa Din[4] Dout1[4] Dout2[4] n282 n274 Sal_and_write[22]
+ n29 VSS VDD_1V8 latchtriestado_315
Xlatches1_22__latches2_3__latchesa Din[3] Dout1[3] Dout2[3] n282 n274 Sal_and_write[22]
+ n5 VSS VDD_1V8 latchtriestado_316
Xlatches1_22__latches2_2__latchesa Din[2] Dout1[2] Dout2[2] n282 n274 Sal_and_write[22]
+ n29 VSS VDD_1V8 latchtriestado_317
Xlatches1_22__latches2_1__latchesa Din[1] Dout1[1] Dout2[1] n282 n274 Sal_and_write[22]
+ n129 VSS VDD_1V8 latchtriestado_318
Xlatches1_22__latches2_0__latchesa Din[0] Dout1[0] Dout2[0] n282 n274 Sal_and_write[22]
+ n94 VSS VDD_1V8 latchtriestado_319
Xlatches1_21__latches2_31__latchesa Din[31] Dout1[31] Dout2[31] n304 n270 Sal_and_write[21]
+ n127 VSS VDD_1V8 latchtriestado_320
Xlatches1_21__latches2_30__latchesa Din[30] Dout1[30] Dout2[30] n304 n270 Sal_and_write[21]
+ n4 VSS VDD_1V8 latchtriestado_321
Xlatches1_21__latches2_29__latchesa Din[29] Dout1[29] Dout2[29] n304 n270 Sal_and_write[21]
+ n94 VSS VDD_1V8 latchtriestado_322
Xlatches1_21__latches2_28__latchesa Din[28] Dout1[28] Dout2[28] n304 n270 Sal_and_write[21]
+ n93 VSS VDD_1V8 latchtriestado_323
Xlatches1_21__latches2_27__latchesa Din[27] Dout1[27] Dout2[27] n304 n270 Sal_and_write[21]
+ n128 VSS VDD_1V8 latchtriestado_324
Xlatches1_21__latches2_26__latchesa Din[26] Dout1[26] Dout2[26] n304 n270 Sal_and_write[21]
+ n93 VSS VDD_1V8 latchtriestado_325
Xlatches1_21__latches2_25__latchesa Din[25] Dout1[25] Dout2[25] n304 n270 Sal_and_write[21]
+ n93 VSS VDD_1V8 latchtriestado_326
Xlatches1_21__latches2_24__latchesa Din[24] Dout1[24] Dout2[24] n304 n270 Sal_and_write[21]
+ n93 VSS VDD_1V8 latchtriestado_327
Xlatches1_21__latches2_23__latchesa Din[23] Dout1[23] Dout2[23] n304 n270 Sal_and_write[21]
+ n74 VSS VDD_1V8 latchtriestado_328
Xlatches1_21__latches2_22__latchesa Din[22] Dout1[22] Dout2[22] n304 n270 Sal_and_write[21]
+ n74 VSS VDD_1V8 latchtriestado_329
Xlatches1_21__latches2_21__latchesa Din[21] Dout1[21] Dout2[21] n304 n270 Sal_and_write[21]
+ n74 VSS VDD_1V8 latchtriestado_330
Xlatches1_21__latches2_20__latchesa Din[20] Dout1[20] Dout2[20] n304 n270 Sal_and_write[21]
+ n5 VSS VDD_1V8 latchtriestado_331
Xlatches1_21__latches2_19__latchesa Din[19] Dout1[19] Dout2[19] n304 n270 Sal_and_write[21]
+ n93 VSS VDD_1V8 latchtriestado_332
Xlatches1_21__latches2_18__latchesa Din[18] Dout1[18] Dout2[18] n304 n270 Sal_and_write[21]
+ n127 VSS VDD_1V8 latchtriestado_333
Xlatches1_21__latches2_17__latchesa Din[17] Dout1[17] Dout2[17] n304 n270 Sal_and_write[21]
+ n5 VSS VDD_1V8 latchtriestado_334
Xlatches1_21__latches2_16__latchesa Din[16] Dout1[16] Dout2[16] n304 n270 Sal_and_write[21]
+ IN99 VSS VDD_1V8 latchtriestado_335
Xlatches1_21__latches2_15__latchesa Din[15] Dout1[15] Dout2[15] n304 n270 Sal_and_write[21]
+ n218 VSS VDD_1V8 latchtriestado_336
Xlatches1_21__latches2_14__latchesa Din[14] Dout1[14] Dout2[14] n304 n270 Sal_and_write[21]
+ n4 VSS VDD_1V8 latchtriestado_337
Xlatches1_21__latches2_13__latchesa Din[13] Dout1[13] Dout2[13] n304 n270 Sal_and_write[21]
+ IN54 VSS VDD_1V8 latchtriestado_338
Xlatches1_21__latches2_12__latchesa Din[12] Dout1[12] Dout2[12] n304 n270 Sal_and_write[21]
+ n30 VSS VDD_1V8 latchtriestado_339
Xlatches1_21__latches2_11__latchesa Din[11] Dout1[11] Dout2[11] n304 n270 Sal_and_write[21]
+ n30 VSS VDD_1V8 latchtriestado_340
Xlatches1_21__latches2_10__latchesa Din[10] Dout1[10] Dout2[10] n304 n270 Sal_and_write[21]
+ IN10 VSS VDD_1V8 latchtriestado_341
Xlatches1_21__latches2_9__latchesa Din[9] Dout1[9] Dout2[9] n304 n270 Sal_and_write[21]
+ n130 VSS VDD_1V8 latchtriestado_342
Xlatches1_21__latches2_8__latchesa Din[8] Dout1[8] Dout2[8] n304 n270 Sal_and_write[21]
+ n30 VSS VDD_1V8 latchtriestado_343
Xlatches1_21__latches2_7__latchesa Din[7] Dout1[7] Dout2[7] n304 n270 Sal_and_write[21]
+ n130 VSS VDD_1V8 latchtriestado_344
Xlatches1_21__latches2_6__latchesa Din[6] Dout1[6] Dout2[6] n304 n270 Sal_and_write[21]
+ n30 VSS VDD_1V8 latchtriestado_345
Xlatches1_21__latches2_5__latchesa Din[5] Dout1[5] Dout2[5] n304 n270 Sal_and_write[21]
+ n30 VSS VDD_1V8 latchtriestado_346
Xlatches1_21__latches2_4__latchesa Din[4] Dout1[4] Dout2[4] n304 n270 Sal_and_write[21]
+ n218 VSS VDD_1V8 latchtriestado_347
Xlatches1_21__latches2_3__latchesa Din[3] Dout1[3] Dout2[3] n304 n270 Sal_and_write[21]
+ n5 VSS VDD_1V8 latchtriestado_348
Xlatches1_21__latches2_2__latchesa Din[2] Dout1[2] Dout2[2] n304 n270 Sal_and_write[21]
+ n218 VSS VDD_1V8 latchtriestado_349
Xlatches1_21__latches2_1__latchesa Din[1] Dout1[1] Dout2[1] n304 n270 Sal_and_write[21]
+ n218 VSS VDD_1V8 latchtriestado_350
Xlatches1_21__latches2_0__latchesa Din[0] Dout1[0] Dout2[0] n304 n270 Sal_and_write[21]
+ n4 VSS VDD_1V8 latchtriestado_351
Xlatches1_20__latches2_31__latchesa Din[31] Dout1[31] Dout2[31] n305 n271 Sal_and_write[20]
+ n95 VSS VDD_1V8 latchtriestado_352
Xlatches1_20__latches2_30__latchesa Din[30] Dout1[30] Dout2[30] n305 n271 Sal_and_write[20]
+ IN69 VSS VDD_1V8 latchtriestado_353
Xlatches1_20__latches2_29__latchesa Din[29] Dout1[29] Dout2[29] n305 n271 Sal_and_write[20]
+ n128 VSS VDD_1V8 latchtriestado_354
Xlatches1_20__latches2_28__latchesa Din[28] Dout1[28] Dout2[28] n305 n271 Sal_and_write[20]
+ n93 VSS VDD_1V8 latchtriestado_355
Xlatches1_20__latches2_27__latchesa Din[27] Dout1[27] Dout2[27] n305 n271 Sal_and_write[20]
+ n74 VSS VDD_1V8 latchtriestado_356
Xlatches1_20__latches2_26__latchesa Din[26] Dout1[26] Dout2[26] n305 n271 Sal_and_write[20]
+ n93 VSS VDD_1V8 latchtriestado_357
Xlatches1_20__latches2_25__latchesa Din[25] Dout1[25] Dout2[25] n305 n271 Sal_and_write[20]
+ n93 VSS VDD_1V8 latchtriestado_358
Xlatches1_20__latches2_24__latchesa Din[24] Dout1[24] Dout2[24] n305 n271 Sal_and_write[20]
+ n73 VSS VDD_1V8 latchtriestado_359
Xlatches1_20__latches2_23__latchesa Din[23] Dout1[23] Dout2[23] n305 n271 Sal_and_write[20]
+ n73 VSS VDD_1V8 latchtriestado_360
Xlatches1_20__latches2_22__latchesa Din[22] Dout1[22] Dout2[22] n305 n271 Sal_and_write[20]
+ n73 VSS VDD_1V8 latchtriestado_361
Xlatches1_20__latches2_21__latchesa Din[21] Dout1[21] Dout2[21] n305 n271 Sal_and_write[20]
+ n5 VSS VDD_1V8 latchtriestado_362
Xlatches1_20__latches2_20__latchesa Din[20] Dout1[20] Dout2[20] n305 n271 Sal_and_write[20]
+ n5 VSS VDD_1V8 latchtriestado_363
Xlatches1_20__latches2_19__latchesa Din[19] Dout1[19] Dout2[19] n305 n271 Sal_and_write[20]
+ n94 VSS VDD_1V8 latchtriestado_364
Xlatches1_20__latches2_18__latchesa Din[18] Dout1[18] Dout2[18] n305 n271 Sal_and_write[20]
+ n94 VSS VDD_1V8 latchtriestado_365
Xlatches1_20__latches2_17__latchesa Din[17] Dout1[17] Dout2[17] n305 n271 Sal_and_write[20]
+ n127 VSS VDD_1V8 latchtriestado_366
Xlatches1_20__latches2_16__latchesa Din[16] Dout1[16] Dout2[16] n305 n271 Sal_and_write[20]
+ n94 VSS VDD_1V8 latchtriestado_367
Xlatches1_20__latches2_15__latchesa Din[15] Dout1[15] Dout2[15] n305 n271 Sal_and_write[20]
+ n29 VSS VDD_1V8 latchtriestado_368
Xlatches1_20__latches2_14__latchesa Din[14] Dout1[14] Dout2[14] n305 n271 Sal_and_write[20]
+ IN48 VSS VDD_1V8 latchtriestado_369
Xlatches1_20__latches2_13__latchesa Din[13] Dout1[13] Dout2[13] n305 n271 Sal_and_write[20]
+ IN43 VSS VDD_1V8 latchtriestado_370
Xlatches1_20__latches2_12__latchesa Din[12] Dout1[12] Dout2[12] n305 n271 Sal_and_write[20]
+ n129 VSS VDD_1V8 latchtriestado_371
Xlatches1_20__latches2_11__latchesa Din[11] Dout1[11] Dout2[11] n305 n271 Sal_and_write[20]
+ rst VSS VDD_1V8 latchtriestado_372
Xlatches1_20__latches2_10__latchesa Din[10] Dout1[10] Dout2[10] n305 n271 Sal_and_write[20]
+ IN168 VSS VDD_1V8 latchtriestado_373
Xlatches1_20__latches2_9__latchesa Din[9] Dout1[9] Dout2[9] n305 n271 Sal_and_write[20]
+ n130 VSS VDD_1V8 latchtriestado_374
Xlatches1_20__latches2_8__latchesa Din[8] Dout1[8] Dout2[8] n305 n271 Sal_and_write[20]
+ n129 VSS VDD_1V8 latchtriestado_375
Xlatches1_20__latches2_7__latchesa Din[7] Dout1[7] Dout2[7] n305 n271 Sal_and_write[20]
+ n129 VSS VDD_1V8 latchtriestado_376
Xlatches1_20__latches2_6__latchesa Din[6] Dout1[6] Dout2[6] n305 n271 Sal_and_write[20]
+ n129 VSS VDD_1V8 latchtriestado_377
Xlatches1_20__latches2_5__latchesa Din[5] Dout1[5] Dout2[5] n305 n271 Sal_and_write[20]
+ n129 VSS VDD_1V8 latchtriestado_378
Xlatches1_20__latches2_4__latchesa Din[4] Dout1[4] Dout2[4] n305 n271 Sal_and_write[20]
+ n75 VSS VDD_1V8 latchtriestado_379
Xlatches1_20__latches2_3__latchesa Din[3] Dout1[3] Dout2[3] n305 n271 Sal_and_write[20]
+ n128 VSS VDD_1V8 latchtriestado_380
Xlatches1_20__latches2_2__latchesa Din[2] Dout1[2] Dout2[2] n305 n271 Sal_and_write[20]
+ n75 VSS VDD_1V8 latchtriestado_381
Xlatches1_20__latches2_1__latchesa Din[1] Dout1[1] Dout2[1] n305 n271 Sal_and_write[20]
+ n75 VSS VDD_1V8 latchtriestado_382
Xlatches1_20__latches2_0__latchesa Din[0] Dout1[0] Dout2[0] n305 n271 Sal_and_write[20]
+ n126 VSS VDD_1V8 latchtriestado_383
Xlatches1_19__latches2_31__latchesa Din[31] Dout1[31] Dout2[31] n280 n272 CTS_CLK_CTO_delay281
+ IN102 VSS VDD_1V8 latchtriestado_384
Xlatches1_19__latches2_30__latchesa Din[30] Dout1[30] Dout2[30] n280 n272 CTS_CLK_CTO_delay281
+ n130 VSS VDD_1V8 latchtriestado_385
Xlatches1_19__latches2_29__latchesa Din[29] Dout1[29] Dout2[29] n280 n272 CTS_CLK_CTO_delay281
+ n126 VSS VDD_1V8 latchtriestado_386
Xlatches1_19__latches2_28__latchesa Din[28] Dout1[28] Dout2[28] n280 n272 CTS_CLK_CTO_delay281
+ n4 VSS VDD_1V8 latchtriestado_387
Xlatches1_19__latches2_27__latchesa Din[27] Dout1[27] Dout2[27] n280 n272 CTS_CLK_CTO_delay281
+ n4 VSS VDD_1V8 latchtriestado_388
Xlatches1_19__latches2_26__latchesa Din[26] Dout1[26] Dout2[26] n280 n272 CTS_CLK_CTO_delay281
+ n94 VSS VDD_1V8 latchtriestado_389
Xlatches1_19__latches2_25__latchesa Din[25] Dout1[25] Dout2[25] n280 n272 CTS_CLK_CTO_delay281
+ n95 VSS VDD_1V8 latchtriestado_390
Xlatches1_19__latches2_24__latchesa Din[24] Dout1[24] Dout2[24] n280 n272 CTS_CLK_CTO_delay281
+ n126 VSS VDD_1V8 latchtriestado_391
Xlatches1_19__latches2_23__latchesa Din[23] Dout1[23] Dout2[23] n280 n272 CTS_CLK_CTO_delay281
+ n127 VSS VDD_1V8 latchtriestado_392
Xlatches1_19__latches2_22__latchesa Din[22] Dout1[22] Dout2[22] n280 n272 CTS_CLK_CTO_delay281
+ n126 VSS VDD_1V8 latchtriestado_393
Xlatches1_19__latches2_21__latchesa Din[21] Dout1[21] Dout2[21] n280 n272 CTS_CLK_CTO_delay281
+ n126 VSS VDD_1V8 latchtriestado_394
Xlatches1_19__latches2_20__latchesa Din[20] Dout1[20] Dout2[20] n280 n272 CTS_CLK_CTO_delay281
+ n95 VSS VDD_1V8 latchtriestado_395
Xlatches1_19__latches2_19__latchesa Din[19] Dout1[19] Dout2[19] n280 n272 CTS_CLK_CTO_delay281
+ n5 VSS VDD_1V8 latchtriestado_396
Xlatches1_19__latches2_18__latchesa Din[18] Dout1[18] Dout2[18] n280 n272 CTS_CLK_CTO_delay281
+ n94 VSS VDD_1V8 latchtriestado_397
Xlatches1_19__latches2_17__latchesa Din[17] Dout1[17] Dout2[17] n280 n272 CTS_CLK_CTO_delay281
+ n126 VSS VDD_1V8 latchtriestado_398
Xlatches1_19__latches2_16__latchesa Din[16] Dout1[16] Dout2[16] n280 n272 CTS_CLK_CTO_delay281
+ n4 VSS VDD_1V8 latchtriestado_399
Xlatches1_19__latches2_15__latchesa Din[15] Dout1[15] Dout2[15] n280 n272 CTS_CLK_CTO_delay281
+ n29 VSS VDD_1V8 latchtriestado_400
Xlatches1_19__latches2_14__latchesa Din[14] Dout1[14] Dout2[14] n280 n272 CTS_CLK_CTO_delay281
+ n29 VSS VDD_1V8 latchtriestado_401
Xlatches1_19__latches2_13__latchesa Din[13] Dout1[13] Dout2[13] n280 n272 CTS_CLK_CTO_delay281
+ IN56 VSS VDD_1V8 latchtriestado_402
Xlatches1_19__latches2_12__latchesa Din[12] Dout1[12] Dout2[12] n280 n272 CTS_CLK_CTO_delay281
+ n129 VSS VDD_1V8 latchtriestado_403
Xlatches1_19__latches2_11__latchesa Din[11] Dout1[11] Dout2[11] n280 n272 CTS_CLK_CTO_delay281
+ IN155 VSS VDD_1V8 latchtriestado_404
Xlatches1_19__latches2_10__latchesa Din[10] Dout1[10] Dout2[10] n280 n272 CTS_CLK_CTO_delay281
+ IN149 VSS VDD_1V8 latchtriestado_405
Xlatches1_19__latches2_9__latchesa Din[9] Dout1[9] Dout2[9] n280 n272 CTS_CLK_CTO_delay281
+ n130 VSS VDD_1V8 latchtriestado_406
Xlatches1_19__latches2_8__latchesa Din[8] Dout1[8] Dout2[8] n280 n272 CTS_CLK_CTO_delay281
+ n129 VSS VDD_1V8 latchtriestado_407
Xlatches1_19__latches2_7__latchesa Din[7] Dout1[7] Dout2[7] n280 n272 CTS_CLK_CTO_delay281
+ n129 VSS VDD_1V8 latchtriestado_408
Xlatches1_19__latches2_6__latchesa Din[6] Dout1[6] Dout2[6] n280 n272 CTS_CLK_CTO_delay281
+ n129 VSS VDD_1V8 latchtriestado_409
Xlatches1_19__latches2_5__latchesa Din[5] Dout1[5] Dout2[5] n280 n272 CTS_CLK_CTO_delay281
+ IN157 VSS VDD_1V8 latchtriestado_410
Xlatches1_19__latches2_4__latchesa Din[4] Dout1[4] Dout2[4] n280 n272 CTS_CLK_CTO_delay281
+ n75 VSS VDD_1V8 latchtriestado_411
Xlatches1_19__latches2_3__latchesa Din[3] Dout1[3] Dout2[3] n280 n272 CTS_CLK_CTO_delay281
+ n4 VSS VDD_1V8 latchtriestado_412
Xlatches1_19__latches2_2__latchesa Din[2] Dout1[2] Dout2[2] n280 n272 CTS_CLK_CTO_delay281
+ n130 VSS VDD_1V8 latchtriestado_413
Xlatches1_19__latches2_1__latchesa Din[1] Dout1[1] Dout2[1] n280 n272 CTS_CLK_CTO_delay281
+ n129 VSS VDD_1V8 latchtriestado_414
Xlatches1_19__latches2_0__latchesa Din[0] Dout1[0] Dout2[0] n280 n272 CTS_CLK_CTO_delay281
+ n4 VSS VDD_1V8 latchtriestado_415
Xlatches1_18__latches2_31__latchesa Din[31] Dout1[31] Dout2[31] n281 n273 CTS_CLK_CTO_delay181
+ n94 VSS VDD_1V8 latchtriestado_416
Xlatches1_18__latches2_30__latchesa Din[30] Dout1[30] Dout2[30] n281 n273 CTS_CLK_CTO_delay181
+ IN113 VSS VDD_1V8 latchtriestado_417
Xlatches1_18__latches2_29__latchesa Din[29] Dout1[29] Dout2[29] n281 n273 CTS_CLK_CTO_delay181
+ n94 VSS VDD_1V8 latchtriestado_418
Xlatches1_18__latches2_28__latchesa Din[28] Dout1[28] Dout2[28] n281 n273 CTS_CLK_CTO_delay181
+ n73 VSS VDD_1V8 latchtriestado_419
Xlatches1_18__latches2_27__latchesa Din[27] Dout1[27] Dout2[27] n281 n273 CTS_CLK_CTO_delay181
+ n128 VSS VDD_1V8 latchtriestado_420
Xlatches1_18__latches2_26__latchesa Din[26] Dout1[26] Dout2[26] n281 n273 CTS_CLK_CTO_delay181
+ n73 VSS VDD_1V8 latchtriestado_421
Xlatches1_18__latches2_25__latchesa Din[25] Dout1[25] Dout2[25] n281 n273 CTS_CLK_CTO_delay181
+ n128 VSS VDD_1V8 latchtriestado_422
Xlatches1_18__latches2_24__latchesa Din[24] Dout1[24] Dout2[24] n281 n273 CTS_CLK_CTO_delay181
+ n96 VSS VDD_1V8 latchtriestado_423
Xlatches1_18__latches2_23__latchesa Din[23] Dout1[23] Dout2[23] n281 n273 CTS_CLK_CTO_delay181
+ n96 VSS VDD_1V8 latchtriestado_424
Xlatches1_18__latches2_22__latchesa Din[22] Dout1[22] Dout2[22] n281 n273 CTS_CLK_CTO_delay181
+ n128 VSS VDD_1V8 latchtriestado_425
Xlatches1_18__latches2_21__latchesa Din[21] Dout1[21] Dout2[21] n281 n273 CTS_CLK_CTO_delay181
+ n128 VSS VDD_1V8 latchtriestado_426
Xlatches1_18__latches2_20__latchesa Din[20] Dout1[20] Dout2[20] n281 n273 CTS_CLK_CTO_delay181
+ IN98 VSS VDD_1V8 latchtriestado_427
Xlatches1_18__latches2_19__latchesa Din[19] Dout1[19] Dout2[19] n281 n273 CTS_CLK_CTO_delay181
+ n94 VSS VDD_1V8 latchtriestado_428
Xlatches1_18__latches2_18__latchesa Din[18] Dout1[18] Dout2[18] n281 n273 CTS_CLK_CTO_delay181
+ IN91 VSS VDD_1V8 latchtriestado_429
Xlatches1_18__latches2_17__latchesa Din[17] Dout1[17] Dout2[17] n281 n273 CTS_CLK_CTO_delay181
+ n95 VSS VDD_1V8 latchtriestado_430
Xlatches1_18__latches2_16__latchesa Din[16] Dout1[16] Dout2[16] n281 n273 CTS_CLK_CTO_delay181
+ IN93 VSS VDD_1V8 latchtriestado_431
Xlatches1_18__latches2_15__latchesa Din[15] Dout1[15] Dout2[15] n281 n273 CTS_CLK_CTO_delay181
+ n29 VSS VDD_1V8 latchtriestado_432
Xlatches1_18__latches2_14__latchesa Din[14] Dout1[14] Dout2[14] n281 n273 CTS_CLK_CTO_delay181
+ n4 VSS VDD_1V8 latchtriestado_433
Xlatches1_18__latches2_13__latchesa Din[13] Dout1[13] Dout2[13] n281 n273 CTS_CLK_CTO_delay181
+ n4 VSS VDD_1V8 latchtriestado_434
Xlatches1_18__latches2_12__latchesa Din[12] Dout1[12] Dout2[12] n281 n273 CTS_CLK_CTO_delay181
+ n130 VSS VDD_1V8 latchtriestado_435
Xlatches1_18__latches2_11__latchesa Din[11] Dout1[11] Dout2[11] n281 n273 CTS_CLK_CTO_delay181
+ n30 VSS VDD_1V8 latchtriestado_436
Xlatches1_18__latches2_10__latchesa Din[10] Dout1[10] Dout2[10] n281 n273 CTS_CLK_CTO_delay181
+ n29 VSS VDD_1V8 latchtriestado_437
Xlatches1_18__latches2_9__latchesa Din[9] Dout1[9] Dout2[9] n281 n273 CTS_CLK_CTO_delay181
+ n130 VSS VDD_1V8 latchtriestado_438
Xlatches1_18__latches2_8__latchesa Din[8] Dout1[8] Dout2[8] n281 n273 CTS_CLK_CTO_delay181
+ n130 VSS VDD_1V8 latchtriestado_439
Xlatches1_18__latches2_7__latchesa Din[7] Dout1[7] Dout2[7] n281 n273 CTS_CLK_CTO_delay181
+ n130 VSS VDD_1V8 latchtriestado_440
Xlatches1_18__latches2_6__latchesa Din[6] Dout1[6] Dout2[6] n281 n273 CTS_CLK_CTO_delay181
+ n130 VSS VDD_1V8 latchtriestado_441
Xlatches1_18__latches2_5__latchesa Din[5] Dout1[5] Dout2[5] n281 n273 CTS_CLK_CTO_delay181
+ n130 VSS VDD_1V8 latchtriestado_442
Xlatches1_18__latches2_4__latchesa Din[4] Dout1[4] Dout2[4] n281 n273 CTS_CLK_CTO_delay181
+ n75 VSS VDD_1V8 latchtriestado_443
Xlatches1_18__latches2_3__latchesa Din[3] Dout1[3] Dout2[3] n281 n273 CTS_CLK_CTO_delay181
+ n73 VSS VDD_1V8 latchtriestado_444
Xlatches1_18__latches2_2__latchesa Din[2] Dout1[2] Dout2[2] n281 n273 CTS_CLK_CTO_delay181
+ n130 VSS VDD_1V8 latchtriestado_445
Xlatches1_18__latches2_1__latchesa Din[1] Dout1[1] Dout2[1] n281 n273 CTS_CLK_CTO_delay181
+ n130 VSS VDD_1V8 latchtriestado_446
Xlatches1_18__latches2_0__latchesa Din[0] Dout1[0] Dout2[0] n281 n273 CTS_CLK_CTO_delay181
+ n4 VSS VDD_1V8 latchtriestado_447
Xlatches1_17__latches2_31__latchesa Din[31] Dout1[31] Dout2[31] n286 n278 CTS_CLK_CTO_delay301
+ n74 VSS VDD_1V8 latchtriestado_448
Xlatches1_17__latches2_30__latchesa Din[30] Dout1[30] Dout2[30] n286 n278 CTS_CLK_CTO_delay301
+ n75 VSS VDD_1V8 latchtriestado_449
Xlatches1_17__latches2_29__latchesa Din[29] Dout1[29] Dout2[29] n286 n278 CTS_CLK_CTO_delay301
+ n74 VSS VDD_1V8 latchtriestado_450
Xlatches1_17__latches2_28__latchesa Din[28] Dout1[28] Dout2[28] n286 n278 CTS_CLK_CTO_delay301
+ n73 VSS VDD_1V8 latchtriestado_451
Xlatches1_17__latches2_27__latchesa Din[27] Dout1[27] Dout2[27] n286 n278 CTS_CLK_CTO_delay301
+ n74 VSS VDD_1V8 latchtriestado_452
Xlatches1_17__latches2_26__latchesa Din[26] Dout1[26] Dout2[26] n286 n278 CTS_CLK_CTO_delay301
+ n128 VSS VDD_1V8 latchtriestado_453
Xlatches1_17__latches2_25__latchesa Din[25] Dout1[25] Dout2[25] n286 n278 CTS_CLK_CTO_delay301
+ n128 VSS VDD_1V8 latchtriestado_454
Xlatches1_17__latches2_24__latchesa Din[24] Dout1[24] Dout2[24] n286 n278 CTS_CLK_CTO_delay301
+ n74 VSS VDD_1V8 latchtriestado_455
Xlatches1_17__latches2_23__latchesa Din[23] Dout1[23] Dout2[23] n286 n278 CTS_CLK_CTO_delay301
+ n74 VSS VDD_1V8 latchtriestado_456
Xlatches1_17__latches2_22__latchesa Din[22] Dout1[22] Dout2[22] n286 n278 CTS_CLK_CTO_delay301
+ n74 VSS VDD_1V8 latchtriestado_457
Xlatches1_17__latches2_21__latchesa Din[21] Dout1[21] Dout2[21] n286 n278 CTS_CLK_CTO_delay301
+ n74 VSS VDD_1V8 latchtriestado_458
Xlatches1_17__latches2_20__latchesa Din[20] Dout1[20] Dout2[20] n286 n278 CTS_CLK_CTO_delay301
+ n5 VSS VDD_1V8 latchtriestado_459
Xlatches1_17__latches2_19__latchesa Din[19] Dout1[19] Dout2[19] n286 n278 CTS_CLK_CTO_delay301
+ n128 VSS VDD_1V8 latchtriestado_460
Xlatches1_17__latches2_18__latchesa Din[18] Dout1[18] Dout2[18] n286 n278 CTS_CLK_CTO_delay301
+ n5 VSS VDD_1V8 latchtriestado_461
Xlatches1_17__latches2_17__latchesa Din[17] Dout1[17] Dout2[17] n286 n278 CTS_CLK_CTO_delay301
+ n5 VSS VDD_1V8 latchtriestado_462
Xlatches1_17__latches2_16__latchesa Din[16] Dout1[16] Dout2[16] n286 n278 CTS_CLK_CTO_delay301
+ n5 VSS VDD_1V8 latchtriestado_463
Xlatches1_17__latches2_15__latchesa Din[15] Dout1[15] Dout2[15] n286 n278 CTS_CLK_CTO_delay301
+ n218 VSS VDD_1V8 latchtriestado_464
Xlatches1_17__latches2_14__latchesa Din[14] Dout1[14] Dout2[14] n286 n278 CTS_CLK_CTO_delay301
+ n218 VSS VDD_1V8 latchtriestado_465
Xlatches1_17__latches2_13__latchesa Din[13] Dout1[13] Dout2[13] n286 n278 CTS_CLK_CTO_delay301
+ n218 VSS VDD_1V8 latchtriestado_466
Xlatches1_17__latches2_12__latchesa Din[12] Dout1[12] Dout2[12] n286 n278 CTS_CLK_CTO_delay301
+ n130 VSS VDD_1V8 latchtriestado_467
Xlatches1_17__latches2_11__latchesa Din[11] Dout1[11] Dout2[11] n286 n278 CTS_CLK_CTO_delay301
+ n30 VSS VDD_1V8 latchtriestado_468
Xlatches1_17__latches2_10__latchesa Din[10] Dout1[10] Dout2[10] n286 n278 CTS_CLK_CTO_delay301
+ n30 VSS VDD_1V8 latchtriestado_469
Xlatches1_17__latches2_9__latchesa Din[9] Dout1[9] Dout2[9] n286 n278 CTS_CLK_CTO_delay301
+ n130 VSS VDD_1V8 latchtriestado_470
Xlatches1_17__latches2_8__latchesa Din[8] Dout1[8] Dout2[8] n286 n278 CTS_CLK_CTO_delay301
+ n30 VSS VDD_1V8 latchtriestado_471
Xlatches1_17__latches2_7__latchesa Din[7] Dout1[7] Dout2[7] n286 n278 CTS_CLK_CTO_delay301
+ n30 VSS VDD_1V8 latchtriestado_472
Xlatches1_17__latches2_6__latchesa Din[6] Dout1[6] Dout2[6] n286 n278 CTS_CLK_CTO_delay301
+ n130 VSS VDD_1V8 latchtriestado_473
Xlatches1_17__latches2_5__latchesa Din[5] Dout1[5] Dout2[5] n286 n278 CTS_CLK_CTO_delay301
+ n30 VSS VDD_1V8 latchtriestado_474
Xlatches1_17__latches2_4__latchesa Din[4] Dout1[4] Dout2[4] n286 n278 CTS_CLK_CTO_delay301
+ n75 VSS VDD_1V8 latchtriestado_475
Xlatches1_17__latches2_3__latchesa Din[3] Dout1[3] Dout2[3] n286 n278 CTS_CLK_CTO_delay301
+ n128 VSS VDD_1V8 latchtriestado_476
Xlatches1_17__latches2_2__latchesa Din[2] Dout1[2] Dout2[2] n286 n278 CTS_CLK_CTO_delay301
+ n130 VSS VDD_1V8 latchtriestado_477
Xlatches1_17__latches2_1__latchesa Din[1] Dout1[1] Dout2[1] n286 n278 CTS_CLK_CTO_delay301
+ n75 VSS VDD_1V8 latchtriestado_478
Xlatches1_17__latches2_0__latchesa Din[0] Dout1[0] Dout2[0] n286 n278 CTS_CLK_CTO_delay301
+ n126 VSS VDD_1V8 latchtriestado_479
Xlatches1_16__latches2_31__latchesa Din[31] Dout1[31] Dout2[31] n287 n279 Sal_and_write[16]
+ n126 VSS VDD_1V8 latchtriestado_480
Xlatches1_16__latches2_30__latchesa Din[30] Dout1[30] Dout2[30] n287 n279 Sal_and_write[16]
+ n75 VSS VDD_1V8 latchtriestado_481
Xlatches1_16__latches2_29__latchesa Din[29] Dout1[29] Dout2[29] n287 n279 Sal_and_write[16]
+ n74 VSS VDD_1V8 latchtriestado_482
Xlatches1_16__latches2_28__latchesa Din[28] Dout1[28] Dout2[28] n287 n279 Sal_and_write[16]
+ IN119 VSS VDD_1V8 latchtriestado_483
Xlatches1_16__latches2_27__latchesa Din[27] Dout1[27] Dout2[27] n287 n279 Sal_and_write[16]
+ n93 VSS VDD_1V8 latchtriestado_484
Xlatches1_16__latches2_26__latchesa Din[26] Dout1[26] Dout2[26] n287 n279 Sal_and_write[16]
+ IN117 VSS VDD_1V8 latchtriestado_485
Xlatches1_16__latches2_25__latchesa Din[25] Dout1[25] Dout2[25] n287 n279 Sal_and_write[16]
+ IN120 VSS VDD_1V8 latchtriestado_486
Xlatches1_16__latches2_24__latchesa Din[24] Dout1[24] Dout2[24] n287 n279 Sal_and_write[16]
+ n96 VSS VDD_1V8 latchtriestado_487
Xlatches1_16__latches2_23__latchesa Din[23] Dout1[23] Dout2[23] n287 n279 Sal_and_write[16]
+ n93 VSS VDD_1V8 latchtriestado_488
Xlatches1_16__latches2_22__latchesa Din[22] Dout1[22] Dout2[22] n287 n279 Sal_and_write[16]
+ n74 VSS VDD_1V8 latchtriestado_489
Xlatches1_16__latches2_21__latchesa Din[21] Dout1[21] Dout2[21] n287 n279 Sal_and_write[16]
+ IN125 VSS VDD_1V8 latchtriestado_490
Xlatches1_16__latches2_20__latchesa Din[20] Dout1[20] Dout2[20] n287 n279 Sal_and_write[16]
+ IN101 VSS VDD_1V8 latchtriestado_491
Xlatches1_16__latches2_19__latchesa Din[19] Dout1[19] Dout2[19] n287 n279 Sal_and_write[16]
+ n74 VSS VDD_1V8 latchtriestado_492
Xlatches1_16__latches2_18__latchesa Din[18] Dout1[18] Dout2[18] n287 n279 Sal_and_write[16]
+ IN88 VSS VDD_1V8 latchtriestado_493
Xlatches1_16__latches2_17__latchesa Din[17] Dout1[17] Dout2[17] n287 n279 Sal_and_write[16]
+ IN131 VSS VDD_1V8 latchtriestado_494
Xlatches1_16__latches2_16__latchesa Din[16] Dout1[16] Dout2[16] n287 n279 Sal_and_write[16]
+ IN104 VSS VDD_1V8 latchtriestado_495
Xlatches1_16__latches2_15__latchesa Din[15] Dout1[15] Dout2[15] n287 n279 Sal_and_write[16]
+ IN65 VSS VDD_1V8 latchtriestado_496
Xlatches1_16__latches2_14__latchesa Din[14] Dout1[14] Dout2[14] n287 n279 Sal_and_write[16]
+ n29 VSS VDD_1V8 latchtriestado_497
Xlatches1_16__latches2_13__latchesa Din[13] Dout1[13] Dout2[13] n287 n279 Sal_and_write[16]
+ n4 VSS VDD_1V8 latchtriestado_498
Xlatches1_16__latches2_12__latchesa Din[12] Dout1[12] Dout2[12] n287 n279 Sal_and_write[16]
+ n129 VSS VDD_1V8 latchtriestado_499
Xlatches1_16__latches2_11__latchesa Din[11] Dout1[11] Dout2[11] n287 n279 Sal_and_write[16]
+ IN146 VSS VDD_1V8 latchtriestado_500
Xlatches1_16__latches2_10__latchesa Din[10] Dout1[10] Dout2[10] n287 n279 Sal_and_write[16]
+ IN145 VSS VDD_1V8 latchtriestado_501
Xlatches1_16__latches2_9__latchesa Din[9] Dout1[9] Dout2[9] n287 n279 Sal_and_write[16]
+ n130 VSS VDD_1V8 latchtriestado_502
Xlatches1_16__latches2_8__latchesa Din[8] Dout1[8] Dout2[8] n287 n279 Sal_and_write[16]
+ n129 VSS VDD_1V8 latchtriestado_503
Xlatches1_16__latches2_7__latchesa Din[7] Dout1[7] Dout2[7] n287 n279 Sal_and_write[16]
+ n129 VSS VDD_1V8 latchtriestado_504
Xlatches1_16__latches2_6__latchesa Din[6] Dout1[6] Dout2[6] n287 n279 Sal_and_write[16]
+ n129 VSS VDD_1V8 latchtriestado_505
Xlatches1_16__latches2_5__latchesa Din[5] Dout1[5] Dout2[5] n287 n279 Sal_and_write[16]
+ n129 VSS VDD_1V8 latchtriestado_506
Xlatches1_16__latches2_4__latchesa Din[4] Dout1[4] Dout2[4] n287 n279 Sal_and_write[16]
+ n218 VSS VDD_1V8 latchtriestado_507
Xlatches1_16__latches2_3__latchesa Din[3] Dout1[3] Dout2[3] n287 n279 Sal_and_write[16]
+ n95 VSS VDD_1V8 latchtriestado_508
Xlatches1_16__latches2_2__latchesa Din[2] Dout1[2] Dout2[2] n287 n279 Sal_and_write[16]
+ n75 VSS VDD_1V8 latchtriestado_509
Xlatches1_16__latches2_1__latchesa Din[1] Dout1[1] Dout2[1] n287 n279 Sal_and_write[16]
+ n129 VSS VDD_1V8 latchtriestado_510
Xlatches1_16__latches2_0__latchesa Din[0] Dout1[0] Dout2[0] n287 n279 Sal_and_write[16]
+ n4 VSS VDD_1V8 latchtriestado_511
Xlatches1_15__latches2_31__latchesa Din[31] Dout1[31] Dout2[31] n283 n275 Sal_and_write[15]
+ n5 VSS VDD_1V8 latchtriestado_512
Xlatches1_15__latches2_30__latchesa Din[30] Dout1[30] Dout2[30] n283 n275 Sal_and_write[15]
+ n218 VSS VDD_1V8 latchtriestado_513
Xlatches1_15__latches2_29__latchesa Din[29] Dout1[29] Dout2[29] n283 n275 Sal_and_write[15]
+ n128 VSS VDD_1V8 latchtriestado_514
Xlatches1_15__latches2_28__latchesa Din[28] Dout1[28] Dout2[28] n283 n275 Sal_and_write[15]
+ n73 VSS VDD_1V8 latchtriestado_515
Xlatches1_15__latches2_27__latchesa Din[27] Dout1[27] Dout2[27] n283 n275 Sal_and_write[15]
+ n74 VSS VDD_1V8 latchtriestado_516
Xlatches1_15__latches2_26__latchesa Din[26] Dout1[26] Dout2[26] n283 n275 Sal_and_write[15]
+ n73 VSS VDD_1V8 latchtriestado_517
Xlatches1_15__latches2_25__latchesa Din[25] Dout1[25] Dout2[25] n283 n275 Sal_and_write[15]
+ n93 VSS VDD_1V8 latchtriestado_518
Xlatches1_15__latches2_24__latchesa Din[24] Dout1[24] Dout2[24] n283 n275 Sal_and_write[15]
+ n93 VSS VDD_1V8 latchtriestado_519
Xlatches1_15__latches2_23__latchesa Din[23] Dout1[23] Dout2[23] n283 n275 Sal_and_write[15]
+ n74 VSS VDD_1V8 latchtriestado_520
Xlatches1_15__latches2_22__latchesa Din[22] Dout1[22] Dout2[22] n283 n275 Sal_and_write[15]
+ n93 VSS VDD_1V8 latchtriestado_521
Xlatches1_15__latches2_21__latchesa Din[21] Dout1[21] Dout2[21] n283 n275 Sal_and_write[15]
+ n73 VSS VDD_1V8 latchtriestado_522
Xlatches1_15__latches2_20__latchesa Din[20] Dout1[20] Dout2[20] n283 n275 Sal_and_write[15]
+ n95 VSS VDD_1V8 latchtriestado_523
Xlatches1_15__latches2_19__latchesa Din[19] Dout1[19] Dout2[19] n283 n275 Sal_and_write[15]
+ n93 VSS VDD_1V8 latchtriestado_524
Xlatches1_15__latches2_18__latchesa Din[18] Dout1[18] Dout2[18] n283 n275 Sal_and_write[15]
+ n94 VSS VDD_1V8 latchtriestado_525
Xlatches1_15__latches2_17__latchesa Din[17] Dout1[17] Dout2[17] n283 n275 Sal_and_write[15]
+ n127 VSS VDD_1V8 latchtriestado_526
Xlatches1_15__latches2_16__latchesa Din[16] Dout1[16] Dout2[16] n283 n275 Sal_and_write[15]
+ n94 VSS VDD_1V8 latchtriestado_527
Xlatches1_15__latches2_15__latchesa Din[15] Dout1[15] Dout2[15] n283 n275 Sal_and_write[15]
+ IN64 VSS VDD_1V8 latchtriestado_528
Xlatches1_15__latches2_14__latchesa Din[14] Dout1[14] Dout2[14] n283 n275 Sal_and_write[15]
+ n4 VSS VDD_1V8 latchtriestado_529
Xlatches1_15__latches2_13__latchesa Din[13] Dout1[13] Dout2[13] n283 n275 Sal_and_write[15]
+ n29 VSS VDD_1V8 latchtriestado_530
Xlatches1_15__latches2_12__latchesa Din[12] Dout1[12] Dout2[12] n283 n275 Sal_and_write[15]
+ n129 VSS VDD_1V8 latchtriestado_531
Xlatches1_15__latches2_11__latchesa Din[11] Dout1[11] Dout2[11] n283 n275 Sal_and_write[15]
+ IN139 VSS VDD_1V8 latchtriestado_532
Xlatches1_15__latches2_10__latchesa Din[10] Dout1[10] Dout2[10] n283 n275 Sal_and_write[15]
+ IN136 VSS VDD_1V8 latchtriestado_533
Xlatches1_15__latches2_9__latchesa Din[9] Dout1[9] Dout2[9] n283 n275 Sal_and_write[15]
+ n75 VSS VDD_1V8 latchtriestado_534
Xlatches1_15__latches2_8__latchesa Din[8] Dout1[8] Dout2[8] n283 n275 Sal_and_write[15]
+ n129 VSS VDD_1V8 latchtriestado_535
Xlatches1_15__latches2_7__latchesa Din[7] Dout1[7] Dout2[7] n283 n275 Sal_and_write[15]
+ n129 VSS VDD_1V8 latchtriestado_536
Xlatches1_15__latches2_6__latchesa Din[6] Dout1[6] Dout2[6] n283 n275 Sal_and_write[15]
+ n129 VSS VDD_1V8 latchtriestado_537
Xlatches1_15__latches2_5__latchesa Din[5] Dout1[5] Dout2[5] n283 n275 Sal_and_write[15]
+ n129 VSS VDD_1V8 latchtriestado_538
Xlatches1_15__latches2_4__latchesa Din[4] Dout1[4] Dout2[4] n283 n275 Sal_and_write[15]
+ n75 VSS VDD_1V8 latchtriestado_539
Xlatches1_15__latches2_3__latchesa Din[3] Dout1[3] Dout2[3] n283 n275 Sal_and_write[15]
+ n73 VSS VDD_1V8 latchtriestado_540
Xlatches1_15__latches2_2__latchesa Din[2] Dout1[2] Dout2[2] n283 n275 Sal_and_write[15]
+ IN72 VSS VDD_1V8 latchtriestado_541
Xlatches1_15__latches2_1__latchesa Din[1] Dout1[1] Dout2[1] n283 n275 Sal_and_write[15]
+ n218 VSS VDD_1V8 latchtriestado_542
Xlatches1_15__latches2_0__latchesa Din[0] Dout1[0] Dout2[0] n283 n275 Sal_and_write[15]
+ n126 VSS VDD_1V8 latchtriestado_543
Xlatches1_14__latches2_31__latchesa Din[31] Dout1[31] Dout2[31] n284 n276 Sal_and_write[14]
+ n218 VSS VDD_1V8 latchtriestado_544
Xlatches1_14__latches2_30__latchesa Din[30] Dout1[30] Dout2[30] n284 n276 Sal_and_write[14]
+ n218 VSS VDD_1V8 latchtriestado_545
Xlatches1_14__latches2_29__latchesa Din[29] Dout1[29] Dout2[29] n284 n276 Sal_and_write[14]
+ n127 VSS VDD_1V8 latchtriestado_546
Xlatches1_14__latches2_28__latchesa Din[28] Dout1[28] Dout2[28] n284 n276 Sal_and_write[14]
+ n95 VSS VDD_1V8 latchtriestado_547
Xlatches1_14__latches2_27__latchesa Din[27] Dout1[27] Dout2[27] n284 n276 Sal_and_write[14]
+ n127 VSS VDD_1V8 latchtriestado_548
Xlatches1_14__latches2_26__latchesa Din[26] Dout1[26] Dout2[26] n284 n276 Sal_and_write[14]
+ n95 VSS VDD_1V8 latchtriestado_549
Xlatches1_14__latches2_25__latchesa Din[25] Dout1[25] Dout2[25] n284 n276 Sal_and_write[14]
+ n127 VSS VDD_1V8 latchtriestado_550
Xlatches1_14__latches2_24__latchesa Din[24] Dout1[24] Dout2[24] n284 n276 Sal_and_write[14]
+ n127 VSS VDD_1V8 latchtriestado_551
Xlatches1_14__latches2_23__latchesa Din[23] Dout1[23] Dout2[23] n284 n276 Sal_and_write[14]
+ n127 VSS VDD_1V8 latchtriestado_552
Xlatches1_14__latches2_22__latchesa Din[22] Dout1[22] Dout2[22] n284 n276 Sal_and_write[14]
+ n95 VSS VDD_1V8 latchtriestado_553
Xlatches1_14__latches2_21__latchesa Din[21] Dout1[21] Dout2[21] n284 n276 Sal_and_write[14]
+ n5 VSS VDD_1V8 latchtriestado_554
Xlatches1_14__latches2_20__latchesa Din[20] Dout1[20] Dout2[20] n284 n276 Sal_and_write[14]
+ n5 VSS VDD_1V8 latchtriestado_555
Xlatches1_14__latches2_19__latchesa Din[19] Dout1[19] Dout2[19] n284 n276 Sal_and_write[14]
+ n5 VSS VDD_1V8 latchtriestado_556
Xlatches1_14__latches2_18__latchesa Din[18] Dout1[18] Dout2[18] n284 n276 Sal_and_write[14]
+ n126 VSS VDD_1V8 latchtriestado_557
Xlatches1_14__latches2_17__latchesa Din[17] Dout1[17] Dout2[17] n284 n276 Sal_and_write[14]
+ n126 VSS VDD_1V8 latchtriestado_558
Xlatches1_14__latches2_16__latchesa Din[16] Dout1[16] Dout2[16] n284 n276 Sal_and_write[14]
+ n95 VSS VDD_1V8 latchtriestado_559
Xlatches1_14__latches2_15__latchesa Din[15] Dout1[15] Dout2[15] n284 n276 Sal_and_write[14]
+ n218 VSS VDD_1V8 latchtriestado_560
Xlatches1_14__latches2_14__latchesa Din[14] Dout1[14] Dout2[14] n284 n276 Sal_and_write[14]
+ n218 VSS VDD_1V8 latchtriestado_561
Xlatches1_14__latches2_13__latchesa Din[13] Dout1[13] Dout2[13] n284 n276 Sal_and_write[14]
+ n218 VSS VDD_1V8 latchtriestado_562
Xlatches1_14__latches2_12__latchesa Din[12] Dout1[12] Dout2[12] n284 n276 Sal_and_write[14]
+ n129 VSS VDD_1V8 latchtriestado_563
Xlatches1_14__latches2_11__latchesa Din[11] Dout1[11] Dout2[11] n284 n276 Sal_and_write[14]
+ IN161 VSS VDD_1V8 latchtriestado_564
Xlatches1_14__latches2_10__latchesa Din[10] Dout1[10] Dout2[10] n284 n276 Sal_and_write[14]
+ IN143 VSS VDD_1V8 latchtriestado_565
Xlatches1_14__latches2_9__latchesa Din[9] Dout1[9] Dout2[9] n284 n276 Sal_and_write[14]
+ n75 VSS VDD_1V8 latchtriestado_566
Xlatches1_14__latches2_8__latchesa Din[8] Dout1[8] Dout2[8] n284 n276 Sal_and_write[14]
+ n129 VSS VDD_1V8 latchtriestado_567
Xlatches1_14__latches2_7__latchesa Din[7] Dout1[7] Dout2[7] n284 n276 Sal_and_write[14]
+ n129 VSS VDD_1V8 latchtriestado_568
Xlatches1_14__latches2_6__latchesa Din[6] Dout1[6] Dout2[6] n284 n276 Sal_and_write[14]
+ n129 VSS VDD_1V8 latchtriestado_569
Xlatches1_14__latches2_5__latchesa Din[5] Dout1[5] Dout2[5] n284 n276 Sal_and_write[14]
+ n129 VSS VDD_1V8 latchtriestado_570
Xlatches1_14__latches2_4__latchesa Din[4] Dout1[4] Dout2[4] n284 n276 Sal_and_write[14]
+ n75 VSS VDD_1V8 latchtriestado_571
Xlatches1_14__latches2_3__latchesa Din[3] Dout1[3] Dout2[3] n284 n276 Sal_and_write[14]
+ n5 VSS VDD_1V8 latchtriestado_572
Xlatches1_14__latches2_2__latchesa Din[2] Dout1[2] Dout2[2] n284 n276 Sal_and_write[14]
+ n75 VSS VDD_1V8 latchtriestado_573
Xlatches1_14__latches2_1__latchesa Din[1] Dout1[1] Dout2[1] n284 n276 Sal_and_write[14]
+ n75 VSS VDD_1V8 latchtriestado_574
Xlatches1_14__latches2_0__latchesa Din[0] Dout1[0] Dout2[0] n284 n276 Sal_and_write[14]
+ n126 VSS VDD_1V8 latchtriestado_575
Xlatches1_13__latches2_31__latchesa Din[31] Dout1[31] Dout2[31] n285 n277 CTS_CLK_CTO_delay421
+ n128 VSS VDD_1V8 latchtriestado_576
Xlatches1_13__latches2_30__latchesa Din[30] Dout1[30] Dout2[30] n285 n277 CTS_CLK_CTO_delay421
+ n75 VSS VDD_1V8 latchtriestado_577
Xlatches1_13__latches2_29__latchesa Din[29] Dout1[29] Dout2[29] n285 n277 CTS_CLK_CTO_delay421
+ n74 VSS VDD_1V8 latchtriestado_578
Xlatches1_13__latches2_28__latchesa Din[28] Dout1[28] Dout2[28] n285 n277 CTS_CLK_CTO_delay421
+ n93 VSS VDD_1V8 latchtriestado_579
Xlatches1_13__latches2_27__latchesa Din[27] Dout1[27] Dout2[27] n285 n277 CTS_CLK_CTO_delay421
+ n128 VSS VDD_1V8 latchtriestado_580
Xlatches1_13__latches2_26__latchesa Din[26] Dout1[26] Dout2[26] n285 n277 CTS_CLK_CTO_delay421
+ n93 VSS VDD_1V8 latchtriestado_581
Xlatches1_13__latches2_25__latchesa Din[25] Dout1[25] Dout2[25] n285 n277 CTS_CLK_CTO_delay421
+ n94 VSS VDD_1V8 latchtriestado_582
Xlatches1_13__latches2_24__latchesa Din[24] Dout1[24] Dout2[24] n285 n277 CTS_CLK_CTO_delay421
+ n128 VSS VDD_1V8 latchtriestado_583
Xlatches1_13__latches2_23__latchesa Din[23] Dout1[23] Dout2[23] n285 n277 CTS_CLK_CTO_delay421
+ n74 VSS VDD_1V8 latchtriestado_584
Xlatches1_13__latches2_22__latchesa Din[22] Dout1[22] Dout2[22] n285 n277 CTS_CLK_CTO_delay421
+ n74 VSS VDD_1V8 latchtriestado_585
Xlatches1_13__latches2_21__latchesa Din[21] Dout1[21] Dout2[21] n285 n277 CTS_CLK_CTO_delay421
+ n74 VSS VDD_1V8 latchtriestado_586
Xlatches1_13__latches2_20__latchesa Din[20] Dout1[20] Dout2[20] n285 n277 CTS_CLK_CTO_delay421
+ n94 VSS VDD_1V8 latchtriestado_587
Xlatches1_13__latches2_19__latchesa Din[19] Dout1[19] Dout2[19] n285 n277 CTS_CLK_CTO_delay421
+ n93 VSS VDD_1V8 latchtriestado_588
Xlatches1_13__latches2_18__latchesa Din[18] Dout1[18] Dout2[18] n285 n277 CTS_CLK_CTO_delay421
+ n127 VSS VDD_1V8 latchtriestado_589
Xlatches1_13__latches2_17__latchesa Din[17] Dout1[17] Dout2[17] n285 n277 CTS_CLK_CTO_delay421
+ n94 VSS VDD_1V8 latchtriestado_590
Xlatches1_13__latches2_16__latchesa Din[16] Dout1[16] Dout2[16] n285 n277 CTS_CLK_CTO_delay421
+ n94 VSS VDD_1V8 latchtriestado_591
Xlatches1_13__latches2_15__latchesa Din[15] Dout1[15] Dout2[15] n285 n277 CTS_CLK_CTO_delay421
+ n29 VSS VDD_1V8 latchtriestado_592
Xlatches1_13__latches2_14__latchesa Din[14] Dout1[14] Dout2[14] n285 n277 CTS_CLK_CTO_delay421
+ n29 VSS VDD_1V8 latchtriestado_593
Xlatches1_13__latches2_13__latchesa Din[13] Dout1[13] Dout2[13] n285 n277 CTS_CLK_CTO_delay421
+ n4 VSS VDD_1V8 latchtriestado_594
Xlatches1_13__latches2_12__latchesa Din[12] Dout1[12] Dout2[12] n285 n277 CTS_CLK_CTO_delay421
+ n129 VSS VDD_1V8 latchtriestado_595
Xlatches1_13__latches2_11__latchesa Din[11] Dout1[11] Dout2[11] n285 n277 CTS_CLK_CTO_delay421
+ n30 VSS VDD_1V8 latchtriestado_596
Xlatches1_13__latches2_10__latchesa Din[10] Dout1[10] Dout2[10] n285 n277 CTS_CLK_CTO_delay421
+ IN138 VSS VDD_1V8 latchtriestado_597
Xlatches1_13__latches2_9__latchesa Din[9] Dout1[9] Dout2[9] n285 n277 CTS_CLK_CTO_delay421
+ n129 VSS VDD_1V8 latchtriestado_598
Xlatches1_13__latches2_8__latchesa Din[8] Dout1[8] Dout2[8] n285 n277 CTS_CLK_CTO_delay421
+ n129 VSS VDD_1V8 latchtriestado_599
Xlatches1_13__latches2_7__latchesa Din[7] Dout1[7] Dout2[7] n285 n277 CTS_CLK_CTO_delay421
+ n129 VSS VDD_1V8 latchtriestado_600
Xlatches1_13__latches2_6__latchesa Din[6] Dout1[6] Dout2[6] n285 n277 CTS_CLK_CTO_delay421
+ n129 VSS VDD_1V8 latchtriestado_601
Xlatches1_13__latches2_5__latchesa Din[5] Dout1[5] Dout2[5] n285 n277 CTS_CLK_CTO_delay421
+ n129 VSS VDD_1V8 latchtriestado_602
Xlatches1_13__latches2_4__latchesa Din[4] Dout1[4] Dout2[4] n285 n277 CTS_CLK_CTO_delay421
+ n75 VSS VDD_1V8 latchtriestado_603
Xlatches1_13__latches2_3__latchesa Din[3] Dout1[3] Dout2[3] n285 n277 CTS_CLK_CTO_delay421
+ n94 VSS VDD_1V8 latchtriestado_604
Xlatches1_13__latches2_2__latchesa Din[2] Dout1[2] Dout2[2] n285 n277 CTS_CLK_CTO_delay421
+ n129 VSS VDD_1V8 latchtriestado_605
Xlatches1_13__latches2_1__latchesa Din[1] Dout1[1] Dout2[1] n285 n277 CTS_CLK_CTO_delay421
+ n129 VSS VDD_1V8 latchtriestado_606
Xlatches1_13__latches2_0__latchesa Din[0] Dout1[0] Dout2[0] n285 n277 CTS_CLK_CTO_delay421
+ n4 VSS VDD_1V8 latchtriestado_607
Xlatches1_12__latches2_31__latchesa Din[31] Dout1[31] Dout2[31] conect_deco_latch1[12]
+ conect_deco_latch2[12] CTS_CLK_CTO_delay401 IN128 VSS VDD_1V8 latchtriestado_608
Xlatches1_12__latches2_30__latchesa Din[30] Dout1[30] Dout2[30] conect_deco_latch1[12]
+ conect_deco_latch2[12] CTS_CLK_CTO_delay401 n4 VSS VDD_1V8 latchtriestado_609
Xlatches1_12__latches2_29__latchesa Din[29] Dout1[29] Dout2[29] conect_deco_latch1[12]
+ conect_deco_latch2[12] CTS_CLK_CTO_delay401 IN126 VSS VDD_1V8 latchtriestado_610
Xlatches1_12__latches2_28__latchesa Din[28] Dout1[28] Dout2[28] conect_deco_latch1[12]
+ conect_deco_latch2[12] CTS_CLK_CTO_delay401 n96 VSS VDD_1V8 latchtriestado_611
Xlatches1_12__latches2_27__latchesa Din[27] Dout1[27] Dout2[27] conect_deco_latch1[12]
+ conect_deco_latch2[12] CTS_CLK_CTO_delay401 n96 VSS VDD_1V8 latchtriestado_612
Xlatches1_12__latches2_26__latchesa Din[26] Dout1[26] Dout2[26] conect_deco_latch1[12]
+ conect_deco_latch2[12] CTS_CLK_CTO_delay401 n96 VSS VDD_1V8 latchtriestado_613
Xlatches1_12__latches2_25__latchesa Din[25] Dout1[25] Dout2[25] conect_deco_latch1[12]
+ conect_deco_latch2[12] CTS_CLK_CTO_delay401 n96 VSS VDD_1V8 latchtriestado_614
Xlatches1_12__latches2_24__latchesa Din[24] Dout1[24] Dout2[24] conect_deco_latch1[12]
+ conect_deco_latch2[12] CTS_CLK_CTO_delay401 n96 VSS VDD_1V8 latchtriestado_615
Xlatches1_12__latches2_23__latchesa Din[23] Dout1[23] Dout2[23] conect_deco_latch1[12]
+ conect_deco_latch2[12] CTS_CLK_CTO_delay401 n93 VSS VDD_1V8 latchtriestado_616
Xlatches1_12__latches2_22__latchesa Din[22] Dout1[22] Dout2[22] conect_deco_latch1[12]
+ conect_deco_latch2[12] CTS_CLK_CTO_delay401 n96 VSS VDD_1V8 latchtriestado_617
Xlatches1_12__latches2_21__latchesa Din[21] Dout1[21] Dout2[21] conect_deco_latch1[12]
+ conect_deco_latch2[12] CTS_CLK_CTO_delay401 n93 VSS VDD_1V8 latchtriestado_618
Xlatches1_12__latches2_20__latchesa Din[20] Dout1[20] Dout2[20] conect_deco_latch1[12]
+ conect_deco_latch2[12] CTS_CLK_CTO_delay401 IN103 VSS VDD_1V8 latchtriestado_619
Xlatches1_12__latches2_19__latchesa Din[19] Dout1[19] Dout2[19] conect_deco_latch1[12]
+ conect_deco_latch2[12] CTS_CLK_CTO_delay401 IN124 VSS VDD_1V8 latchtriestado_620
Xlatches1_12__latches2_18__latchesa Din[18] Dout1[18] Dout2[18] conect_deco_latch1[12]
+ conect_deco_latch2[12] CTS_CLK_CTO_delay401 IN90 VSS VDD_1V8 latchtriestado_621
Xlatches1_12__latches2_17__latchesa Din[17] Dout1[17] Dout2[17] conect_deco_latch1[12]
+ conect_deco_latch2[12] CTS_CLK_CTO_delay401 IN129 VSS VDD_1V8 latchtriestado_622
Xlatches1_12__latches2_16__latchesa Din[16] Dout1[16] Dout2[16] conect_deco_latch1[12]
+ conect_deco_latch2[12] CTS_CLK_CTO_delay401 IN100 VSS VDD_1V8 latchtriestado_623
Xlatches1_12__latches2_15__latchesa Din[15] Dout1[15] Dout2[15] conect_deco_latch1[12]
+ conect_deco_latch2[12] CTS_CLK_CTO_delay401 n4 VSS VDD_1V8 latchtriestado_624
Xlatches1_12__latches2_14__latchesa Din[14] Dout1[14] Dout2[14] conect_deco_latch1[12]
+ conect_deco_latch2[12] CTS_CLK_CTO_delay401 n4 VSS VDD_1V8 latchtriestado_625
Xlatches1_12__latches2_13__latchesa Din[13] Dout1[13] Dout2[13] conect_deco_latch1[12]
+ conect_deco_latch2[12] CTS_CLK_CTO_delay401 n4 VSS VDD_1V8 latchtriestado_626
Xlatches1_12__latches2_12__latchesa Din[12] Dout1[12] Dout2[12] conect_deco_latch1[12]
+ conect_deco_latch2[12] CTS_CLK_CTO_delay401 IN13 VSS VDD_1V8 latchtriestado_627
Xlatches1_12__latches2_11__latchesa Din[11] Dout1[11] Dout2[11] conect_deco_latch1[12]
+ conect_deco_latch2[12] CTS_CLK_CTO_delay401 IN15 VSS VDD_1V8 latchtriestado_628
Xlatches1_12__latches2_10__latchesa Din[10] Dout1[10] Dout2[10] conect_deco_latch1[12]
+ conect_deco_latch2[12] CTS_CLK_CTO_delay401 IN30 VSS VDD_1V8 latchtriestado_629
Xlatches1_12__latches2_9__latchesa Din[9] Dout1[9] Dout2[9] conect_deco_latch1[12]
+ conect_deco_latch2[12] CTS_CLK_CTO_delay401 IN5 VSS VDD_1V8 latchtriestado_630
Xlatches1_12__latches2_8__latchesa Din[8] Dout1[8] Dout2[8] conect_deco_latch1[12]
+ conect_deco_latch2[12] CTS_CLK_CTO_delay401 IN29 VSS VDD_1V8 latchtriestado_631
Xlatches1_12__latches2_7__latchesa Din[7] Dout1[7] Dout2[7] conect_deco_latch1[12]
+ conect_deco_latch2[12] CTS_CLK_CTO_delay401 IN26 VSS VDD_1V8 latchtriestado_632
Xlatches1_12__latches2_6__latchesa Din[6] Dout1[6] Dout2[6] conect_deco_latch1[12]
+ conect_deco_latch2[12] CTS_CLK_CTO_delay401 IN175 VSS VDD_1V8 latchtriestado_633
Xlatches1_12__latches2_5__latchesa Din[5] Dout1[5] Dout2[5] conect_deco_latch1[12]
+ conect_deco_latch2[12] CTS_CLK_CTO_delay401 IN32 VSS VDD_1V8 latchtriestado_634
Xlatches1_12__latches2_4__latchesa Din[4] Dout1[4] Dout2[4] conect_deco_latch1[12]
+ conect_deco_latch2[12] CTS_CLK_CTO_delay401 IN47 VSS VDD_1V8 latchtriestado_635
Xlatches1_12__latches2_3__latchesa Din[3] Dout1[3] Dout2[3] conect_deco_latch1[12]
+ conect_deco_latch2[12] CTS_CLK_CTO_delay401 IN95 VSS VDD_1V8 latchtriestado_636
Xlatches1_12__latches2_2__latchesa Din[2] Dout1[2] Dout2[2] conect_deco_latch1[12]
+ conect_deco_latch2[12] CTS_CLK_CTO_delay401 IN78 VSS VDD_1V8 latchtriestado_637
Xlatches1_12__latches2_1__latchesa Din[1] Dout1[1] Dout2[1] conect_deco_latch1[12]
+ conect_deco_latch2[12] CTS_CLK_CTO_delay401 IN81 VSS VDD_1V8 latchtriestado_638
Xlatches1_12__latches2_0__latchesa Din[0] Dout1[0] Dout2[0] conect_deco_latch1[12]
+ conect_deco_latch2[12] CTS_CLK_CTO_delay401 n4 VSS VDD_1V8 latchtriestado_639
Xlatches1_11__latches2_31__latchesa Din[31] Dout1[31] Dout2[31] n298 n264 Sal_and_write[11]
+ n4 VSS VDD_1V8 latchtriestado_640
Xlatches1_11__latches2_30__latchesa Din[30] Dout1[30] Dout2[30] n298 n264 Sal_and_write[11]
+ IN77 VSS VDD_1V8 latchtriestado_641
Xlatches1_11__latches2_29__latchesa Din[29] Dout1[29] Dout2[29] n298 n264 Sal_and_write[11]
+ n5 VSS VDD_1V8 latchtriestado_642
Xlatches1_11__latches2_28__latchesa Din[28] Dout1[28] Dout2[28] n298 n264 Sal_and_write[11]
+ n94 VSS VDD_1V8 latchtriestado_643
Xlatches1_11__latches2_27__latchesa Din[27] Dout1[27] Dout2[27] n298 n264 Sal_and_write[11]
+ n94 VSS VDD_1V8 latchtriestado_644
Xlatches1_11__latches2_26__latchesa Din[26] Dout1[26] Dout2[26] n298 n264 Sal_and_write[11]
+ n94 VSS VDD_1V8 latchtriestado_645
Xlatches1_11__latches2_25__latchesa Din[25] Dout1[25] Dout2[25] n298 n264 Sal_and_write[11]
+ n127 VSS VDD_1V8 latchtriestado_646
Xlatches1_11__latches2_24__latchesa Din[24] Dout1[24] Dout2[24] n298 n264 Sal_and_write[11]
+ n95 VSS VDD_1V8 latchtriestado_647
Xlatches1_11__latches2_23__latchesa Din[23] Dout1[23] Dout2[23] n298 n264 Sal_and_write[11]
+ n5 VSS VDD_1V8 latchtriestado_648
Xlatches1_11__latches2_22__latchesa Din[22] Dout1[22] Dout2[22] n298 n264 Sal_and_write[11]
+ n127 VSS VDD_1V8 latchtriestado_649
Xlatches1_11__latches2_21__latchesa Din[21] Dout1[21] Dout2[21] n298 n264 Sal_and_write[11]
+ n94 VSS VDD_1V8 latchtriestado_650
Xlatches1_11__latches2_20__latchesa Din[20] Dout1[20] Dout2[20] n298 n264 Sal_and_write[11]
+ n94 VSS VDD_1V8 latchtriestado_651
Xlatches1_11__latches2_19__latchesa Din[19] Dout1[19] Dout2[19] n298 n264 Sal_and_write[11]
+ n94 VSS VDD_1V8 latchtriestado_652
Xlatches1_11__latches2_18__latchesa Din[18] Dout1[18] Dout2[18] n298 n264 Sal_and_write[11]
+ n94 VSS VDD_1V8 latchtriestado_653
Xlatches1_11__latches2_17__latchesa Din[17] Dout1[17] Dout2[17] n298 n264 Sal_and_write[11]
+ n126 VSS VDD_1V8 latchtriestado_654
Xlatches1_11__latches2_16__latchesa Din[16] Dout1[16] Dout2[16] n298 n264 Sal_and_write[11]
+ n94 VSS VDD_1V8 latchtriestado_655
Xlatches1_11__latches2_15__latchesa Din[15] Dout1[15] Dout2[15] n298 n264 Sal_and_write[11]
+ n29 VSS VDD_1V8 latchtriestado_656
Xlatches1_11__latches2_14__latchesa Din[14] Dout1[14] Dout2[14] n298 n264 Sal_and_write[11]
+ n29 VSS VDD_1V8 latchtriestado_657
Xlatches1_11__latches2_13__latchesa Din[13] Dout1[13] Dout2[13] n298 n264 Sal_and_write[11]
+ n29 VSS VDD_1V8 latchtriestado_658
Xlatches1_11__latches2_12__latchesa Din[12] Dout1[12] Dout2[12] n298 n264 Sal_and_write[11]
+ n129 VSS VDD_1V8 latchtriestado_659
Xlatches1_11__latches2_11__latchesa Din[11] Dout1[11] Dout2[11] n298 n264 Sal_and_write[11]
+ IN86 VSS VDD_1V8 latchtriestado_660
Xlatches1_11__latches2_10__latchesa Din[10] Dout1[10] Dout2[10] n298 n264 Sal_and_write[11]
+ IN135 VSS VDD_1V8 latchtriestado_661
Xlatches1_11__latches2_9__latchesa Din[9] Dout1[9] Dout2[9] n298 n264 Sal_and_write[11]
+ n130 VSS VDD_1V8 latchtriestado_662
Xlatches1_11__latches2_8__latchesa Din[8] Dout1[8] Dout2[8] n298 n264 Sal_and_write[11]
+ n130 VSS VDD_1V8 latchtriestado_663
Xlatches1_11__latches2_7__latchesa Din[7] Dout1[7] Dout2[7] n298 n264 Sal_and_write[11]
+ n129 VSS VDD_1V8 latchtriestado_664
Xlatches1_11__latches2_6__latchesa Din[6] Dout1[6] Dout2[6] n298 n264 Sal_and_write[11]
+ n129 VSS VDD_1V8 latchtriestado_665
Xlatches1_11__latches2_5__latchesa Din[5] Dout1[5] Dout2[5] n298 n264 Sal_and_write[11]
+ n129 VSS VDD_1V8 latchtriestado_666
Xlatches1_11__latches2_4__latchesa Din[4] Dout1[4] Dout2[4] n298 n264 Sal_and_write[11]
+ n75 VSS VDD_1V8 latchtriestado_667
Xlatches1_11__latches2_3__latchesa Din[3] Dout1[3] Dout2[3] n298 n264 Sal_and_write[11]
+ n5 VSS VDD_1V8 latchtriestado_668
Xlatches1_11__latches2_2__latchesa Din[2] Dout1[2] Dout2[2] n298 n264 Sal_and_write[11]
+ n75 VSS VDD_1V8 latchtriestado_669
Xlatches1_11__latches2_1__latchesa Din[1] Dout1[1] Dout2[1] n298 n264 Sal_and_write[11]
+ n75 VSS VDD_1V8 latchtriestado_670
Xlatches1_11__latches2_0__latchesa Din[0] Dout1[0] Dout2[0] n298 n264 Sal_and_write[11]
+ n126 VSS VDD_1V8 latchtriestado_671
Xlatches1_10__latches2_31__latchesa Din[31] Dout1[31] Dout2[31] n299 n265 Sal_and_write[10]
+ n73 VSS VDD_1V8 latchtriestado_672
Xlatches1_10__latches2_30__latchesa Din[30] Dout1[30] Dout2[30] n299 n265 Sal_and_write[10]
+ IN74 VSS VDD_1V8 latchtriestado_673
Xlatches1_10__latches2_29__latchesa Din[29] Dout1[29] Dout2[29] n299 n265 Sal_and_write[10]
+ n73 VSS VDD_1V8 latchtriestado_674
Xlatches1_10__latches2_28__latchesa Din[28] Dout1[28] Dout2[28] n299 n265 Sal_and_write[10]
+ n96 VSS VDD_1V8 latchtriestado_675
Xlatches1_10__latches2_27__latchesa Din[27] Dout1[27] Dout2[27] n299 n265 Sal_and_write[10]
+ n96 VSS VDD_1V8 latchtriestado_676
Xlatches1_10__latches2_26__latchesa Din[26] Dout1[26] Dout2[26] n299 n265 Sal_and_write[10]
+ n96 VSS VDD_1V8 latchtriestado_677
Xlatches1_10__latches2_25__latchesa Din[25] Dout1[25] Dout2[25] n299 n265 Sal_and_write[10]
+ n96 VSS VDD_1V8 latchtriestado_678
Xlatches1_10__latches2_24__latchesa Din[24] Dout1[24] Dout2[24] n299 n265 Sal_and_write[10]
+ n93 VSS VDD_1V8 latchtriestado_679
Xlatches1_10__latches2_23__latchesa Din[23] Dout1[23] Dout2[23] n299 n265 Sal_and_write[10]
+ n93 VSS VDD_1V8 latchtriestado_680
Xlatches1_10__latches2_22__latchesa Din[22] Dout1[22] Dout2[22] n299 n265 Sal_and_write[10]
+ n73 VSS VDD_1V8 latchtriestado_681
Xlatches1_10__latches2_21__latchesa Din[21] Dout1[21] Dout2[21] n299 n265 Sal_and_write[10]
+ n93 VSS VDD_1V8 latchtriestado_682
Xlatches1_10__latches2_20__latchesa Din[20] Dout1[20] Dout2[20] n299 n265 Sal_and_write[10]
+ n94 VSS VDD_1V8 latchtriestado_683
Xlatches1_10__latches2_19__latchesa Din[19] Dout1[19] Dout2[19] n299 n265 Sal_and_write[10]
+ n93 VSS VDD_1V8 latchtriestado_684
Xlatches1_10__latches2_18__latchesa Din[18] Dout1[18] Dout2[18] n299 n265 Sal_and_write[10]
+ n94 VSS VDD_1V8 latchtriestado_685
Xlatches1_10__latches2_17__latchesa Din[17] Dout1[17] Dout2[17] n299 n265 Sal_and_write[10]
+ n94 VSS VDD_1V8 latchtriestado_686
Xlatches1_10__latches2_16__latchesa Din[16] Dout1[16] Dout2[16] n299 n265 Sal_and_write[10]
+ n4 VSS VDD_1V8 latchtriestado_687
Xlatches1_10__latches2_15__latchesa Din[15] Dout1[15] Dout2[15] n299 n265 Sal_and_write[10]
+ n29 VSS VDD_1V8 latchtriestado_688
Xlatches1_10__latches2_14__latchesa Din[14] Dout1[14] Dout2[14] n299 n265 Sal_and_write[10]
+ n4 VSS VDD_1V8 latchtriestado_689
Xlatches1_10__latches2_13__latchesa Din[13] Dout1[13] Dout2[13] n299 n265 Sal_and_write[10]
+ n95 VSS VDD_1V8 latchtriestado_690
Xlatches1_10__latches2_12__latchesa Din[12] Dout1[12] Dout2[12] n299 n265 Sal_and_write[10]
+ IN195 VSS VDD_1V8 latchtriestado_691
Xlatches1_10__latches2_11__latchesa Din[11] Dout1[11] Dout2[11] n299 n265 Sal_and_write[10]
+ IN182 VSS VDD_1V8 latchtriestado_692
Xlatches1_10__latches2_10__latchesa Din[10] Dout1[10] Dout2[10] n299 n265 Sal_and_write[10]
+ IN177 VSS VDD_1V8 latchtriestado_693
Xlatches1_10__latches2_9__latchesa Din[9] Dout1[9] Dout2[9] n299 n265 Sal_and_write[10]
+ IN76 VSS VDD_1V8 latchtriestado_694
Xlatches1_10__latches2_8__latchesa Din[8] Dout1[8] Dout2[8] n299 n265 Sal_and_write[10]
+ IN186 VSS VDD_1V8 latchtriestado_695
Xlatches1_10__latches2_7__latchesa Din[7] Dout1[7] Dout2[7] n299 n265 Sal_and_write[10]
+ IN193 VSS VDD_1V8 latchtriestado_696
Xlatches1_10__latches2_6__latchesa Din[6] Dout1[6] Dout2[6] n299 n265 Sal_and_write[10]
+ IN197 VSS VDD_1V8 latchtriestado_697
Xlatches1_10__latches2_5__latchesa Din[5] Dout1[5] Dout2[5] n299 n265 Sal_and_write[10]
+ IN194 VSS VDD_1V8 latchtriestado_698
Xlatches1_10__latches2_4__latchesa Din[4] Dout1[4] Dout2[4] n299 n265 Sal_and_write[10]
+ n95 VSS VDD_1V8 latchtriestado_699
Xlatches1_10__latches2_3__latchesa Din[3] Dout1[3] Dout2[3] n299 n265 Sal_and_write[10]
+ n73 VSS VDD_1V8 latchtriestado_700
Xlatches1_10__latches2_2__latchesa Din[2] Dout1[2] Dout2[2] n299 n265 Sal_and_write[10]
+ IN28 VSS VDD_1V8 latchtriestado_701
Xlatches1_10__latches2_1__latchesa Din[1] Dout1[1] Dout2[1] n299 n265 Sal_and_write[10]
+ IN184 VSS VDD_1V8 latchtriestado_702
Xlatches1_10__latches2_0__latchesa Din[0] Dout1[0] Dout2[0] n299 n265 Sal_and_write[10]
+ IN114 VSS VDD_1V8 latchtriestado_703
Xlatches1_9__latches2_31__latchesa Din[31] Dout1[31] Dout2[31] n294 n260 CTS_CLK_CTO_delay241
+ n94 VSS VDD_1V8 latchtriestado_704
Xlatches1_9__latches2_30__latchesa Din[30] Dout1[30] Dout2[30] n294 n260 CTS_CLK_CTO_delay241
+ IN110 VSS VDD_1V8 latchtriestado_705
Xlatches1_9__latches2_29__latchesa Din[29] Dout1[29] Dout2[29] n294 n260 CTS_CLK_CTO_delay241
+ n94 VSS VDD_1V8 latchtriestado_706
Xlatches1_9__latches2_28__latchesa Din[28] Dout1[28] Dout2[28] n294 n260 CTS_CLK_CTO_delay241
+ n96 VSS VDD_1V8 latchtriestado_707
Xlatches1_9__latches2_27__latchesa Din[27] Dout1[27] Dout2[27] n294 n260 CTS_CLK_CTO_delay241
+ n74 VSS VDD_1V8 latchtriestado_708
Xlatches1_9__latches2_26__latchesa Din[26] Dout1[26] Dout2[26] n294 n260 CTS_CLK_CTO_delay241
+ n96 VSS VDD_1V8 latchtriestado_709
Xlatches1_9__latches2_25__latchesa Din[25] Dout1[25] Dout2[25] n294 n260 CTS_CLK_CTO_delay241
+ n96 VSS VDD_1V8 latchtriestado_710
Xlatches1_9__latches2_24__latchesa Din[24] Dout1[24] Dout2[24] n294 n260 CTS_CLK_CTO_delay241
+ n96 VSS VDD_1V8 latchtriestado_711
Xlatches1_9__latches2_23__latchesa Din[23] Dout1[23] Dout2[23] n294 n260 CTS_CLK_CTO_delay241
+ n74 VSS VDD_1V8 latchtriestado_712
Xlatches1_9__latches2_22__latchesa Din[22] Dout1[22] Dout2[22] n294 n260 CTS_CLK_CTO_delay241
+ n128 VSS VDD_1V8 latchtriestado_713
Xlatches1_9__latches2_21__latchesa Din[21] Dout1[21] Dout2[21] n294 n260 CTS_CLK_CTO_delay241
+ n93 VSS VDD_1V8 latchtriestado_714
Xlatches1_9__latches2_20__latchesa Din[20] Dout1[20] Dout2[20] n294 n260 CTS_CLK_CTO_delay241
+ n95 VSS VDD_1V8 latchtriestado_715
Xlatches1_9__latches2_19__latchesa Din[19] Dout1[19] Dout2[19] n294 n260 CTS_CLK_CTO_delay241
+ n128 VSS VDD_1V8 latchtriestado_716
Xlatches1_9__latches2_18__latchesa Din[18] Dout1[18] Dout2[18] n294 n260 CTS_CLK_CTO_delay241
+ n127 VSS VDD_1V8 latchtriestado_717
Xlatches1_9__latches2_17__latchesa Din[17] Dout1[17] Dout2[17] n294 n260 CTS_CLK_CTO_delay241
+ n95 VSS VDD_1V8 latchtriestado_718
Xlatches1_9__latches2_16__latchesa Din[16] Dout1[16] Dout2[16] n294 n260 CTS_CLK_CTO_delay241
+ IN108 VSS VDD_1V8 latchtriestado_719
Xlatches1_9__latches2_15__latchesa Din[15] Dout1[15] Dout2[15] n294 n260 CTS_CLK_CTO_delay241
+ n29 VSS VDD_1V8 latchtriestado_720
Xlatches1_9__latches2_14__latchesa Din[14] Dout1[14] Dout2[14] n294 n260 CTS_CLK_CTO_delay241
+ n29 VSS VDD_1V8 latchtriestado_721
Xlatches1_9__latches2_13__latchesa Din[13] Dout1[13] Dout2[13] n294 n260 CTS_CLK_CTO_delay241
+ n4 VSS VDD_1V8 latchtriestado_722
Xlatches1_9__latches2_12__latchesa Din[12] Dout1[12] Dout2[12] n294 n260 CTS_CLK_CTO_delay241
+ IN3 VSS VDD_1V8 latchtriestado_723
Xlatches1_9__latches2_11__latchesa Din[11] Dout1[11] Dout2[11] n294 n260 CTS_CLK_CTO_delay241
+ IN85 VSS VDD_1V8 latchtriestado_724
Xlatches1_9__latches2_10__latchesa Din[10] Dout1[10] Dout2[10] n294 n260 CTS_CLK_CTO_delay241
+ IN8 VSS VDD_1V8 latchtriestado_725
Xlatches1_9__latches2_9__latchesa Din[9] Dout1[9] Dout2[9] n294 n260 CTS_CLK_CTO_delay241
+ n218 VSS VDD_1V8 latchtriestado_726
Xlatches1_9__latches2_8__latchesa Din[8] Dout1[8] Dout2[8] n294 n260 CTS_CLK_CTO_delay241
+ n30 VSS VDD_1V8 latchtriestado_727
Xlatches1_9__latches2_7__latchesa Din[7] Dout1[7] Dout2[7] n294 n260 CTS_CLK_CTO_delay241
+ n30 VSS VDD_1V8 latchtriestado_728
Xlatches1_9__latches2_6__latchesa Din[6] Dout1[6] Dout2[6] n294 n260 CTS_CLK_CTO_delay241
+ n130 VSS VDD_1V8 latchtriestado_729
Xlatches1_9__latches2_5__latchesa Din[5] Dout1[5] Dout2[5] n294 n260 CTS_CLK_CTO_delay241
+ n30 VSS VDD_1V8 latchtriestado_730
Xlatches1_9__latches2_4__latchesa Din[4] Dout1[4] Dout2[4] n294 n260 CTS_CLK_CTO_delay241
+ n218 VSS VDD_1V8 latchtriestado_731
Xlatches1_9__latches2_3__latchesa Din[3] Dout1[3] Dout2[3] n294 n260 CTS_CLK_CTO_delay241
+ n128 VSS VDD_1V8 latchtriestado_732
Xlatches1_9__latches2_2__latchesa Din[2] Dout1[2] Dout2[2] n294 n260 CTS_CLK_CTO_delay241
+ n218 VSS VDD_1V8 latchtriestado_733
Xlatches1_9__latches2_1__latchesa Din[1] Dout1[1] Dout2[1] n294 n260 CTS_CLK_CTO_delay241
+ n218 VSS VDD_1V8 latchtriestado_734
Xlatches1_9__latches2_0__latchesa Din[0] Dout1[0] Dout2[0] n294 n260 CTS_CLK_CTO_delay241
+ n95 VSS VDD_1V8 latchtriestado_735
Xlatches1_8__latches2_31__latchesa Din[31] Dout1[31] Dout2[31] n295 n261 Sal_and_write[8]
+ n5 VSS VDD_1V8 latchtriestado_736
Xlatches1_8__latches2_30__latchesa Din[30] Dout1[30] Dout2[30] n295 n261 Sal_and_write[8]
+ n218 VSS VDD_1V8 latchtriestado_737
Xlatches1_8__latches2_29__latchesa Din[29] Dout1[29] Dout2[29] n295 n261 Sal_and_write[8]
+ n127 VSS VDD_1V8 latchtriestado_738
Xlatches1_8__latches2_28__latchesa Din[28] Dout1[28] Dout2[28] n295 n261 Sal_and_write[8]
+ n73 VSS VDD_1V8 latchtriestado_739
Xlatches1_8__latches2_27__latchesa Din[27] Dout1[27] Dout2[27] n295 n261 Sal_and_write[8]
+ n73 VSS VDD_1V8 latchtriestado_740
Xlatches1_8__latches2_26__latchesa Din[26] Dout1[26] Dout2[26] n295 n261 Sal_and_write[8]
+ n73 VSS VDD_1V8 latchtriestado_741
Xlatches1_8__latches2_25__latchesa Din[25] Dout1[25] Dout2[25] n295 n261 Sal_and_write[8]
+ n127 VSS VDD_1V8 latchtriestado_742
Xlatches1_8__latches2_24__latchesa Din[24] Dout1[24] Dout2[24] n295 n261 Sal_and_write[8]
+ n73 VSS VDD_1V8 latchtriestado_743
Xlatches1_8__latches2_23__latchesa Din[23] Dout1[23] Dout2[23] n295 n261 Sal_and_write[8]
+ n127 VSS VDD_1V8 latchtriestado_744
Xlatches1_8__latches2_22__latchesa Din[22] Dout1[22] Dout2[22] n295 n261 Sal_and_write[8]
+ n73 VSS VDD_1V8 latchtriestado_745
Xlatches1_8__latches2_21__latchesa Din[21] Dout1[21] Dout2[21] n295 n261 Sal_and_write[8]
+ n127 VSS VDD_1V8 latchtriestado_746
Xlatches1_8__latches2_20__latchesa Din[20] Dout1[20] Dout2[20] n295 n261 Sal_and_write[8]
+ n95 VSS VDD_1V8 latchtriestado_747
Xlatches1_8__latches2_19__latchesa Din[19] Dout1[19] Dout2[19] n295 n261 Sal_and_write[8]
+ n95 VSS VDD_1V8 latchtriestado_748
Xlatches1_8__latches2_18__latchesa Din[18] Dout1[18] Dout2[18] n295 n261 Sal_and_write[8]
+ n5 VSS VDD_1V8 latchtriestado_749
Xlatches1_8__latches2_17__latchesa Din[17] Dout1[17] Dout2[17] n295 n261 Sal_and_write[8]
+ n95 VSS VDD_1V8 latchtriestado_750
Xlatches1_8__latches2_16__latchesa Din[16] Dout1[16] Dout2[16] n295 n261 Sal_and_write[8]
+ n95 VSS VDD_1V8 latchtriestado_751
Xlatches1_8__latches2_15__latchesa Din[15] Dout1[15] Dout2[15] n295 n261 Sal_and_write[8]
+ n29 VSS VDD_1V8 latchtriestado_752
Xlatches1_8__latches2_14__latchesa Din[14] Dout1[14] Dout2[14] n295 n261 Sal_and_write[8]
+ n218 VSS VDD_1V8 latchtriestado_753
Xlatches1_8__latches2_13__latchesa Din[13] Dout1[13] Dout2[13] n295 n261 Sal_and_write[8]
+ n218 VSS VDD_1V8 latchtriestado_754
Xlatches1_8__latches2_12__latchesa Din[12] Dout1[12] Dout2[12] n295 n261 Sal_and_write[8]
+ IN37 VSS VDD_1V8 latchtriestado_755
Xlatches1_8__latches2_11__latchesa Din[11] Dout1[11] Dout2[11] n295 n261 Sal_and_write[8]
+ rst VSS VDD_1V8 latchtriestado_756
Xlatches1_8__latches2_10__latchesa Din[10] Dout1[10] Dout2[10] n295 n261 Sal_and_write[8]
+ IN174 VSS VDD_1V8 latchtriestado_757
Xlatches1_8__latches2_9__latchesa Din[9] Dout1[9] Dout2[9] n295 n261 Sal_and_write[8]
+ n75 VSS VDD_1V8 latchtriestado_758
Xlatches1_8__latches2_8__latchesa Din[8] Dout1[8] Dout2[8] n295 n261 Sal_and_write[8]
+ IN41 VSS VDD_1V8 latchtriestado_759
Xlatches1_8__latches2_7__latchesa Din[7] Dout1[7] Dout2[7] n295 n261 Sal_and_write[8]
+ IN36 VSS VDD_1V8 latchtriestado_760
Xlatches1_8__latches2_6__latchesa Din[6] Dout1[6] Dout2[6] n295 n261 Sal_and_write[8]
+ IN39 VSS VDD_1V8 latchtriestado_761
Xlatches1_8__latches2_5__latchesa Din[5] Dout1[5] Dout2[5] n295 n261 Sal_and_write[8]
+ IN34 VSS VDD_1V8 latchtriestado_762
Xlatches1_8__latches2_4__latchesa Din[4] Dout1[4] Dout2[4] n295 n261 Sal_and_write[8]
+ n75 VSS VDD_1V8 latchtriestado_763
Xlatches1_8__latches2_3__latchesa Din[3] Dout1[3] Dout2[3] n295 n261 Sal_and_write[8]
+ n95 VSS VDD_1V8 latchtriestado_764
Xlatches1_8__latches2_2__latchesa Din[2] Dout1[2] Dout2[2] n295 n261 Sal_and_write[8]
+ n75 VSS VDD_1V8 latchtriestado_765
Xlatches1_8__latches2_1__latchesa Din[1] Dout1[1] Dout2[1] n295 n261 Sal_and_write[8]
+ n75 VSS VDD_1V8 latchtriestado_766
Xlatches1_8__latches2_0__latchesa Din[0] Dout1[0] Dout2[0] n295 n261 Sal_and_write[8]
+ n126 VSS VDD_1V8 latchtriestado_767
Xlatches1_7__latches2_31__latchesa Din[31] Dout1[31] Dout2[31] n296 n262 CTS_CLK_CTO_delay321
+ n128 VSS VDD_1V8 latchtriestado_768
Xlatches1_7__latches2_30__latchesa Din[30] Dout1[30] Dout2[30] n296 n262 CTS_CLK_CTO_delay321
+ n75 VSS VDD_1V8 latchtriestado_769
Xlatches1_7__latches2_29__latchesa Din[29] Dout1[29] Dout2[29] n296 n262 CTS_CLK_CTO_delay321
+ IN123 VSS VDD_1V8 latchtriestado_770
Xlatches1_7__latches2_28__latchesa Din[28] Dout1[28] Dout2[28] n296 n262 CTS_CLK_CTO_delay321
+ n96 VSS VDD_1V8 latchtriestado_771
Xlatches1_7__latches2_27__latchesa Din[27] Dout1[27] Dout2[27] n296 n262 CTS_CLK_CTO_delay321
+ n128 VSS VDD_1V8 latchtriestado_772
Xlatches1_7__latches2_26__latchesa Din[26] Dout1[26] Dout2[26] n296 n262 CTS_CLK_CTO_delay321
+ IN118 VSS VDD_1V8 latchtriestado_773
Xlatches1_7__latches2_25__latchesa Din[25] Dout1[25] Dout2[25] n296 n262 CTS_CLK_CTO_delay321
+ n96 VSS VDD_1V8 latchtriestado_774
Xlatches1_7__latches2_24__latchesa Din[24] Dout1[24] Dout2[24] n296 n262 CTS_CLK_CTO_delay321
+ n96 VSS VDD_1V8 latchtriestado_775
Xlatches1_7__latches2_23__latchesa Din[23] Dout1[23] Dout2[23] n296 n262 CTS_CLK_CTO_delay321
+ n127 VSS VDD_1V8 latchtriestado_776
Xlatches1_7__latches2_22__latchesa Din[22] Dout1[22] Dout2[22] n296 n262 CTS_CLK_CTO_delay321
+ n96 VSS VDD_1V8 latchtriestado_777
Xlatches1_7__latches2_21__latchesa Din[21] Dout1[21] Dout2[21] n296 n262 CTS_CLK_CTO_delay321
+ n94 VSS VDD_1V8 latchtriestado_778
Xlatches1_7__latches2_20__latchesa Din[20] Dout1[20] Dout2[20] n296 n262 CTS_CLK_CTO_delay321
+ n94 VSS VDD_1V8 latchtriestado_779
Xlatches1_7__latches2_19__latchesa Din[19] Dout1[19] Dout2[19] n296 n262 CTS_CLK_CTO_delay321
+ n74 VSS VDD_1V8 latchtriestado_780
Xlatches1_7__latches2_18__latchesa Din[18] Dout1[18] Dout2[18] n296 n262 CTS_CLK_CTO_delay321
+ n127 VSS VDD_1V8 latchtriestado_781
Xlatches1_7__latches2_17__latchesa Din[17] Dout1[17] Dout2[17] n296 n262 CTS_CLK_CTO_delay321
+ n94 VSS VDD_1V8 latchtriestado_782
Xlatches1_7__latches2_16__latchesa Din[16] Dout1[16] Dout2[16] n296 n262 CTS_CLK_CTO_delay321
+ n4 VSS VDD_1V8 latchtriestado_783
Xlatches1_7__latches2_15__latchesa Din[15] Dout1[15] Dout2[15] n296 n262 CTS_CLK_CTO_delay321
+ n29 VSS VDD_1V8 latchtriestado_784
Xlatches1_7__latches2_14__latchesa Din[14] Dout1[14] Dout2[14] n296 n262 CTS_CLK_CTO_delay321
+ n29 VSS VDD_1V8 latchtriestado_785
Xlatches1_7__latches2_13__latchesa Din[13] Dout1[13] Dout2[13] n296 n262 CTS_CLK_CTO_delay321
+ n29 VSS VDD_1V8 latchtriestado_786
Xlatches1_7__latches2_12__latchesa Din[12] Dout1[12] Dout2[12] n296 n262 CTS_CLK_CTO_delay321
+ n129 VSS VDD_1V8 latchtriestado_787
Xlatches1_7__latches2_11__latchesa Din[11] Dout1[11] Dout2[11] n296 n262 CTS_CLK_CTO_delay321
+ IN150 VSS VDD_1V8 latchtriestado_788
Xlatches1_7__latches2_10__latchesa Din[10] Dout1[10] Dout2[10] n296 n262 CTS_CLK_CTO_delay321
+ IN140 VSS VDD_1V8 latchtriestado_789
Xlatches1_7__latches2_9__latchesa Din[9] Dout1[9] Dout2[9] n296 n262 CTS_CLK_CTO_delay321
+ n130 VSS VDD_1V8 latchtriestado_790
Xlatches1_7__latches2_8__latchesa Din[8] Dout1[8] Dout2[8] n296 n262 CTS_CLK_CTO_delay321
+ n129 VSS VDD_1V8 latchtriestado_791
Xlatches1_7__latches2_7__latchesa Din[7] Dout1[7] Dout2[7] n296 n262 CTS_CLK_CTO_delay321
+ n129 VSS VDD_1V8 latchtriestado_792
Xlatches1_7__latches2_6__latchesa Din[6] Dout1[6] Dout2[6] n296 n262 CTS_CLK_CTO_delay321
+ n129 VSS VDD_1V8 latchtriestado_793
Xlatches1_7__latches2_5__latchesa Din[5] Dout1[5] Dout2[5] n296 n262 CTS_CLK_CTO_delay321
+ n129 VSS VDD_1V8 latchtriestado_794
Xlatches1_7__latches2_4__latchesa Din[4] Dout1[4] Dout2[4] n296 n262 CTS_CLK_CTO_delay321
+ n218 VSS VDD_1V8 latchtriestado_795
Xlatches1_7__latches2_3__latchesa Din[3] Dout1[3] Dout2[3] n296 n262 CTS_CLK_CTO_delay321
+ n5 VSS VDD_1V8 latchtriestado_796
Xlatches1_7__latches2_2__latchesa Din[2] Dout1[2] Dout2[2] n296 n262 CTS_CLK_CTO_delay321
+ n129 VSS VDD_1V8 latchtriestado_797
Xlatches1_7__latches2_1__latchesa Din[1] Dout1[1] Dout2[1] n296 n262 CTS_CLK_CTO_delay321
+ IN154 VSS VDD_1V8 latchtriestado_798
Xlatches1_7__latches2_0__latchesa Din[0] Dout1[0] Dout2[0] n296 n262 CTS_CLK_CTO_delay321
+ IN112 VSS VDD_1V8 latchtriestado_799
Xlatches1_6__latches2_31__latchesa Din[31] Dout1[31] Dout2[31] n297 n263 CTS_CLK_CTO_delay381
+ n94 VSS VDD_1V8 latchtriestado_800
Xlatches1_6__latches2_30__latchesa Din[30] Dout1[30] Dout2[30] n297 n263 CTS_CLK_CTO_delay381
+ n29 VSS VDD_1V8 latchtriestado_801
Xlatches1_6__latches2_29__latchesa Din[29] Dout1[29] Dout2[29] n297 n263 CTS_CLK_CTO_delay381
+ n128 VSS VDD_1V8 latchtriestado_802
Xlatches1_6__latches2_28__latchesa Din[28] Dout1[28] Dout2[28] n297 n263 CTS_CLK_CTO_delay381
+ n93 VSS VDD_1V8 latchtriestado_803
Xlatches1_6__latches2_27__latchesa Din[27] Dout1[27] Dout2[27] n297 n263 CTS_CLK_CTO_delay381
+ n128 VSS VDD_1V8 latchtriestado_804
Xlatches1_6__latches2_26__latchesa Din[26] Dout1[26] Dout2[26] n297 n263 CTS_CLK_CTO_delay381
+ n93 VSS VDD_1V8 latchtriestado_805
Xlatches1_6__latches2_25__latchesa Din[25] Dout1[25] Dout2[25] n297 n263 CTS_CLK_CTO_delay381
+ n128 VSS VDD_1V8 latchtriestado_806
Xlatches1_6__latches2_24__latchesa Din[24] Dout1[24] Dout2[24] n297 n263 CTS_CLK_CTO_delay381
+ n128 VSS VDD_1V8 latchtriestado_807
Xlatches1_6__latches2_23__latchesa Din[23] Dout1[23] Dout2[23] n297 n263 CTS_CLK_CTO_delay381
+ n128 VSS VDD_1V8 latchtriestado_808
Xlatches1_6__latches2_22__latchesa Din[22] Dout1[22] Dout2[22] n297 n263 CTS_CLK_CTO_delay381
+ n93 VSS VDD_1V8 latchtriestado_809
Xlatches1_6__latches2_21__latchesa Din[21] Dout1[21] Dout2[21] n297 n263 CTS_CLK_CTO_delay381
+ n93 VSS VDD_1V8 latchtriestado_810
Xlatches1_6__latches2_20__latchesa Din[20] Dout1[20] Dout2[20] n297 n263 CTS_CLK_CTO_delay381
+ n94 VSS VDD_1V8 latchtriestado_811
Xlatches1_6__latches2_19__latchesa Din[19] Dout1[19] Dout2[19] n297 n263 CTS_CLK_CTO_delay381
+ n128 VSS VDD_1V8 latchtriestado_812
Xlatches1_6__latches2_18__latchesa Din[18] Dout1[18] Dout2[18] n297 n263 CTS_CLK_CTO_delay381
+ n5 VSS VDD_1V8 latchtriestado_813
Xlatches1_6__latches2_17__latchesa Din[17] Dout1[17] Dout2[17] n297 n263 CTS_CLK_CTO_delay381
+ n5 VSS VDD_1V8 latchtriestado_814
Xlatches1_6__latches2_16__latchesa Din[16] Dout1[16] Dout2[16] n297 n263 CTS_CLK_CTO_delay381
+ n94 VSS VDD_1V8 latchtriestado_815
Xlatches1_6__latches2_15__latchesa Din[15] Dout1[15] Dout2[15] n297 n263 CTS_CLK_CTO_delay381
+ n29 VSS VDD_1V8 latchtriestado_816
Xlatches1_6__latches2_14__latchesa Din[14] Dout1[14] Dout2[14] n297 n263 CTS_CLK_CTO_delay381
+ n29 VSS VDD_1V8 latchtriestado_817
Xlatches1_6__latches2_13__latchesa Din[13] Dout1[13] Dout2[13] n297 n263 CTS_CLK_CTO_delay381
+ IN57 VSS VDD_1V8 latchtriestado_818
Xlatches1_6__latches2_12__latchesa Din[12] Dout1[12] Dout2[12] n297 n263 CTS_CLK_CTO_delay381
+ IN171 VSS VDD_1V8 latchtriestado_819
Xlatches1_6__latches2_11__latchesa Din[11] Dout1[11] Dout2[11] n297 n263 CTS_CLK_CTO_delay381
+ IN151 VSS VDD_1V8 latchtriestado_820
Xlatches1_6__latches2_10__latchesa Din[10] Dout1[10] Dout2[10] n297 n263 CTS_CLK_CTO_delay381
+ IN144 VSS VDD_1V8 latchtriestado_821
Xlatches1_6__latches2_9__latchesa Din[9] Dout1[9] Dout2[9] n297 n263 CTS_CLK_CTO_delay381
+ n218 VSS VDD_1V8 latchtriestado_822
Xlatches1_6__latches2_8__latchesa Din[8] Dout1[8] Dout2[8] n297 n263 CTS_CLK_CTO_delay381
+ IN165 VSS VDD_1V8 latchtriestado_823
Xlatches1_6__latches2_7__latchesa Din[7] Dout1[7] Dout2[7] n297 n263 CTS_CLK_CTO_delay381
+ IN192 VSS VDD_1V8 latchtriestado_824
Xlatches1_6__latches2_6__latchesa Din[6] Dout1[6] Dout2[6] n297 n263 CTS_CLK_CTO_delay381
+ IN170 VSS VDD_1V8 latchtriestado_825
Xlatches1_6__latches2_5__latchesa Din[5] Dout1[5] Dout2[5] n297 n263 CTS_CLK_CTO_delay381
+ IN162 VSS VDD_1V8 latchtriestado_826
Xlatches1_6__latches2_4__latchesa Din[4] Dout1[4] Dout2[4] n297 n263 CTS_CLK_CTO_delay381
+ n218 VSS VDD_1V8 latchtriestado_827
Xlatches1_6__latches2_3__latchesa Din[3] Dout1[3] Dout2[3] n297 n263 CTS_CLK_CTO_delay381
+ IN58 VSS VDD_1V8 latchtriestado_828
Xlatches1_6__latches2_2__latchesa Din[2] Dout1[2] Dout2[2] n297 n263 CTS_CLK_CTO_delay381
+ IN68 VSS VDD_1V8 latchtriestado_829
Xlatches1_6__latches2_1__latchesa Din[1] Dout1[1] Dout2[1] n297 n263 CTS_CLK_CTO_delay381
+ IN156 VSS VDD_1V8 latchtriestado_830
Xlatches1_6__latches2_0__latchesa Din[0] Dout1[0] Dout2[0] n297 n263 CTS_CLK_CTO_delay381
+ n218 VSS VDD_1V8 latchtriestado_831
Xlatches1_5__latches2_31__latchesa Din[31] Dout1[31] Dout2[31] n302 n268 Sal_and_write[5]
+ n126 VSS VDD_1V8 latchtriestado_832
Xlatches1_5__latches2_30__latchesa Din[30] Dout1[30] Dout2[30] n302 n268 Sal_and_write[5]
+ n30 VSS VDD_1V8 latchtriestado_833
Xlatches1_5__latches2_29__latchesa Din[29] Dout1[29] Dout2[29] n302 n268 Sal_and_write[5]
+ n74 VSS VDD_1V8 latchtriestado_834
Xlatches1_5__latches2_28__latchesa Din[28] Dout1[28] Dout2[28] n302 n268 Sal_and_write[5]
+ n73 VSS VDD_1V8 latchtriestado_835
Xlatches1_5__latches2_27__latchesa Din[27] Dout1[27] Dout2[27] n302 n268 Sal_and_write[5]
+ n74 VSS VDD_1V8 latchtriestado_836
Xlatches1_5__latches2_26__latchesa Din[26] Dout1[26] Dout2[26] n302 n268 Sal_and_write[5]
+ n73 VSS VDD_1V8 latchtriestado_837
Xlatches1_5__latches2_25__latchesa Din[25] Dout1[25] Dout2[25] n302 n268 Sal_and_write[5]
+ n128 VSS VDD_1V8 latchtriestado_838
Xlatches1_5__latches2_24__latchesa Din[24] Dout1[24] Dout2[24] n302 n268 Sal_and_write[5]
+ n128 VSS VDD_1V8 latchtriestado_839
Xlatches1_5__latches2_23__latchesa Din[23] Dout1[23] Dout2[23] n302 n268 Sal_and_write[5]
+ n74 VSS VDD_1V8 latchtriestado_840
Xlatches1_5__latches2_22__latchesa Din[22] Dout1[22] Dout2[22] n302 n268 Sal_and_write[5]
+ n128 VSS VDD_1V8 latchtriestado_841
Xlatches1_5__latches2_21__latchesa Din[21] Dout1[21] Dout2[21] n302 n268 Sal_and_write[5]
+ n128 VSS VDD_1V8 latchtriestado_842
Xlatches1_5__latches2_20__latchesa Din[20] Dout1[20] Dout2[20] n302 n268 Sal_and_write[5]
+ n5 VSS VDD_1V8 latchtriestado_843
Xlatches1_5__latches2_19__latchesa Din[19] Dout1[19] Dout2[19] n302 n268 Sal_and_write[5]
+ n74 VSS VDD_1V8 latchtriestado_844
Xlatches1_5__latches2_18__latchesa Din[18] Dout1[18] Dout2[18] n302 n268 Sal_and_write[5]
+ n5 VSS VDD_1V8 latchtriestado_845
Xlatches1_5__latches2_17__latchesa Din[17] Dout1[17] Dout2[17] n302 n268 Sal_and_write[5]
+ n5 VSS VDD_1V8 latchtriestado_846
Xlatches1_5__latches2_16__latchesa Din[16] Dout1[16] Dout2[16] n302 n268 Sal_and_write[5]
+ n5 VSS VDD_1V8 latchtriestado_847
Xlatches1_5__latches2_15__latchesa Din[15] Dout1[15] Dout2[15] n302 n268 Sal_and_write[5]
+ n218 VSS VDD_1V8 latchtriestado_848
Xlatches1_5__latches2_14__latchesa Din[14] Dout1[14] Dout2[14] n302 n268 Sal_and_write[5]
+ n218 VSS VDD_1V8 latchtriestado_849
Xlatches1_5__latches2_13__latchesa Din[13] Dout1[13] Dout2[13] n302 n268 Sal_and_write[5]
+ n218 VSS VDD_1V8 latchtriestado_850
Xlatches1_5__latches2_12__latchesa Din[12] Dout1[12] Dout2[12] n302 n268 Sal_and_write[5]
+ IN35 VSS VDD_1V8 latchtriestado_851
Xlatches1_5__latches2_11__latchesa Din[11] Dout1[11] Dout2[11] n302 n268 Sal_and_write[5]
+ IN169 VSS VDD_1V8 latchtriestado_852
Xlatches1_5__latches2_10__latchesa Din[10] Dout1[10] Dout2[10] n302 n268 Sal_and_write[5]
+ IN148 VSS VDD_1V8 latchtriestado_853
Xlatches1_5__latches2_9__latchesa Din[9] Dout1[9] Dout2[9] n302 n268 Sal_and_write[5]
+ n130 VSS VDD_1V8 latchtriestado_854
Xlatches1_5__latches2_8__latchesa Din[8] Dout1[8] Dout2[8] n302 n268 Sal_and_write[5]
+ IN42 VSS VDD_1V8 latchtriestado_855
Xlatches1_5__latches2_7__latchesa Din[7] Dout1[7] Dout2[7] n302 n268 Sal_and_write[5]
+ IN38 VSS VDD_1V8 latchtriestado_856
Xlatches1_5__latches2_6__latchesa Din[6] Dout1[6] Dout2[6] n302 n268 Sal_and_write[5]
+ IN40 VSS VDD_1V8 latchtriestado_857
Xlatches1_5__latches2_5__latchesa Din[5] Dout1[5] Dout2[5] n302 n268 Sal_and_write[5]
+ IN33 VSS VDD_1V8 latchtriestado_858
Xlatches1_5__latches2_4__latchesa Din[4] Dout1[4] Dout2[4] n302 n268 Sal_and_write[5]
+ n75 VSS VDD_1V8 latchtriestado_859
Xlatches1_5__latches2_3__latchesa Din[3] Dout1[3] Dout2[3] n302 n268 Sal_and_write[5]
+ n128 VSS VDD_1V8 latchtriestado_860
Xlatches1_5__latches2_2__latchesa Din[2] Dout1[2] Dout2[2] n302 n268 Sal_and_write[5]
+ n75 VSS VDD_1V8 latchtriestado_861
Xlatches1_5__latches2_1__latchesa Din[1] Dout1[1] Dout2[1] n302 n268 Sal_and_write[5]
+ n130 VSS VDD_1V8 latchtriestado_862
Xlatches1_5__latches2_0__latchesa Din[0] Dout1[0] Dout2[0] n302 n268 Sal_and_write[5]
+ n126 VSS VDD_1V8 latchtriestado_863
Xlatches1_4__latches2_31__latchesa Din[31] Dout1[31] Dout2[31] n303 n269 Sal_and_write[4]
+ n95 VSS VDD_1V8 latchtriestado_864
Xlatches1_4__latches2_30__latchesa Din[30] Dout1[30] Dout2[30] n303 n269 Sal_and_write[4]
+ n29 VSS VDD_1V8 latchtriestado_865
Xlatches1_4__latches2_29__latchesa Din[29] Dout1[29] Dout2[29] n303 n269 Sal_and_write[4]
+ n128 VSS VDD_1V8 latchtriestado_866
Xlatches1_4__latches2_28__latchesa Din[28] Dout1[28] Dout2[28] n303 n269 Sal_and_write[4]
+ n93 VSS VDD_1V8 latchtriestado_867
Xlatches1_4__latches2_27__latchesa Din[27] Dout1[27] Dout2[27] n303 n269 Sal_and_write[4]
+ n73 VSS VDD_1V8 latchtriestado_868
Xlatches1_4__latches2_26__latchesa Din[26] Dout1[26] Dout2[26] n303 n269 Sal_and_write[4]
+ IN116 VSS VDD_1V8 latchtriestado_869
Xlatches1_4__latches2_25__latchesa Din[25] Dout1[25] Dout2[25] n303 n269 Sal_and_write[4]
+ n73 VSS VDD_1V8 latchtriestado_870
Xlatches1_4__latches2_24__latchesa Din[24] Dout1[24] Dout2[24] n303 n269 Sal_and_write[4]
+ n96 VSS VDD_1V8 latchtriestado_871
Xlatches1_4__latches2_23__latchesa Din[23] Dout1[23] Dout2[23] n303 n269 Sal_and_write[4]
+ n73 VSS VDD_1V8 latchtriestado_872
Xlatches1_4__latches2_22__latchesa Din[22] Dout1[22] Dout2[22] n303 n269 Sal_and_write[4]
+ n93 VSS VDD_1V8 latchtriestado_873
Xlatches1_4__latches2_21__latchesa Din[21] Dout1[21] Dout2[21] n303 n269 Sal_and_write[4]
+ n128 VSS VDD_1V8 latchtriestado_874
Xlatches1_4__latches2_20__latchesa Din[20] Dout1[20] Dout2[20] n303 n269 Sal_and_write[4]
+ n95 VSS VDD_1V8 latchtriestado_875
Xlatches1_4__latches2_19__latchesa Din[19] Dout1[19] Dout2[19] n303 n269 Sal_and_write[4]
+ n128 VSS VDD_1V8 latchtriestado_876
Xlatches1_4__latches2_18__latchesa Din[18] Dout1[18] Dout2[18] n303 n269 Sal_and_write[4]
+ n94 VSS VDD_1V8 latchtriestado_877
Xlatches1_4__latches2_17__latchesa Din[17] Dout1[17] Dout2[17] n303 n269 Sal_and_write[4]
+ n94 VSS VDD_1V8 latchtriestado_878
Xlatches1_4__latches2_16__latchesa Din[16] Dout1[16] Dout2[16] n303 n269 Sal_and_write[4]
+ n94 VSS VDD_1V8 latchtriestado_879
Xlatches1_4__latches2_15__latchesa Din[15] Dout1[15] Dout2[15] n303 n269 Sal_and_write[4]
+ n4 VSS VDD_1V8 latchtriestado_880
Xlatches1_4__latches2_14__latchesa Din[14] Dout1[14] Dout2[14] n303 n269 Sal_and_write[4]
+ n4 VSS VDD_1V8 latchtriestado_881
Xlatches1_4__latches2_13__latchesa Din[13] Dout1[13] Dout2[13] n303 n269 Sal_and_write[4]
+ n4 VSS VDD_1V8 latchtriestado_882
Xlatches1_4__latches2_12__latchesa Din[12] Dout1[12] Dout2[12] n303 n269 Sal_and_write[4]
+ IN173 VSS VDD_1V8 latchtriestado_883
Xlatches1_4__latches2_11__latchesa Din[11] Dout1[11] Dout2[11] n303 n269 Sal_and_write[4]
+ IN84 VSS VDD_1V8 latchtriestado_884
Xlatches1_4__latches2_10__latchesa Din[10] Dout1[10] Dout2[10] n303 n269 Sal_and_write[4]
+ IN159 VSS VDD_1V8 latchtriestado_885
Xlatches1_4__latches2_9__latchesa Din[9] Dout1[9] Dout2[9] n303 n269 Sal_and_write[4]
+ n30 VSS VDD_1V8 latchtriestado_886
Xlatches1_4__latches2_8__latchesa Din[8] Dout1[8] Dout2[8] n303 n269 Sal_and_write[4]
+ IN164 VSS VDD_1V8 latchtriestado_887
Xlatches1_4__latches2_7__latchesa Din[7] Dout1[7] Dout2[7] n303 n269 Sal_and_write[4]
+ IN166 VSS VDD_1V8 latchtriestado_888
Xlatches1_4__latches2_6__latchesa Din[6] Dout1[6] Dout2[6] n303 n269 Sal_and_write[4]
+ IN172 VSS VDD_1V8 latchtriestado_889
Xlatches1_4__latches2_5__latchesa Din[5] Dout1[5] Dout2[5] n303 n269 Sal_and_write[4]
+ IN163 VSS VDD_1V8 latchtriestado_890
Xlatches1_4__latches2_4__latchesa Din[4] Dout1[4] Dout2[4] n303 n269 Sal_and_write[4]
+ n29 VSS VDD_1V8 latchtriestado_891
Xlatches1_4__latches2_3__latchesa Din[3] Dout1[3] Dout2[3] n303 n269 Sal_and_write[4]
+ n94 VSS VDD_1V8 latchtriestado_892
Xlatches1_4__latches2_2__latchesa Din[2] Dout1[2] Dout2[2] n303 n269 Sal_and_write[4]
+ n218 VSS VDD_1V8 latchtriestado_893
Xlatches1_4__latches2_1__latchesa Din[1] Dout1[1] Dout2[1] n303 n269 Sal_and_write[4]
+ IN158 VSS VDD_1V8 latchtriestado_894
Xlatches1_4__latches2_0__latchesa Din[0] Dout1[0] Dout2[0] n303 n269 Sal_and_write[4]
+ n4 VSS VDD_1V8 latchtriestado_895
Xlatches1_3__latches2_31__latchesa Din[31] Dout1[31] Dout2[31] n300 n266 CTS_CLK_CTO_delay341
+ IN132 VSS VDD_1V8 latchtriestado_896
Xlatches1_3__latches2_30__latchesa Din[30] Dout1[30] Dout2[30] n300 n266 CTS_CLK_CTO_delay341
+ IN111 VSS VDD_1V8 latchtriestado_897
Xlatches1_3__latches2_29__latchesa Din[29] Dout1[29] Dout2[29] n300 n266 CTS_CLK_CTO_delay341
+ n94 VSS VDD_1V8 latchtriestado_898
Xlatches1_3__latches2_28__latchesa Din[28] Dout1[28] Dout2[28] n300 n266 CTS_CLK_CTO_delay341
+ n96 VSS VDD_1V8 latchtriestado_899
Xlatches1_3__latches2_27__latchesa Din[27] Dout1[27] Dout2[27] n300 n266 CTS_CLK_CTO_delay341
+ n73 VSS VDD_1V8 latchtriestado_900
Xlatches1_3__latches2_26__latchesa Din[26] Dout1[26] Dout2[26] n300 n266 CTS_CLK_CTO_delay341
+ n96 VSS VDD_1V8 latchtriestado_901
Xlatches1_3__latches2_25__latchesa Din[25] Dout1[25] Dout2[25] n300 n266 CTS_CLK_CTO_delay341
+ n73 VSS VDD_1V8 latchtriestado_902
Xlatches1_3__latches2_24__latchesa Din[24] Dout1[24] Dout2[24] n300 n266 CTS_CLK_CTO_delay341
+ n73 VSS VDD_1V8 latchtriestado_903
Xlatches1_3__latches2_23__latchesa Din[23] Dout1[23] Dout2[23] n300 n266 CTS_CLK_CTO_delay341
+ n93 VSS VDD_1V8 latchtriestado_904
Xlatches1_3__latches2_22__latchesa Din[22] Dout1[22] Dout2[22] n300 n266 CTS_CLK_CTO_delay341
+ n93 VSS VDD_1V8 latchtriestado_905
Xlatches1_3__latches2_21__latchesa Din[21] Dout1[21] Dout2[21] n300 n266 CTS_CLK_CTO_delay341
+ n93 VSS VDD_1V8 latchtriestado_906
Xlatches1_3__latches2_20__latchesa Din[20] Dout1[20] Dout2[20] n300 n266 CTS_CLK_CTO_delay341
+ n95 VSS VDD_1V8 latchtriestado_907
Xlatches1_3__latches2_19__latchesa Din[19] Dout1[19] Dout2[19] n300 n266 CTS_CLK_CTO_delay341
+ n93 VSS VDD_1V8 latchtriestado_908
Xlatches1_3__latches2_18__latchesa Din[18] Dout1[18] Dout2[18] n300 n266 CTS_CLK_CTO_delay341
+ IN92 VSS VDD_1V8 latchtriestado_909
Xlatches1_3__latches2_17__latchesa Din[17] Dout1[17] Dout2[17] n300 n266 CTS_CLK_CTO_delay341
+ IN61 VSS VDD_1V8 latchtriestado_910
Xlatches1_3__latches2_16__latchesa Din[16] Dout1[16] Dout2[16] n300 n266 CTS_CLK_CTO_delay341
+ IN106 VSS VDD_1V8 latchtriestado_911
Xlatches1_3__latches2_15__latchesa Din[15] Dout1[15] Dout2[15] n300 n266 CTS_CLK_CTO_delay341
+ n29 VSS VDD_1V8 latchtriestado_912
Xlatches1_3__latches2_14__latchesa Din[14] Dout1[14] Dout2[14] n300 n266 CTS_CLK_CTO_delay341
+ n4 VSS VDD_1V8 latchtriestado_913
Xlatches1_3__latches2_13__latchesa Din[13] Dout1[13] Dout2[13] n300 n266 CTS_CLK_CTO_delay341
+ n4 VSS VDD_1V8 latchtriestado_914
Xlatches1_3__latches2_12__latchesa Din[12] Dout1[12] Dout2[12] n300 n266 CTS_CLK_CTO_delay341
+ IN188 VSS VDD_1V8 latchtriestado_915
Xlatches1_3__latches2_11__latchesa Din[11] Dout1[11] Dout2[11] n300 n266 CTS_CLK_CTO_delay341
+ IN2 VSS VDD_1V8 latchtriestado_916
Xlatches1_3__latches2_10__latchesa Din[10] Dout1[10] Dout2[10] n300 n266 CTS_CLK_CTO_delay341
+ n29 VSS VDD_1V8 latchtriestado_917
Xlatches1_3__latches2_9__latchesa Din[9] Dout1[9] Dout2[9] n300 n266 CTS_CLK_CTO_delay341
+ IN23 VSS VDD_1V8 latchtriestado_918
Xlatches1_3__latches2_8__latchesa Din[8] Dout1[8] Dout2[8] n300 n266 CTS_CLK_CTO_delay341
+ IN190 VSS VDD_1V8 latchtriestado_919
Xlatches1_3__latches2_7__latchesa Din[7] Dout1[7] Dout2[7] n300 n266 CTS_CLK_CTO_delay341
+ IN189 VSS VDD_1V8 latchtriestado_920
Xlatches1_3__latches2_6__latchesa Din[6] Dout1[6] Dout2[6] n300 n266 CTS_CLK_CTO_delay341
+ IN196 VSS VDD_1V8 latchtriestado_921
Xlatches1_3__latches2_5__latchesa Din[5] Dout1[5] Dout2[5] n300 n266 CTS_CLK_CTO_delay341
+ IN191 VSS VDD_1V8 latchtriestado_922
Xlatches1_3__latches2_4__latchesa Din[4] Dout1[4] Dout2[4] n300 n266 CTS_CLK_CTO_delay341
+ n95 VSS VDD_1V8 latchtriestado_923
Xlatches1_3__latches2_3__latchesa Din[3] Dout1[3] Dout2[3] n300 n266 CTS_CLK_CTO_delay341
+ IN97 VSS VDD_1V8 latchtriestado_924
Xlatches1_3__latches2_2__latchesa Din[2] Dout1[2] Dout2[2] n300 n266 CTS_CLK_CTO_delay341
+ n29 VSS VDD_1V8 latchtriestado_925
Xlatches1_3__latches2_1__latchesa Din[1] Dout1[1] Dout2[1] n300 n266 CTS_CLK_CTO_delay341
+ IN180 VSS VDD_1V8 latchtriestado_926
Xlatches1_3__latches2_0__latchesa Din[0] Dout1[0] Dout2[0] n300 n266 CTS_CLK_CTO_delay341
+ n29 VSS VDD_1V8 latchtriestado_927
Xlatches1_2__latches2_31__latchesa Din[31] Dout1[31] Dout2[31] n301 n2 Sal_and_write[2]
+ n126 VSS VDD_1V8 latchtriestado_928
Xlatches1_2__latches2_30__latchesa Din[30] Dout1[30] Dout2[30] n301 n2 Sal_and_write[2]
+ n75 VSS VDD_1V8 latchtriestado_929
Xlatches1_2__latches2_29__latchesa Din[29] Dout1[29] Dout2[29] n301 conect_deco_latch2[2]
+ Sal_and_write[2] n74 VSS VDD_1V8 latchtriestado_930
Xlatches1_2__latches2_28__latchesa Din[28] Dout1[28] Dout2[28] n301 conect_deco_latch2[2]
+ Sal_and_write[2] n73 VSS VDD_1V8 latchtriestado_931
Xlatches1_2__latches2_27__latchesa Din[27] Dout1[27] Dout2[27] n301 conect_deco_latch2[2]
+ Sal_and_write[2] n74 VSS VDD_1V8 latchtriestado_932
Xlatches1_2__latches2_26__latchesa Din[26] Dout1[26] Dout2[26] n301 n2 Sal_and_write[2]
+ n128 VSS VDD_1V8 latchtriestado_933
Xlatches1_2__latches2_25__latchesa Din[25] Dout1[25] Dout2[25] n301 n2 Sal_and_write[2]
+ n74 VSS VDD_1V8 latchtriestado_934
Xlatches1_2__latches2_24__latchesa Din[24] Dout1[24] Dout2[24] n301 n2 Sal_and_write[2]
+ n74 VSS VDD_1V8 latchtriestado_935
Xlatches1_2__latches2_23__latchesa Din[23] Dout1[23] Dout2[23] n301 conect_deco_latch2[2]
+ Sal_and_write[2] n74 VSS VDD_1V8 latchtriestado_936
Xlatches1_2__latches2_22__latchesa Din[22] Dout1[22] Dout2[22] n301 n2 Sal_and_write[2]
+ n73 VSS VDD_1V8 latchtriestado_937
Xlatches1_2__latches2_21__latchesa Din[21] Dout1[21] Dout2[21] n301 n2 Sal_and_write[2]
+ n127 VSS VDD_1V8 latchtriestado_938
Xlatches1_2__latches2_20__latchesa Din[20] Dout1[20] Dout2[20] n301 n2 Sal_and_write[2]
+ n5 VSS VDD_1V8 latchtriestado_939
Xlatches1_2__latches2_19__latchesa Din[19] Dout1[19] Dout2[19] n301 n2 Sal_and_write[2]
+ n74 VSS VDD_1V8 latchtriestado_940
Xlatches1_2__latches2_18__latchesa Din[18] Dout1[18] Dout2[18] n301 n2 Sal_and_write[2]
+ n126 VSS VDD_1V8 latchtriestado_941
Xlatches1_2__latches2_17__latchesa Din[17] Dout1[17] Dout2[17] n301 conect_deco_latch2[2]
+ Sal_and_write[2] n126 VSS VDD_1V8 latchtriestado_942
Xlatches1_2__latches2_16__latchesa Din[16] Dout1[16] Dout2[16] n301 n2 Sal_and_write[2]
+ n5 VSS VDD_1V8 latchtriestado_943
Xlatches1_2__latches2_15__latchesa Din[15] Dout1[15] Dout2[15] n301 n2 Sal_and_write[2]
+ n218 VSS VDD_1V8 latchtriestado_944
Xlatches1_2__latches2_14__latchesa Din[14] Dout1[14] Dout2[14] n301 n2 Sal_and_write[2]
+ n218 VSS VDD_1V8 latchtriestado_945
Xlatches1_2__latches2_13__latchesa Din[13] Dout1[13] Dout2[13] n301 n2 Sal_and_write[2]
+ n5 VSS VDD_1V8 latchtriestado_946
Xlatches1_2__latches2_12__latchesa Din[12] Dout1[12] Dout2[12] n301 n2 Sal_and_write[2]
+ n129 VSS VDD_1V8 latchtriestado_947
Xlatches1_2__latches2_11__latchesa Din[11] Dout1[11] Dout2[11] n301 conect_deco_latch2[2]
+ Sal_and_write[2] IN133 VSS VDD_1V8 latchtriestado_948
Xlatches1_2__latches2_10__latchesa Din[10] Dout1[10] Dout2[10] n301 n2 Sal_and_write[2]
+ IN134 VSS VDD_1V8 latchtriestado_949
Xlatches1_2__latches2_9__latchesa Din[9] Dout1[9] Dout2[9] n301 n2 Sal_and_write[2]
+ n75 VSS VDD_1V8 latchtriestado_950
Xlatches1_2__latches2_8__latchesa Din[8] Dout1[8] Dout2[8] n301 n2 Sal_and_write[2]
+ n130 VSS VDD_1V8 latchtriestado_951
Xlatches1_2__latches2_7__latchesa Din[7] Dout1[7] Dout2[7] n301 n2 Sal_and_write[2]
+ n129 VSS VDD_1V8 latchtriestado_952
Xlatches1_2__latches2_6__latchesa Din[6] Dout1[6] Dout2[6] n301 n2 Sal_and_write[2]
+ n129 VSS VDD_1V8 latchtriestado_953
Xlatches1_2__latches2_5__latchesa Din[5] Dout1[5] Dout2[5] n301 n2 Sal_and_write[2]
+ n129 VSS VDD_1V8 latchtriestado_954
Xlatches1_2__latches2_4__latchesa Din[4] Dout1[4] Dout2[4] n301 conect_deco_latch2[2]
+ Sal_and_write[2] n75 VSS VDD_1V8 latchtriestado_955
Xlatches1_2__latches2_3__latchesa Din[3] Dout1[3] Dout2[3] n301 n2 Sal_and_write[2]
+ n128 VSS VDD_1V8 latchtriestado_956
Xlatches1_2__latches2_2__latchesa Din[2] Dout1[2] Dout2[2] n301 n2 Sal_and_write[2]
+ n75 VSS VDD_1V8 latchtriestado_957
Xlatches1_2__latches2_1__latchesa Din[1] Dout1[1] Dout2[1] n301 n2 Sal_and_write[2]
+ n218 VSS VDD_1V8 latchtriestado_958
Xlatches1_2__latches2_0__latchesa Din[0] Dout1[0] Dout2[0] n301 n2 Sal_and_write[2]
+ n126 VSS VDD_1V8 latchtriestado_959
Xlatches1_1__latches2_31__latchesa Din[31] Dout1[31] Dout2[31] conect_deco_latch1[1]
+ conect_deco_latch2[1] Sal_and_write[1] n126 VSS VDD_1V8 latchtriestado_960
Xlatches1_1__latches2_30__latchesa Din[30] Dout1[30] Dout2[30] conect_deco_latch1[1]
+ conect_deco_latch2[1] Sal_and_write[1] n130 VSS VDD_1V8 latchtriestado_961
Xlatches1_1__latches2_29__latchesa Din[29] Dout1[29] Dout2[29] conect_deco_latch1[1]
+ conect_deco_latch2[1] Sal_and_write[1] n126 VSS VDD_1V8 latchtriestado_962
Xlatches1_1__latches2_28__latchesa Din[28] Dout1[28] Dout2[28] conect_deco_latch1[1]
+ conect_deco_latch2[1] Sal_and_write[1] n29 VSS VDD_1V8 latchtriestado_963
Xlatches1_1__latches2_27__latchesa Din[27] Dout1[27] Dout2[27] conect_deco_latch1[1]
+ conect_deco_latch2[1] Sal_and_write[1] n126 VSS VDD_1V8 latchtriestado_964
Xlatches1_1__latches2_26__latchesa Din[26] Dout1[26] Dout2[26] conect_deco_latch1[1]
+ conect_deco_latch2[1] Sal_and_write[1] n95 VSS VDD_1V8 latchtriestado_965
Xlatches1_1__latches2_25__latchesa Din[25] Dout1[25] Dout2[25] conect_deco_latch1[1]
+ conect_deco_latch2[1] Sal_and_write[1] n5 VSS VDD_1V8 latchtriestado_966
Xlatches1_1__latches2_24__latchesa Din[24] Dout1[24] Dout2[24] conect_deco_latch1[1]
+ conect_deco_latch2[1] Sal_and_write[1] n5 VSS VDD_1V8 latchtriestado_967
Xlatches1_1__latches2_23__latchesa Din[23] Dout1[23] Dout2[23] conect_deco_latch1[1]
+ conect_deco_latch2[1] Sal_and_write[1] n126 VSS VDD_1V8 latchtriestado_968
Xlatches1_1__latches2_22__latchesa Din[22] Dout1[22] Dout2[22] conect_deco_latch1[1]
+ conect_deco_latch2[1] Sal_and_write[1] n126 VSS VDD_1V8 latchtriestado_969
Xlatches1_1__latches2_21__latchesa Din[21] Dout1[21] Dout2[21] conect_deco_latch1[1]
+ conect_deco_latch2[1] Sal_and_write[1] n127 VSS VDD_1V8 latchtriestado_970
Xlatches1_1__latches2_20__latchesa Din[20] Dout1[20] Dout2[20] conect_deco_latch1[1]
+ conect_deco_latch2[1] Sal_and_write[1] n5 VSS VDD_1V8 latchtriestado_971
Xlatches1_1__latches2_19__latchesa Din[19] Dout1[19] Dout2[19] conect_deco_latch1[1]
+ conect_deco_latch2[1] Sal_and_write[1] n5 VSS VDD_1V8 latchtriestado_972
Xlatches1_1__latches2_18__latchesa Din[18] Dout1[18] Dout2[18] conect_deco_latch1[1]
+ conect_deco_latch2[1] Sal_and_write[1] n126 VSS VDD_1V8 latchtriestado_973
Xlatches1_1__latches2_17__latchesa Din[17] Dout1[17] Dout2[17] conect_deco_latch1[1]
+ conect_deco_latch2[1] Sal_and_write[1] n95 VSS VDD_1V8 latchtriestado_974
Xlatches1_1__latches2_16__latchesa Din[16] Dout1[16] Dout2[16] conect_deco_latch1[1]
+ conect_deco_latch2[1] Sal_and_write[1] n95 VSS VDD_1V8 latchtriestado_975
Xlatches1_1__latches2_15__latchesa Din[15] Dout1[15] Dout2[15] conect_deco_latch1[1]
+ conect_deco_latch2[1] Sal_and_write[1] n218 VSS VDD_1V8 latchtriestado_976
Xlatches1_1__latches2_14__latchesa Din[14] Dout1[14] Dout2[14] conect_deco_latch1[1]
+ conect_deco_latch2[1] Sal_and_write[1] n218 VSS VDD_1V8 latchtriestado_977
Xlatches1_1__latches2_13__latchesa Din[13] Dout1[13] Dout2[13] conect_deco_latch1[1]
+ conect_deco_latch2[1] Sal_and_write[1] n218 VSS VDD_1V8 latchtriestado_978
Xlatches1_1__latches2_12__latchesa Din[12] Dout1[12] Dout2[12] conect_deco_latch1[1]
+ conect_deco_latch2[1] Sal_and_write[1] n130 VSS VDD_1V8 latchtriestado_979
Xlatches1_1__latches2_11__latchesa Din[11] Dout1[11] Dout2[11] conect_deco_latch1[1]
+ conect_deco_latch2[1] Sal_and_write[1] n30 VSS VDD_1V8 latchtriestado_980
Xlatches1_1__latches2_10__latchesa Din[10] Dout1[10] Dout2[10] conect_deco_latch1[1]
+ conect_deco_latch2[1] Sal_and_write[1] n30 VSS VDD_1V8 latchtriestado_981
Xlatches1_1__latches2_9__latchesa Din[9] Dout1[9] Dout2[9] conect_deco_latch1[1]
+ conect_deco_latch2[1] Sal_and_write[1] n130 VSS VDD_1V8 latchtriestado_982
Xlatches1_1__latches2_8__latchesa Din[8] Dout1[8] Dout2[8] conect_deco_latch1[1]
+ conect_deco_latch2[1] Sal_and_write[1] n130 VSS VDD_1V8 latchtriestado_983
Xlatches1_1__latches2_7__latchesa Din[7] Dout1[7] Dout2[7] conect_deco_latch1[1]
+ conect_deco_latch2[1] Sal_and_write[1] n130 VSS VDD_1V8 latchtriestado_984
Xlatches1_1__latches2_6__latchesa Din[6] Dout1[6] Dout2[6] conect_deco_latch1[1]
+ conect_deco_latch2[1] Sal_and_write[1] n130 VSS VDD_1V8 latchtriestado_985
Xlatches1_1__latches2_5__latchesa Din[5] Dout1[5] Dout2[5] conect_deco_latch1[1]
+ conect_deco_latch2[1] Sal_and_write[1] n130 VSS VDD_1V8 latchtriestado_986
Xlatches1_1__latches2_4__latchesa Din[4] Dout1[4] Dout2[4] conect_deco_latch1[1]
+ conect_deco_latch2[1] Sal_and_write[1] n75 VSS VDD_1V8 latchtriestado_987
Xlatches1_1__latches2_3__latchesa Din[3] Dout1[3] Dout2[3] conect_deco_latch1[1]
+ conect_deco_latch2[1] Sal_and_write[1] n30 VSS VDD_1V8 latchtriestado_988
Xlatches1_1__latches2_2__latchesa Din[2] Dout1[2] Dout2[2] conect_deco_latch1[1]
+ conect_deco_latch2[1] Sal_and_write[1] n130 VSS VDD_1V8 latchtriestado_989
Xlatches1_1__latches2_1__latchesa Din[1] Dout1[1] Dout2[1] conect_deco_latch1[1]
+ conect_deco_latch2[1] Sal_and_write[1] n130 VSS VDD_1V8 latchtriestado_990
Xlatches1_1__latches2_0__latchesa Din[0] Dout1[0] Dout2[0] conect_deco_latch1[1]
+ conect_deco_latch2[1] Sal_and_write[1] n126 VSS VDD_1V8 latchtriestado_991
XDeco_escritura addres3[4] addres3[3] addres3[2] addres3[1] addres3[0] conect_deco_latch3[31]
+ conect_deco_latch3[30] conect_deco_latch3[29] conect_deco_latch3[28] conect_deco_latch3[27]
+ conect_deco_latch3[26] conect_deco_latch3[25] conect_deco_latch3[24] conect_deco_latch3[23]
+ conect_deco_latch3[22] conect_deco_latch3[21] conect_deco_latch3[20] conect_deco_latch3[19]
+ conect_deco_latch3[18] conect_deco_latch3[17] conect_deco_latch3[16] conect_deco_latch3[15]
+ conect_deco_latch3[14] conect_deco_latch3[13] conect_deco_latch3[12] conect_deco_latch3[11]
+ conect_deco_latch3[10] conect_deco_latch3[9] conect_deco_latch3[8] conect_deco_latch3[7]
+ conect_deco_latch3[6] conect_deco_latch3[5] conect_deco_latch3[4] conect_deco_latch3[3]
+ conect_deco_latch3[2] conect_deco_latch3[1] SYNOPSYS_UNCONNECTED_1 VSS VDD_1V8 Decodificador_width32_0
XDecodificador2 addres2[4] addres2[3] addres2[2] addres2[1] addres2[0] conect_deco_latch2[31]
+ conect_deco_latch2[30] conect_deco_latch2[29] conect_deco_latch2[28] conect_deco_latch2[27]
+ conect_deco_latch2[26] conect_deco_latch2[25] conect_deco_latch2[24] conect_deco_latch2[23]
+ conect_deco_latch2[22] conect_deco_latch2[21] conect_deco_latch2[20] conect_deco_latch2[19]
+ conect_deco_latch2[18] conect_deco_latch2[17] conect_deco_latch2[16] conect_deco_latch2[15]
+ conect_deco_latch2[14] conect_deco_latch2[13] conect_deco_latch2[12] conect_deco_latch2[11]
+ conect_deco_latch2[10] conect_deco_latch2[9] conect_deco_latch2[8] conect_deco_latch2[7]
+ conect_deco_latch2[6] conect_deco_latch2[5] conect_deco_latch2[4] conect_deco_latch2[3]
+ conect_deco_latch2[2] conect_deco_latch2[1] conect_deco_latch2[0] VSS VDD_1V8 Decodificador_width32_1
XDecodificador1 addres1[4] addres1[3] addres1[2] addres1[1] addres1[0] conect_deco_latch1[31]
+ conect_deco_latch1[30] conect_deco_latch1[29] conect_deco_latch1[28] conect_deco_latch1[27]
+ conect_deco_latch1[26] conect_deco_latch1[25] conect_deco_latch1[24] conect_deco_latch1[23]
+ conect_deco_latch1[22] conect_deco_latch1[21] conect_deco_latch1[20] conect_deco_latch1[19]
+ conect_deco_latch1[18] conect_deco_latch1[17] conect_deco_latch1[16] conect_deco_latch1[15]
+ conect_deco_latch1[14] conect_deco_latch1[13] conect_deco_latch1[12] conect_deco_latch1[11]
+ conect_deco_latch1[10] conect_deco_latch1[9] conect_deco_latch1[8] conect_deco_latch1[7]
+ conect_deco_latch1[6] conect_deco_latch1[5] conect_deco_latch1[4] conect_deco_latch1[3]
+ conect_deco_latch1[2] conect_deco_latch1[1] conect_deco_latch1[0] VSS VDD_1V8 Decodificador_width32_2
Xplace34 VSS VDD_1V8 n2 conect_deco_latch2[2] BUHDLLX0
Xplace66 VSS VDD_1V8 n299 conect_deco_latch1[10] BUHDLLX1
Xplace60 VSS VDD_1V8 n293 conect_deco_latch1[29] BUHDLLX1
Xplace58 VSS VDD_1V8 n291 conect_deco_latch1[30] BUHDLLX1
Xplace23 VSS VDD_1V8 n256 conect_deco_latch2[26] BUHDLLX1
Xplace25 VSS VDD_1V8 n258 conect_deco_latch2[29] BUHDLLX1
XU2 VSS VDD_1V8 n1 Write_en clk NO2I1HDLLX4
XU33 VSS n1_G4B2I1 conect_deco_latch3[1] VDD_1V8 Sal_and_write[1] AND2HDLLX4
XU32 VSS CTS_CLK_CTO_delay141 conect_deco_latch3[2] VDD_1V8 Sal_and_write[2] AND2HDLLX4
XU31 VSS n1_G4B2I1 conect_deco_latch3[3] VDD_1V8 Sal_and_write[3] AND2HDLLX4
XU30 VSS n1_G4B2I1 conect_deco_latch3[4] VDD_1V8 Sal_and_write[4] AND2HDLLX4
XU29 VSS n1_G4B2I1 conect_deco_latch3[5] VDD_1V8 Sal_and_write[5] AND2HDLLX4
XU28 VSS n1_G4B2I1 conect_deco_latch3[6] VDD_1V8 Sal_and_write[6] AND2HDLLX4
XU27 VSS n1_G4B2I1 conect_deco_latch3[7] VDD_1V8 Sal_and_write[7] AND2HDLLX4
XU26 VSS n1_G4B2I1 conect_deco_latch3[8] VDD_1V8 Sal_and_write[8] AND2HDLLX4
XU25 VSS n1_G4B2I1 conect_deco_latch3[9] VDD_1V8 Sal_and_write[9] AND2HDLLX4
XU24 VSS CTS_CLK_CTO_delay161 conect_deco_latch3[10] VDD_1V8 Sal_and_write[10] AND2HDLLX4
XU23 VSS n1_G4B2I1 conect_deco_latch3[11] VDD_1V8 Sal_and_write[11] AND2HDLLX4
XU22 VSS n1_G4B2I1 conect_deco_latch3[12] VDD_1V8 Sal_and_write[12] AND2HDLLX4
XU21 VSS n1_G4B2I1 conect_deco_latch3[13] VDD_1V8 Sal_and_write[13] AND2HDLLX4
XU20 VSS n1_G4B2I1 conect_deco_latch3[14] VDD_1V8 Sal_and_write[14] AND2HDLLX4
XU19 VSS n1_G4B2I1 conect_deco_latch3[15] VDD_1V8 Sal_and_write[15] AND2HDLLX4
XU18 VSS n1_G4B2I1 conect_deco_latch3[16] VDD_1V8 Sal_and_write[16] AND2HDLLX4
XU17 VSS n1_G4B2I1 conect_deco_latch3[17] VDD_1V8 Sal_and_write[17] AND2HDLLX4
XU16 VSS n1_G4B2I1 conect_deco_latch3[18] VDD_1V8 Sal_and_write[18] AND2HDLLX4
XU15 VSS n1_G4B2I1 conect_deco_latch3[19] VDD_1V8 Sal_and_write[19] AND2HDLLX4
XU14 VSS n1_G4B2I1 conect_deco_latch3[20] VDD_1V8 Sal_and_write[20] AND2HDLLX4
XU13 VSS n1_G4B2I1 conect_deco_latch3[21] VDD_1V8 Sal_and_write[21] AND2HDLLX4
XU12 VSS n1_G4B2I1 conect_deco_latch3[22] VDD_1V8 Sal_and_write[22] AND2HDLLX4
XU11 VSS n1_G4B2I1 conect_deco_latch3[23] VDD_1V8 Sal_and_write[23] AND2HDLLX4
XU10 VSS n1_G4B2I1 conect_deco_latch3[24] VDD_1V8 Sal_and_write[24] AND2HDLLX4
XU9 VSS n1_G4B2I1 conect_deco_latch3[25] VDD_1V8 Sal_and_write[25] AND2HDLLX4
XU8 VSS n1_G4B2I1 conect_deco_latch3[26] VDD_1V8 Sal_and_write[26] AND2HDLLX4
XU7 VSS n1_G4B2I1 conect_deco_latch3[27] VDD_1V8 Sal_and_write[27] AND2HDLLX4
XU6 VSS CTS_CLK_CTO_delay141 conect_deco_latch3[28] VDD_1V8 Sal_and_write[28] AND2HDLLX4
XU5 VSS n1_G4B2I1 conect_deco_latch3[29] VDD_1V8 Sal_and_write[29] AND2HDLLX2
XU4 VSS n1_G4B2I1 conect_deco_latch3[30] VDD_1V8 Sal_and_write[30] AND2HDLLX4
XU3 VSS n1_G4B2I1 conect_deco_latch3[31] VDD_1V8 Sal_and_write[31] AND2HDLLX4
Xplace9 n93 VSS VDD_1V8 IN199 INHDLLX1
Xplace8 n75 VSS VDD_1V8 IN199 INHDLLX1
Xplace7 n74 VSS VDD_1V8 IN199 INHDLLX1
Xplace6 n73 VSS VDD_1V8 IN199 INHDLLX1
Xplace5 n30 VSS VDD_1V8 IN198 INHDLLX1
Xplace4 n29 VSS VDD_1V8 IN199 INHDLLX1
Xplace3 n5 VSS VDD_1V8 IN199 INHDLLX1
Xplace2 n4 VSS VDD_1V8 IN199 INHDLLX1
Xplace28 VSS VDD_1V8 n261 conect_deco_latch2[8] BUHDLLX1
Xplace26 VSS VDD_1V8 n259 conect_deco_latch2[30] BUHDLLX0
Xplace32 VSS VDD_1V8 n265 conect_deco_latch2[10] BUHDLLX0
Xplace43 VSS VDD_1V8 n276 conect_deco_latch2[14] BUHDLLX1
Xplace38 VSS VDD_1V8 n271 conect_deco_latch2[20] BUHDLLX1
Xplace62 VSS VDD_1V8 n295 conect_deco_latch1[8] BUHDLLX1
Xplace51 VSS VDD_1V8 n284 conect_deco_latch1[14] BUHDLLX1
Xplace72 VSS VDD_1V8 n305 conect_deco_latch1[20] BUHDLLX1
Xplace70 VSS VDD_1V8 n303 conect_deco_latch1[4] BUHDLLX1
Xplace71 VSS VDD_1V8 n304 conect_deco_latch1[21] BUHDLLX1
Xplace19 VSS VDD_1V8 conect_deco_latch2[31] n252 BUHDLLX6
Xplace20 VSS VDD_1V8 conect_deco_latch1[31] n253 BUHDLLX6
Xplace21 VSS VDD_1V8 conect_deco_latch2[25] n254 BUHDLLX6
Xplace22 VSS VDD_1V8 conect_deco_latch2[27] n255 BUHDLLX6
Xplace24 VSS VDD_1V8 conect_deco_latch2[23] n257 BUHDLLX6
Xplace27 VSS VDD_1V8 conect_deco_latch2[9] n260 BUHDLLX6
Xplace29 VSS VDD_1V8 conect_deco_latch2[7] n262 BUHDLLX6
Xplace30 VSS VDD_1V8 conect_deco_latch2[6] n263 BUHDLLX6
Xplace31 VSS VDD_1V8 conect_deco_latch2[11] n264 BUHDLLX6
Xplace33 VSS VDD_1V8 conect_deco_latch2[3] n266 BUHDLLX6
Xplace35 VSS VDD_1V8 conect_deco_latch2[5] n268 BUHDLLX6
Xplace36 VSS VDD_1V8 conect_deco_latch2[4] n269 BUHDLLX6
Xplace37 VSS VDD_1V8 conect_deco_latch2[21] n270 BUHDLLX6
Xplace39 VSS VDD_1V8 conect_deco_latch2[19] n272 BUHDLLX6
Xplace40 VSS VDD_1V8 conect_deco_latch2[18] n273 BUHDLLX6
Xplace41 VSS VDD_1V8 conect_deco_latch2[22] n274 BUHDLLX6
Xplace42 VSS VDD_1V8 conect_deco_latch2[15] n275 BUHDLLX6
Xplace44 VSS VDD_1V8 conect_deco_latch2[13] n277 BUHDLLX6
Xplace45 VSS VDD_1V8 conect_deco_latch2[17] n278 BUHDLLX6
Xplace46 VSS VDD_1V8 conect_deco_latch2[16] n279 BUHDLLX6
Xplace47 VSS VDD_1V8 conect_deco_latch1[19] n280 BUHDLLX6
Xplace48 VSS VDD_1V8 conect_deco_latch1[18] n281 BUHDLLX6
Xplace49 VSS VDD_1V8 conect_deco_latch1[22] n282 BUHDLLX6
Xplace50 VSS VDD_1V8 conect_deco_latch1[15] n283 BUHDLLX6
Xplace52 VSS VDD_1V8 conect_deco_latch1[13] n285 BUHDLLX6
Xplace53 VSS VDD_1V8 conect_deco_latch1[17] n286 BUHDLLX6
Xplace54 VSS VDD_1V8 conect_deco_latch1[16] n287 BUHDLLX6
Xplace55 VSS VDD_1V8 conect_deco_latch1[25] n288 BUHDLLX6
Xplace56 VSS VDD_1V8 conect_deco_latch1[26] n289 BUHDLLX6
Xplace57 VSS VDD_1V8 conect_deco_latch1[27] n290 BUHDLLX6
Xplace59 VSS VDD_1V8 conect_deco_latch1[23] n292 BUHDLLX6
Xplace61 VSS VDD_1V8 conect_deco_latch1[9] n294 BUHDLLX6
Xplace63 VSS VDD_1V8 conect_deco_latch1[7] n296 BUHDLLX6
Xplace64 VSS VDD_1V8 conect_deco_latch1[6] n297 BUHDLLX6
Xplace65 VSS VDD_1V8 conect_deco_latch1[11] n298 BUHDLLX6
Xplace67 VSS VDD_1V8 conect_deco_latch1[3] n300 BUHDLLX6
Xplace68 VSS VDD_1V8 conect_deco_latch1[2] n301 BUHDLLX6
Xplace69 VSS VDD_1V8 conect_deco_latch1[5] n302 BUHDLLX6
Xplace18 n218 VSS VDD_1V8 IN199 INHDLLX1
Xplace17 n130 VSS VDD_1V8 IN198 INHDLLX1
Xplace16 n129 VSS VDD_1V8 IN198 INHDLLX1
Xplace15 n128 VSS VDD_1V8 IN199 INHDLLX1
Xplace14 n127 VSS VDD_1V8 IN199 INHDLLX1
Xplace13 n126 VSS VDD_1V8 IN199 INHDLLX1
Xplace12 n96 VSS VDD_1V8 IN199 INHDLLX1
Xplace11 n95 VSS VDD_1V8 IN199 INHDLLX1
Xplace10 n94 VSS VDD_1V8 IN199 INHDLLX1
XINHDLLX2_G5B2I12 Sal_and_write_G5B1I1_29_ VSS VDD_1V8 Sal_and_write[29] INHDLLX2
XINHDLLX6_G4B1I1 VSS VDD_1V8 n1_G4B2I1 n1_G4B1I1 INHDLLX8
XINHDLLX2_G4B2I1 VSS VDD_1V8 n1_G4B1I1 n1 INHDLLX4
XINHDLLX4_G5B1I12 VSS VDD_1V8 Sal_and_write_G5B1I1_29_ Sal_and_write_G5B2I1_29_ INHDLLX6
XCTS_CLK_CTO_delay16 CTS_CLK_CTO_delay161 VSS VDD_1V8 n1_G4B2I1 BUHDLLX2
XCTS_CLK_CTO_delay18 VSS VDD_1V8 Sal_and_write[18] CTS_CLK_CTO_delay181 BUHDLLX6
XCTS_CLK_CTO_delay22 VSS VDD_1V8 Sal_and_write[30] CTS_CLK_CTO_delay221 BUHDLLX6
XCTS_CLK_CTO_delay24 VSS VDD_1V8 Sal_and_write[9] CTS_CLK_CTO_delay241 BUHDLLX6
XCTS_CLK_CTO_delay26 VSS VDD_1V8 Sal_and_write[27] CTS_CLK_CTO_delay261 BUHDLLX6
XCTS_CLK_CTO_delay28 VSS VDD_1V8 Sal_and_write[19] CTS_CLK_CTO_delay281 BUHDLLX6
XCTS_CLK_CTO_delay30 VSS VDD_1V8 Sal_and_write[17] CTS_CLK_CTO_delay301 BUHDLLX6
XCTS_CLK_CTO_delay32 VSS VDD_1V8 Sal_and_write[7] CTS_CLK_CTO_delay321 BUHDLLX6
XCTS_CLK_CTO_delay34 VSS VDD_1V8 Sal_and_write[3] CTS_CLK_CTO_delay341 BUHDLLX6
XCTS_CLK_CTO_delay36 VSS VDD_1V8 Sal_and_write[24] CTS_CLK_CTO_delay361 BUHDLLX6
XCTS_CLK_CTO_delay38 VSS VDD_1V8 Sal_and_write[6] CTS_CLK_CTO_delay381 BUHDLLX6
XCTS_CLK_CTO_delay40 VSS VDD_1V8 Sal_and_write[12] CTS_CLK_CTO_delay401 BUHDLLX6
XCTS_CLK_CTO_delay42 VSS VDD_1V8 Sal_and_write[13] CTS_CLK_CTO_delay421 BUHDLLX6
XCTS_CLK_CTO_delay14 VSS VDD_1V8 n1_G4B2I1 CTS_CLK_CTO_delay141 BUHDLLX6
XCTS_CLK_CTO_delay20 VSS VDD_1V8 Sal_and_write[26] CTS_CLK_CTO_delay201 BUHDLLX6
.ENDS

.SUBCKT latch_tri_rst0_Hard_126 In Out1_tri En1 Write rst Out_latch VSS VDD_1V8
Xlatch1 Write In Out_latch rst VSS VDD_1V8 latch_250
Xtristategate1 Out_latch En1 Out1_tri VSS VDD_1V8 tristategate_250
.ENDS

.SUBCKT latch_tri_rst0_Hard_125 In Out1_tri En1 Write rst Out_latch VSS VDD_1V8
Xlatch1 Write In Out_latch rst VSS VDD_1V8 latch_249
Xtristategate1 Out_latch En1 Out1_tri VSS VDD_1V8 tristategate_249
.ENDS

.SUBCKT latch_tri_rst0_Hard_124 In Out1_tri En1 Write rst Out_latch VSS VDD_1V8
Xlatch1 Write In Out_latch rst VSS VDD_1V8 latch_248
Xtristategate1 Out_latch En1 Out1_tri VSS VDD_1V8 tristategate_248
.ENDS

.SUBCKT latch_tri_rst0_Hard_123 In Out1_tri En1 Write rst Out_latch VSS VDD_1V8
Xlatch1 Write In Out_latch rst VSS VDD_1V8 latch_247
Xtristategate1 Out_latch En1 Out1_tri VSS VDD_1V8 tristategate_247
.ENDS

.SUBCKT latch_tri_rst0_Hard_122 In Out1_tri En1 Write rst Out_latch VSS VDD_1V8
Xlatch1 Write In Out_latch rst VSS VDD_1V8 latch_246
Xtristategate1 Out_latch En1 Out1_tri VSS VDD_1V8 tristategate_246
.ENDS

.SUBCKT latch_tri_rst0_Hard_121 In Out1_tri En1 Write rst Out_latch VSS VDD_1V8
Xlatch1 Write In Out_latch rst VSS VDD_1V8 latch_245
Xtristategate1 Out_latch En1 Out1_tri VSS VDD_1V8 tristategate_245
.ENDS

.SUBCKT latch_tri_rst0_Hard_120 In Out1_tri En1 Write rst Out_latch VSS VDD_1V8
Xlatch1 Write In Out_latch rst VSS VDD_1V8 latch_244
Xtristategate1 Out_latch En1 Out1_tri VSS VDD_1V8 tristategate_244
.ENDS

.SUBCKT latch_tri_rst0_Hard_119 In Out1_tri En1 Write rst Out_latch VSS VDD_1V8
Xlatch1 Write In Out_latch rst VSS VDD_1V8 latch_243
Xtristategate1 Out_latch En1 Out1_tri VSS VDD_1V8 tristategate_243
.ENDS

.SUBCKT latch_tri_rst0_Hard_118 In Out1_tri En1 Write rst Out_latch VSS VDD_1V8
Xlatch1 Write In Out_latch rst VSS VDD_1V8 latch_242
Xtristategate1 Out_latch En1 Out1_tri VSS VDD_1V8 tristategate_242
.ENDS

.SUBCKT latch_tri_rst0_Hard_117 In Out1_tri En1 Write rst Out_latch VSS VDD_1V8
Xlatch1 Write In Out_latch rst VSS VDD_1V8 latch_241
Xtristategate1 Out_latch En1 Out1_tri VSS VDD_1V8 tristategate_241
.ENDS

.SUBCKT latch_tri_rst0_Hard_116 In Out1_tri En1 Write rst Out_latch VSS VDD_1V8
Xlatch1 Write In Out_latch rst VSS VDD_1V8 latch_240
Xtristategate1 Out_latch En1 Out1_tri VSS VDD_1V8 tristategate_240
.ENDS

.SUBCKT latch_tri_estado_123 In Out1 En1 Write rst VSS VDD_1V8
Xlatch1 Write In conect rst VSS VDD_1V8 latch_239
Xtristategate1 conect En1 Out1 VSS VDD_1V8 tristategate_239
.ENDS

.SUBCKT latch_tri_estado_122 In Out1 En1 Write rst VSS VDD_1V8
Xlatch1 Write In conect rst VSS VDD_1V8 latch_238
Xtristategate1 conect En1 Out1 VSS VDD_1V8 tristategate_238
.ENDS

.SUBCKT latch_tri_estado_121 In Out1 En1 Write rst VSS VDD_1V8
Xlatch1 Write In conect rst VSS VDD_1V8 latch_237
Xtristategate1 conect En1 Out1 VSS VDD_1V8 tristategate_237
.ENDS

.SUBCKT latch_tri_estado_120 In Out1 En1 Write rst VSS VDD_1V8
Xlatch1 Write In conect rst VSS VDD_1V8 latch_236
Xtristategate1 conect En1 Out1 VSS VDD_1V8 tristategate_236
.ENDS

.SUBCKT latch_tri_estado_119 In Out1 En1 Write rst VSS VDD_1V8
Xlatch1 Write In conect rst VSS VDD_1V8 latch_235
Xtristategate1 conect En1 Out1 VSS VDD_1V8 tristategate_235
.ENDS

.SUBCKT latch_tri_estado_118 In Out1 En1 Write rst VSS VDD_1V8
Xlatch1 Write In conect rst VSS VDD_1V8 latch_234
Xtristategate1 conect En1 Out1 VSS VDD_1V8 tristategate_234
.ENDS

.SUBCKT latch_tri_estado_117 In Out1 En1 Write rst VSS VDD_1V8
Xlatch1 Write In conect rst VSS VDD_1V8 latch_233
Xtristategate1 conect En1 Out1 VSS VDD_1V8 tristategate_233
.ENDS

.SUBCKT latch_tri_estado_116 In Out1 En1 Write rst VSS VDD_1V8
Xlatch1 Write In conect rst VSS VDD_1V8 latch_232
Xtristategate1 conect En1 Out1 VSS VDD_1V8 tristategate_232
.ENDS

.SUBCKT latch_tri_estado_115 In Out1 En1 Write rst VSS VDD_1V8
Xlatch1 Write In conect rst VSS VDD_1V8 latch_231
Xtristategate1 conect En1 Out1 VSS VDD_1V8 tristategate_231
.ENDS

.SUBCKT latch_tri_estado_114 In Out1 En1 Write rst VSS VDD_1V8
Xlatch1 Write In conect rst VSS VDD_1V8 latch_230
Xtristategate1 conect En1 Out1 VSS VDD_1V8 tristategate_230
.ENDS

.SUBCKT latch_tri_estado_113 In Out1 En1 Write rst VSS VDD_1V8
Xlatch1 Write In conect rst VSS VDD_1V8 latch_229
Xtristategate1 conect En1 Out1 VSS VDD_1V8 tristategate_229
.ENDS

.SUBCKT latch_tri_estado_112 In Out1 En1 Write rst VSS VDD_1V8
Xlatch1 Write In conect rst VSS VDD_1V8 latch_228
Xtristategate1 conect En1 Out1 VSS VDD_1V8 tristategate_228
.ENDS

.SUBCKT latch_tri_estado_111 In Out1 En1 Write rst VSS VDD_1V8
Xlatch1 Write In conect rst VSS VDD_1V8 latch_227
Xtristategate1 conect En1 Out1 VSS VDD_1V8 tristategate_227
.ENDS

.SUBCKT latch_tri_estado_110 In Out1 En1 Write rst VSS VDD_1V8
Xlatch1 Write In conect rst VSS VDD_1V8 latch_226
Xtristategate1 conect En1 Out1 VSS VDD_1V8 tristategate_226
.ENDS

.SUBCKT latch_tri_estado_109 In Out1 En1 Write rst VSS VDD_1V8
Xlatch1 Write In conect rst VSS VDD_1V8 latch_225
Xtristategate1 conect En1 Out1 VSS VDD_1V8 tristategate_225
.ENDS

.SUBCKT latch_tri_estado_108 In Out1 En1 Write rst VSS VDD_1V8
Xlatch1 Write In conect rst VSS VDD_1V8 latch_224
Xtristategate1 conect En1 Out1 VSS VDD_1V8 tristategate_224
.ENDS

.SUBCKT latch_tri_estado_107 In Out1 En1 Write rst VSS VDD_1V8
Xlatch1 Write In conect rst VSS VDD_1V8 latch_223
Xtristategate1 conect En1 Out1 VSS VDD_1V8 tristategate_223
.ENDS

.SUBCKT latch_tri_estado_106 In Out1 En1 Write rst VSS VDD_1V8
Xlatch1 Write In conect rst VSS VDD_1V8 latch_222
Xtristategate1 conect En1 Out1 VSS VDD_1V8 tristategate_222
.ENDS

.SUBCKT latch_tri_estado_105 In Out1 En1 Write rst VSS VDD_1V8
Xlatch1 Write In conect rst VSS VDD_1V8 latch_221
Xtristategate1 conect En1 Out1 VSS VDD_1V8 tristategate_221
.ENDS

.SUBCKT latch_tri_estado_104 In Out1 En1 Write rst VSS VDD_1V8
Xlatch1 Write In conect rst VSS VDD_1V8 latch_220
Xtristategate1 conect En1 Out1 VSS VDD_1V8 tristategate_220
.ENDS

.SUBCKT latch_tri_estado_103 In Out1 En1 Write rst VSS VDD_1V8
Xlatch1 Write In conect rst VSS VDD_1V8 latch_219
Xtristategate1 conect En1 Out1 VSS VDD_1V8 tristategate_219
.ENDS

.SUBCKT latch_tri_estado_102 In Out1 En1 Write rst VSS VDD_1V8
Xlatch1 Write In conect rst VSS VDD_1V8 latch_218
Xtristategate1 conect En1 Out1 VSS VDD_1V8 tristategate_218
.ENDS

.SUBCKT latch_tri_estado_101 In Out1 En1 Write rst VSS VDD_1V8
Xlatch1 Write In conect rst VSS VDD_1V8 latch_217
Xtristategate1 conect En1 Out1 VSS VDD_1V8 tristategate_217
.ENDS

.SUBCKT latch_tri_estado_100 In Out1 En1 Write rst VSS VDD_1V8
Xlatch1 Write In conect rst VSS VDD_1V8 latch_216
Xtristategate1 conect En1 Out1 VSS VDD_1V8 tristategate_216
.ENDS

.SUBCKT latch_tri_estado_99 In Out1 En1 Write rst VSS VDD_1V8
Xlatch1 Write In conect rst VSS VDD_1V8 latch_215
Xtristategate1 conect En1 Out1 VSS VDD_1V8 tristategate_215
.ENDS

.SUBCKT latch_tri_estado_98 In Out1 En1 Write rst VSS VDD_1V8
Xlatch1 Write In conect rst VSS VDD_1V8 latch_214
Xtristategate1 conect En1 Out1 VSS VDD_1V8 tristategate_214
.ENDS

.SUBCKT latch_tri_estado_97 In Out1 En1 Write rst VSS VDD_1V8
Xlatch1 Write In conect rst VSS VDD_1V8 latch_213
Xtristategate1 conect En1 Out1 VSS VDD_1V8 tristategate_213
.ENDS

.SUBCKT latch_tri_estado_96 In Out1 En1 Write rst VSS VDD_1V8
Xlatch1 Write In conect rst VSS VDD_1V8 latch_212
Xtristategate1 conect En1 Out1 VSS VDD_1V8 tristategate_212
.ENDS

.SUBCKT latch_tri_estado_95 In Out1 En1 Write rst VSS VDD_1V8
Xlatch1 Write In conect rst VSS VDD_1V8 latch_211
Xtristategate1 conect En1 Out1 VSS VDD_1V8 tristategate_211
.ENDS

.SUBCKT latch_tri_estado_94 In Out1 En1 Write rst VSS VDD_1V8
Xlatch1 Write In conect rst VSS VDD_1V8 latch_210
Xtristategate1 conect En1 Out1 VSS VDD_1V8 tristategate_210
.ENDS

.SUBCKT latch_tri_estado_93 In Out1 En1 Write rst VSS VDD_1V8
Xlatch1 Write In conect rst VSS VDD_1V8 latch_209
Xtristategate1 conect En1 Out1 VSS VDD_1V8 tristategate_209
.ENDS

.SUBCKT latch_tri_estado_92 In Out1 En1 Write rst VSS VDD_1V8
Xlatch1 Write In conect rst VSS VDD_1V8 latch_208
Xtristategate1 conect En1 Out1 VSS VDD_1V8 tristategate_208
.ENDS

.SUBCKT latch_tri_estado_91 In Out1 En1 Write rst VSS VDD_1V8
Xlatch1 Write In conect rst VSS VDD_1V8 latch_207
Xtristategate1 conect En1 Out1 VSS VDD_1V8 tristategate_207
.ENDS

.SUBCKT latch_tri_estado_90 In Out1 En1 Write rst VSS VDD_1V8
Xlatch1 Write In conect rst VSS VDD_1V8 latch_206
Xtristategate1 conect En1 Out1 VSS VDD_1V8 tristategate_206
.ENDS

.SUBCKT latch_tri_estado_89 In Out1 En1 Write rst VSS VDD_1V8
Xlatch1 Write In conect rst VSS VDD_1V8 latch_205
Xtristategate1 conect En1 Out1 VSS VDD_1V8 tristategate_205
.ENDS

.SUBCKT latch_tri_estado_88 In Out1 En1 Write rst VSS VDD_1V8
Xlatch1 Write In conect rst VSS VDD_1V8 latch_204
Xtristategate1 conect En1 Out1 VSS VDD_1V8 tristategate_204
.ENDS

.SUBCKT latch_tri_estado_87 In Out1 En1 Write rst VSS VDD_1V8
Xlatch1 Write In conect rst VSS VDD_1V8 latch_203
Xtristategate1 conect En1 Out1 VSS VDD_1V8 tristategate_203
.ENDS

.SUBCKT latch_tri_estado_86 In Out1 En1 Write rst VSS VDD_1V8
Xlatch1 Write In conect rst VSS VDD_1V8 latch_202
Xtristategate1 conect En1 Out1 VSS VDD_1V8 tristategate_202
.ENDS

.SUBCKT latch_tri_estado_85 In Out1 En1 Write rst VSS VDD_1V8
Xlatch1 Write In conect rst VSS VDD_1V8 latch_201
Xtristategate1 conect En1 Out1 VSS VDD_1V8 tristategate_201
.ENDS

.SUBCKT latch_tri_estado_84 In Out1 En1 Write rst VSS VDD_1V8
Xlatch1 Write In conect rst VSS VDD_1V8 latch_200
Xtristategate1 conect En1 Out1 VSS VDD_1V8 tristategate_200
.ENDS

.SUBCKT latch_tri_estado_83 In Out1 En1 Write rst VSS VDD_1V8
Xlatch1 Write In conect rst VSS VDD_1V8 latch_199
Xtristategate1 conect En1 Out1 VSS VDD_1V8 tristategate_199
.ENDS

.SUBCKT latch_tri_estado_82 In Out1 En1 Write rst VSS VDD_1V8
Xlatch1 Write In conect rst VSS VDD_1V8 latch_198
Xtristategate1 conect En1 Out1 VSS VDD_1V8 tristategate_198
.ENDS

.SUBCKT latch_tri_estado_81 In Out1 En1 Write rst VSS VDD_1V8
Xlatch1 Write In conect rst VSS VDD_1V8 latch_197
Xtristategate1 conect En1 Out1 VSS VDD_1V8 tristategate_197
.ENDS

.SUBCKT latch_tri_estado_80 In Out1 En1 Write rst VSS VDD_1V8
Xlatch1 Write In conect rst VSS VDD_1V8 latch_196
Xtristategate1 conect En1 Out1 VSS VDD_1V8 tristategate_196
.ENDS

.SUBCKT latch_tri_estado_79 In Out1 En1 Write rst VSS VDD_1V8
Xlatch1 Write In conect rst VSS VDD_1V8 latch_195
Xtristategate1 conect En1 Out1 VSS VDD_1V8 tristategate_195
.ENDS

.SUBCKT latch_tri_estado_78 In Out1 En1 Write rst VSS VDD_1V8
Xlatch1 Write In conect rst VSS VDD_1V8 latch_194
Xtristategate1 conect En1 Out1 VSS VDD_1V8 tristategate_194
.ENDS

.SUBCKT latch_tri_estado_77 In Out1 En1 Write rst VSS VDD_1V8
Xlatch1 Write In conect rst VSS VDD_1V8 latch_193
Xtristategate1 conect En1 Out1 VSS VDD_1V8 tristategate_193
.ENDS

.SUBCKT latch_tri_estado_76 In Out1 En1 Write rst VSS VDD_1V8
Xlatch1 Write In conect rst VSS VDD_1V8 latch_192
Xtristategate1 conect En1 Out1 VSS VDD_1V8 tristategate_192
.ENDS

.SUBCKT latch_tri_estado_75 In Out1 En1 Write rst VSS VDD_1V8
Xlatch1 Write In conect rst VSS VDD_1V8 latch_191
Xtristategate1 conect En1 Out1 VSS VDD_1V8 tristategate_191
.ENDS

.SUBCKT latch_tri_estado_74 In Out1 En1 Write rst VSS VDD_1V8
Xlatch1 Write In conect rst VSS VDD_1V8 latch_190
Xtristategate1 conect En1 Out1 VSS VDD_1V8 tristategate_190
.ENDS

.SUBCKT latch_tri_estado_73 In Out1 En1 Write rst VSS VDD_1V8
Xlatch1 Write In conect rst VSS VDD_1V8 latch_189
Xtristategate1 conect En1 Out1 VSS VDD_1V8 tristategate_189
.ENDS

.SUBCKT latch_tri_estado_72 In Out1 En1 Write rst VSS VDD_1V8
Xlatch1 Write In conect rst VSS VDD_1V8 latch_188
Xtristategate1 conect En1 Out1 VSS VDD_1V8 tristategate_188
.ENDS

.SUBCKT latch_tri_estado_71 In Out1 En1 Write rst VSS VDD_1V8
Xlatch1 Write In conect rst VSS VDD_1V8 latch_187
Xtristategate1 conect En1 Out1 VSS VDD_1V8 tristategate_187
.ENDS

.SUBCKT latch_tri_estado_70 In Out1 En1 Write rst VSS VDD_1V8
Xlatch1 Write In conect rst VSS VDD_1V8 latch_186
Xtristategate1 conect En1 Out1 VSS VDD_1V8 tristategate_186
.ENDS

.SUBCKT latch_tri_estado_69 In Out1 En1 Write rst VSS VDD_1V8
Xlatch1 Write In conect rst VSS VDD_1V8 latch_185
Xtristategate1 conect En1 Out1 VSS VDD_1V8 tristategate_185
.ENDS

.SUBCKT latch_tri_estado_68 In Out1 En1 Write rst VSS VDD_1V8
Xlatch1 Write In conect rst VSS VDD_1V8 latch_184
Xtristategate1 conect En1 Out1 VSS VDD_1V8 tristategate_184
.ENDS

.SUBCKT latch_tri_estado_67 In Out1 En1 Write rst VSS VDD_1V8
Xlatch1 Write In conect rst VSS VDD_1V8 latch_183
Xtristategate1 conect En1 Out1 VSS VDD_1V8 tristategate_183
.ENDS

.SUBCKT latch_tri_estado_66 In Out1 En1 Write rst VSS VDD_1V8
Xlatch1 Write In conect rst VSS VDD_1V8 latch_182
Xtristategate1 conect En1 Out1 VSS VDD_1V8 tristategate_182
.ENDS

.SUBCKT latch_tri_estado_65 In Out1 En1 Write rst VSS VDD_1V8
Xlatch1 Write In conect rst VSS VDD_1V8 latch_181
Xtristategate1 conect En1 Out1 VSS VDD_1V8 tristategate_181
.ENDS

.SUBCKT latch_tri_estado_64 In Out1 En1 Write rst VSS VDD_1V8
Xlatch1 Write In conect rst VSS VDD_1V8 latch_180
Xtristategate1 conect En1 Out1 VSS VDD_1V8 tristategate_180
.ENDS

.SUBCKT latch_tri_estado_63 In Out1 En1 Write rst VSS VDD_1V8
Xlatch1 Write In conect rst VSS VDD_1V8 latch_179
Xtristategate1 conect En1 Out1 VSS VDD_1V8 tristategate_179
.ENDS

.SUBCKT latch_tri_estado_62 In Out1 En1 Write rst VSS VDD_1V8
Xlatch1 Write In conect rst VSS VDD_1V8 latch_178
Xtristategate1 conect En1 Out1 VSS VDD_1V8 tristategate_178
.ENDS

.SUBCKT latch_tri_estado_61 In Out1 En1 Write rst VSS VDD_1V8
Xlatch1 Write In conect rst VSS VDD_1V8 latch_177
Xtristategate1 conect En1 Out1 VSS VDD_1V8 tristategate_177
.ENDS

.SUBCKT latch_tri_estado_60 In Out1 En1 Write rst VSS VDD_1V8
Xlatch1 Write In conect rst VSS VDD_1V8 latch_176
Xtristategate1 conect En1 Out1 VSS VDD_1V8 tristategate_176
.ENDS

.SUBCKT latch_tri_estado_59 In Out1 En1 Write rst VSS VDD_1V8
Xlatch1 Write In conect rst VSS VDD_1V8 latch_175
Xtristategate1 conect En1 Out1 VSS VDD_1V8 tristategate_175
.ENDS

.SUBCKT latch_tri_estado_58 In Out1 En1 Write rst VSS VDD_1V8
Xlatch1 Write In conect rst VSS VDD_1V8 latch_174
Xtristategate1 conect En1 Out1 VSS VDD_1V8 tristategate_174
.ENDS

.SUBCKT latch_tri_estado_57 In Out1 En1 Write rst VSS VDD_1V8
Xlatch1 Write In conect rst VSS VDD_1V8 latch_173
Xtristategate1 conect En1 Out1 VSS VDD_1V8 tristategate_173
.ENDS

.SUBCKT latch_tri_estado_56 In Out1 En1 Write rst VSS VDD_1V8
Xlatch1 Write In conect rst VSS VDD_1V8 latch_172
Xtristategate1 conect En1 Out1 VSS VDD_1V8 tristategate_172
.ENDS

.SUBCKT latch_tri_estado_55 In Out1 En1 Write rst VSS VDD_1V8
Xlatch1 Write In conect rst VSS VDD_1V8 latch_171
Xtristategate1 conect En1 Out1 VSS VDD_1V8 tristategate_171
.ENDS

.SUBCKT latch_tri_estado_54 In Out1 En1 Write rst VSS VDD_1V8
Xlatch1 Write In conect rst VSS VDD_1V8 latch_170
Xtristategate1 conect En1 Out1 VSS VDD_1V8 tristategate_170
.ENDS

.SUBCKT latch_tri_estado_53 In Out1 En1 Write rst VSS VDD_1V8
Xlatch1 Write In conect rst VSS VDD_1V8 latch_169
Xtristategate1 conect En1 Out1 VSS VDD_1V8 tristategate_169
.ENDS

.SUBCKT latch_tri_estado_52 In Out1 En1 Write rst VSS VDD_1V8
Xlatch1 Write In conect rst VSS VDD_1V8 latch_168
Xtristategate1 conect En1 Out1 VSS VDD_1V8 tristategate_168
.ENDS

.SUBCKT latch_tri_estado_51 In Out1 En1 Write rst VSS VDD_1V8
Xlatch1 Write In conect rst VSS VDD_1V8 latch_167
Xtristategate1 conect En1 Out1 VSS VDD_1V8 tristategate_167
.ENDS

.SUBCKT latch_tri_estado_50 In Out1 En1 Write rst VSS VDD_1V8
Xlatch1 Write In conect rst VSS VDD_1V8 latch_166
Xtristategate1 conect En1 Out1 VSS VDD_1V8 tristategate_166
.ENDS

.SUBCKT latch_tri_estado_49 In Out1 En1 Write rst VSS VDD_1V8
Xlatch1 Write In conect rst VSS VDD_1V8 latch_165
Xtristategate1 conect En1 Out1 VSS VDD_1V8 tristategate_165
.ENDS

.SUBCKT latch_tri_estado_48 In Out1 En1 Write rst VSS VDD_1V8
Xlatch1 Write In conect rst VSS VDD_1V8 latch_164
Xtristategate1 conect En1 Out1 VSS VDD_1V8 tristategate_164
.ENDS

.SUBCKT latch_tri_estado_47 In Out1 En1 Write rst VSS VDD_1V8
Xlatch1 Write In conect rst VSS VDD_1V8 latch_163
Xtristategate1 conect En1 Out1 VSS VDD_1V8 tristategate_163
.ENDS

.SUBCKT latch_tri_estado_46 In Out1 En1 Write rst VSS VDD_1V8
Xlatch1 Write In conect rst VSS VDD_1V8 latch_162
Xtristategate1 conect En1 Out1 VSS VDD_1V8 tristategate_162
.ENDS

.SUBCKT latch_tri_estado_45 In Out1 En1 Write rst VSS VDD_1V8
Xlatch1 Write In conect rst VSS VDD_1V8 latch_161
Xtristategate1 conect En1 Out1 VSS VDD_1V8 tristategate_161
.ENDS

.SUBCKT latch_tri_estado_44 In Out1 En1 Write rst VSS VDD_1V8
Xlatch1 Write In conect rst VSS VDD_1V8 latch_160
Xtristategate1 conect En1 Out1 VSS VDD_1V8 tristategate_160
.ENDS

.SUBCKT latch_tri_estado_43 In Out1 En1 Write rst VSS VDD_1V8
Xlatch1 Write In conect rst VSS VDD_1V8 latch_159
Xtristategate1 conect En1 Out1 VSS VDD_1V8 tristategate_159
.ENDS

.SUBCKT latch_tri_estado_42 In Out1 En1 Write rst VSS VDD_1V8
Xlatch1 Write In conect rst VSS VDD_1V8 latch_158
Xtristategate1 conect En1 Out1 VSS VDD_1V8 tristategate_158
.ENDS

.SUBCKT latch_tri_estado_41 In Out1 En1 Write rst VSS VDD_1V8
Xlatch1 Write In conect rst VSS VDD_1V8 latch_157
Xtristategate1 conect En1 Out1 VSS VDD_1V8 tristategate_157
.ENDS

.SUBCKT latch_tri_estado_40 In Out1 En1 Write rst VSS VDD_1V8
Xlatch1 Write In conect rst VSS VDD_1V8 latch_156
Xtristategate1 conect En1 Out1 VSS VDD_1V8 tristategate_156
.ENDS

.SUBCKT latch_tri_estado_39 In Out1 En1 Write rst VSS VDD_1V8
Xlatch1 Write In conect rst VSS VDD_1V8 latch_155
Xtristategate1 conect En1 Out1 VSS VDD_1V8 tristategate_155
.ENDS

.SUBCKT latch_tri_estado_38 In Out1 En1 Write rst VSS VDD_1V8
Xlatch1 Write In conect rst VSS VDD_1V8 latch_154
Xtristategate1 conect En1 Out1 VSS VDD_1V8 tristategate_154
.ENDS

.SUBCKT latch_tri_estado_37 In Out1 En1 Write rst VSS VDD_1V8
Xlatch1 Write In conect rst VSS VDD_1V8 latch_153
Xtristategate1 conect En1 Out1 VSS VDD_1V8 tristategate_153
.ENDS

.SUBCKT latch_tri_estado_36 In Out1 En1 Write rst VSS VDD_1V8
Xlatch1 Write In conect rst VSS VDD_1V8 latch_152
Xtristategate1 conect En1 Out1 VSS VDD_1V8 tristategate_152
.ENDS

.SUBCKT latch_tri_estado_35 In Out1 En1 Write rst VSS VDD_1V8
Xlatch1 Write In conect rst VSS VDD_1V8 latch_151
Xtristategate1 conect En1 Out1 VSS VDD_1V8 tristategate_151
.ENDS

.SUBCKT latch_tri_estado_34 In Out1 En1 Write rst VSS VDD_1V8
Xlatch1 Write In conect rst VSS VDD_1V8 latch_150
Xtristategate1 conect En1 Out1 VSS VDD_1V8 tristategate_150
.ENDS

.SUBCKT latch_tri_estado_33 In Out1 En1 Write rst VSS VDD_1V8
Xlatch1 Write In conect rst VSS VDD_1V8 latch_149
Xtristategate1 conect En1 Out1 VSS VDD_1V8 tristategate_149
.ENDS

.SUBCKT latch_tri_estado_32 In Out1 En1 Write rst VSS VDD_1V8
Xlatch1 Write In conect rst VSS VDD_1V8 latch_148
Xtristategate1 conect En1 Out1 VSS VDD_1V8 tristategate_148
.ENDS

.SUBCKT latch_tri_estado_31 In Out1 En1 Write rst VSS VDD_1V8
Xlatch1 Write In conect rst VSS VDD_1V8 latch_147
Xtristategate1 conect En1 Out1 VSS VDD_1V8 tristategate_147
.ENDS

.SUBCKT latch_tri_estado_30 In Out1 En1 Write rst VSS VDD_1V8
Xlatch1 Write In conect rst VSS VDD_1V8 latch_146
Xtristategate1 conect En1 Out1 VSS VDD_1V8 tristategate_146
.ENDS

.SUBCKT latch_tri_rst0_Hard_115 In Out1_tri En1 Write rst Out_latch VSS VDD_1V8
Xlatch1 Write In Out_latch rst VSS VDD_1V8 latch_145
Xtristategate1 Out_latch En1 Out1_tri VSS VDD_1V8 tristategate_145
.ENDS

.SUBCKT latch_tri_rst0_Hard_114 In Out1_tri En1 Write rst Out_latch VSS VDD_1V8
Xlatch1 Write In Out_latch rst VSS VDD_1V8 latch_144
Xtristategate1 Out_latch En1 Out1_tri VSS VDD_1V8 tristategate_144
.ENDS

.SUBCKT latch_tri_rst0_Hard_113 In Out1_tri En1 Write rst Out_latch VSS VDD_1V8
Xlatch1 Write In Out_latch rst VSS VDD_1V8 latch_143
Xtristategate1 Out_latch En1 Out1_tri VSS VDD_1V8 tristategate_143
.ENDS

.SUBCKT latch_tri_rst0_Hard_112 In Out1_tri En1 Write rst Out_latch VSS VDD_1V8
Xlatch1 Write In Out_latch rst VSS VDD_1V8 latch_142
Xtristategate1 Out_latch En1 Out1_tri VSS VDD_1V8 tristategate_142
.ENDS

.SUBCKT latch_tri_rst0_Hard_111 In Out1_tri En1 Write rst Out_latch VSS VDD_1V8
Xlatch1 Write In Out_latch rst VSS VDD_1V8 latch_141
Xtristategate1 Out_latch En1 Out1_tri VSS VDD_1V8 tristategate_141
.ENDS

.SUBCKT latch_tri_rst0_Hard_110 In Out1_tri En1 Write rst Out_latch VSS VDD_1V8
Xlatch1 Write In Out_latch rst VSS VDD_1V8 latch_140
Xtristategate1 Out_latch En1 Out1_tri VSS VDD_1V8 tristategate_140
.ENDS

.SUBCKT latch_tri_rst0_Hard_109 In Out1_tri En1 Write rst Out_latch VSS VDD_1V8
Xlatch1 Write In Out_latch rst VSS VDD_1V8 latch_139
Xtristategate1 Out_latch En1 Out1_tri VSS VDD_1V8 tristategate_139
.ENDS

.SUBCKT latch_tri_rst0_Hard_108 In Out1_tri En1 Write rst Out_latch VSS VDD_1V8
Xlatch1 Write In Out_latch rst VSS VDD_1V8 latch_138
Xtristategate1 Out_latch En1 Out1_tri VSS VDD_1V8 tristategate_138
.ENDS

.SUBCKT latch_tri_estado_29 In Out1 En1 Write rst VSS VDD_1V8
Xlatch1 Write In conect rst VSS VDD_1V8 latch_137
Xtristategate1 conect En1 Out1 VSS VDD_1V8 tristategate_137
.ENDS

.SUBCKT latch_tri_estado_28 In Out1 En1 Write rst VSS VDD_1V8
Xlatch1 Write In conect rst VSS VDD_1V8 latch_136
Xtristategate1 conect En1 Out1 VSS VDD_1V8 tristategate_136
.ENDS

.SUBCKT latch_tri_estado_27 In Out1 En1 Write rst VSS VDD_1V8
Xlatch1 Write In conect rst VSS VDD_1V8 latch_135
Xtristategate1 conect En1 Out1 VSS VDD_1V8 tristategate_135
.ENDS

.SUBCKT latch_tri_estado_26 In Out1 En1 Write rst VSS VDD_1V8
Xlatch1 Write In conect rst VSS VDD_1V8 latch_134
Xtristategate1 conect En1 Out1 VSS VDD_1V8 tristategate_134
.ENDS

.SUBCKT latch_tri_estado_25 In Out1 En1 Write rst VSS VDD_1V8
Xlatch1 Write In conect rst VSS VDD_1V8 latch_133
Xtristategate1 conect En1 Out1 VSS VDD_1V8 tristategate_133
.ENDS

.SUBCKT latch_tri_estado_24 In Out1 En1 Write rst VSS VDD_1V8
Xlatch1 Write In conect rst VSS VDD_1V8 latch_132
Xtristategate1 conect En1 Out1 VSS VDD_1V8 tristategate_132
.ENDS

.SUBCKT latch_tri_estado_23 In Out1 En1 Write rst VSS VDD_1V8
Xlatch1 Write In conect rst VSS VDD_1V8 latch_131
Xtristategate1 conect En1 Out1 VSS VDD_1V8 tristategate_131
.ENDS

.SUBCKT latch_tri_estado_22 In Out1 En1 Write rst VSS VDD_1V8
Xlatch1 Write In conect rst VSS VDD_1V8 latch_130
Xtristategate1 conect En1 Out1 VSS VDD_1V8 tristategate_130
.ENDS

.SUBCKT latch_tri_estado_21 In Out1 En1 Write rst VSS VDD_1V8
Xlatch1 Write In conect rst VSS VDD_1V8 latch_129
Xtristategate1 conect En1 Out1 VSS VDD_1V8 tristategate_129
.ENDS

.SUBCKT latch_tri_estado_20 In Out1 En1 Write rst VSS VDD_1V8
Xlatch1 Write In conect rst VSS VDD_1V8 latch_128
Xtristategate1 conect En1 Out1 VSS VDD_1V8 tristategate_128
.ENDS

.SUBCKT latch_tri_estado_19 In Out1 En1 Write rst VSS VDD_1V8
Xlatch1 Write In conect rst VSS VDD_1V8 latch_127
Xtristategate1 conect En1 Out1 VSS VDD_1V8 tristategate_127
.ENDS

.SUBCKT latch_tri_estado_18 In Out1 En1 Write rst VSS VDD_1V8
Xlatch1 Write In conect rst VSS VDD_1V8 latch_126
Xtristategate1 conect En1 Out1 VSS VDD_1V8 tristategate_126
.ENDS

.SUBCKT latch_tri_estado_17 In Out1 En1 Write rst VSS VDD_1V8
Xlatch1 Write In conect rst VSS VDD_1V8 latch_125
Xtristategate1 conect En1 Out1 VSS VDD_1V8 tristategate_125
.ENDS

.SUBCKT latch_tri_estado_16 In Out1 En1 Write rst VSS VDD_1V8
Xlatch1 Write In conect rst VSS VDD_1V8 latch_124
Xtristategate1 conect En1 Out1 VSS VDD_1V8 tristategate_124
.ENDS

.SUBCKT latch_tri_estado_15 In Out1 En1 Write rst VSS VDD_1V8
Xlatch1 Write In conect rst VSS VDD_1V8 latch_123
Xtristategate1 conect En1 Out1 VSS VDD_1V8 tristategate_123
.ENDS

.SUBCKT latch_tri_estado_14 In Out1 En1 Write rst VSS VDD_1V8
Xlatch1 Write In conect rst VSS VDD_1V8 latch_122
Xtristategate1 conect En1 Out1 VSS VDD_1V8 tristategate_122
.ENDS

.SUBCKT latch_tri_estado_13 In Out1 En1 Write rst VSS VDD_1V8
Xlatch1 Write In conect rst VSS VDD_1V8 latch_121
Xtristategate1 conect En1 Out1 VSS VDD_1V8 tristategate_121
.ENDS

.SUBCKT latch_tri_estado_12 In Out1 En1 Write rst VSS VDD_1V8
Xlatch1 Write In conect rst VSS VDD_1V8 latch_120
Xtristategate1 conect En1 Out1 VSS VDD_1V8 tristategate_120
.ENDS

.SUBCKT latch_tri_estado_11 In Out1 En1 Write rst VSS VDD_1V8
Xlatch1 Write In conect rst VSS VDD_1V8 latch_119
Xtristategate1 conect En1 Out1 VSS VDD_1V8 tristategate_119
.ENDS

.SUBCKT latch_tri_estado_10 In Out1 En1 Write rst VSS VDD_1V8
Xlatch1 Write In conect rst VSS VDD_1V8 latch_118
Xtristategate1 conect En1 Out1 VSS VDD_1V8 tristategate_118
.ENDS

.SUBCKT latch_tri_estado_9 In Out1 En1 Write rst VSS VDD_1V8
Xlatch1 Write In conect rst VSS VDD_1V8 latch_117
Xtristategate1 conect En1 Out1 VSS VDD_1V8 tristategate_117
.ENDS

.SUBCKT latch_tri_estado_8 In Out1 En1 Write rst VSS VDD_1V8
Xlatch1 Write In conect rst VSS VDD_1V8 latch_116
Xtristategate1 conect En1 Out1 VSS VDD_1V8 tristategate_116
.ENDS

.SUBCKT latch_tri_estado_7 In Out1 En1 Write rst VSS VDD_1V8
Xlatch1 Write In conect rst VSS VDD_1V8 latch_115
Xtristategate1 conect En1 Out1 VSS VDD_1V8 tristategate_115
.ENDS

.SUBCKT latch_tri_estado_6 In Out1 En1 Write rst VSS VDD_1V8
Xlatch1 Write In conect rst VSS VDD_1V8 latch_114
Xtristategate1 conect En1 Out1 VSS VDD_1V8 tristategate_114
.ENDS

.SUBCKT latch_tri_estado_5 In Out1 En1 Write rst VSS VDD_1V8
Xlatch1 Write In conect rst VSS VDD_1V8 latch_113
Xtristategate1 conect En1 Out1 VSS VDD_1V8 tristategate_113
.ENDS

.SUBCKT latch_tri_estado_4 In Out1 En1 Write rst VSS VDD_1V8
Xlatch1 Write In conect rst VSS VDD_1V8 latch_112
Xtristategate1 conect En1 Out1 VSS VDD_1V8 tristategate_112
.ENDS

.SUBCKT latch_tri_estado_3 In Out1 En1 Write rst VSS VDD_1V8
Xlatch1 Write In conect rst VSS VDD_1V8 latch_111
Xtristategate1 conect En1 Out1 VSS VDD_1V8 tristategate_111
.ENDS

.SUBCKT latch_tri_estado_2 In Out1 En1 Write rst VSS VDD_1V8
Xlatch1 Write In conect rst VSS VDD_1V8 latch_110
Xtristategate1 conect En1 Out1 VSS VDD_1V8 tristategate_110
.ENDS

.SUBCKT latch_tri_estado_1 In Out1 En1 Write rst VSS VDD_1V8
Xlatch1 Write In conect rst VSS VDD_1V8 latch_109
Xtristategate1 conect En1 Out1 VSS VDD_1V8 tristategate_109
.ENDS

.SUBCKT latch_tri_estado_0 In Out1 En1 Write rst VSS VDD_1V8
Xlatch1 Write In conect rst VSS VDD_1V8 latch_108
Xtristategate1 conect En1 Out1 VSS VDD_1V8 tristategate_108
.ENDS

.SUBCKT latch_tri_rst0_Hard_107 In Out1_tri En1 Write rst Out_latch VSS VDD_1V8
Xlatch1 Write In Out_latch rst VSS VDD_1V8 latch_107
Xtristategate1 Out_latch En1 Out1_tri VSS VDD_1V8 tristategate_107
.ENDS

.SUBCKT latch_tri_rst0_Hard_106 In Out1_tri En1 Write rst Out_latch VSS VDD_1V8
Xlatch1 Write In Out_latch rst VSS VDD_1V8 latch_106
Xtristategate1 Out_latch En1 Out1_tri VSS VDD_1V8 tristategate_106
.ENDS

.SUBCKT latch_tri_rst0_Hard_105 In Out1_tri En1 Write rst Out_latch VSS VDD_1V8
Xlatch1 Write In Out_latch rst VSS VDD_1V8 latch_105
Xtristategate1 Out_latch En1 Out1_tri VSS VDD_1V8 tristategate_105
.ENDS

.SUBCKT latch_tri_rst0_Hard_104 In Out1_tri En1 Write rst Out_latch VSS VDD_1V8
Xlatch1 Write In Out_latch rst VSS VDD_1V8 latch_104
Xtristategate1 Out_latch En1 Out1_tri VSS VDD_1V8 tristategate_104
.ENDS

.SUBCKT latch_tri_rst0_Hard_103 In Out1_tri En1 Write rst Out_latch VSS VDD_1V8
Xlatch1 Write In Out_latch rst VSS VDD_1V8 latch_103
Xtristategate1 Out_latch En1 Out1_tri VSS VDD_1V8 tristategate_103
.ENDS

.SUBCKT latch_tri_rst0_Hard_102 In Out1_tri En1 Write rst Out_latch VSS VDD_1V8
Xlatch1 Write In Out_latch rst VSS VDD_1V8 latch_102
Xtristategate1 Out_latch En1 Out1_tri VSS VDD_1V8 tristategate_102
.ENDS

.SUBCKT latch_tri_rst0_Hard_101 In Out1_tri En1 Write rst Out_latch VSS VDD_1V8
Xlatch1 Write In Out_latch rst VSS VDD_1V8 latch_101
Xtristategate1 Out_latch En1 Out1_tri VSS VDD_1V8 tristategate_101
.ENDS

.SUBCKT latch_tri_rst0_Hard_100 In Out1_tri En1 Write rst Out_latch VSS VDD_1V8
Xlatch1 Write In Out_latch rst VSS VDD_1V8 latch_100
Xtristategate1 Out_latch En1 Out1_tri VSS VDD_1V8 tristategate_100
.ENDS

.SUBCKT latch_tri_rst0_Hard_99 In Out1_tri En1 Write rst Out_latch VSS VDD_1V8
Xlatch1 Write In Out_latch rst VSS VDD_1V8 latch_99
Xtristategate1 Out_latch En1 Out1_tri VSS VDD_1V8 tristategate_99
.ENDS

.SUBCKT latch_tri_rst0_Hard_98 In Out1_tri En1 Write rst Out_latch VSS VDD_1V8
Xlatch1 Write In Out_latch rst VSS VDD_1V8 latch_98
Xtristategate1 Out_latch En1 Out1_tri VSS VDD_1V8 tristategate_98
.ENDS

.SUBCKT latch_tri_rst0_Hard_97 In Out1_tri En1 Write rst Out_latch VSS VDD_1V8
Xlatch1 Write In Out_latch rst VSS VDD_1V8 latch_97
Xtristategate1 Out_latch En1 Out1_tri VSS VDD_1V8 tristategate_97
.ENDS

.SUBCKT latch_tri_rst0_Hard_96 In Out1_tri En1 Write rst Out_latch VSS VDD_1V8
Xlatch1 Write In Out_latch rst VSS VDD_1V8 latch_96
Xtristategate1 Out_latch En1 Out1_tri VSS VDD_1V8 tristategate_96
.ENDS

.SUBCKT latch_tri_rst0_Hard_95 In Out1_tri En1 Write rst Out_latch VSS VDD_1V8
Xlatch1 Write In Out_latch rst VSS VDD_1V8 latch_95
Xtristategate1 Out_latch En1 Out1_tri VSS VDD_1V8 tristategate_95
.ENDS

.SUBCKT latch_tri_rst0_Hard_94 In Out1_tri En1 Write rst Out_latch VSS VDD_1V8
Xlatch1 Write In Out_latch rst VSS VDD_1V8 latch_94
Xtristategate1 Out_latch En1 Out1_tri VSS VDD_1V8 tristategate_94
.ENDS

.SUBCKT latch_tri_rst0_Hard_93 In Out1_tri En1 Write rst Out_latch VSS VDD_1V8
Xlatch1 Write In Out_latch rst VSS VDD_1V8 latch_93
Xtristategate1 Out_latch En1 Out1_tri VSS VDD_1V8 tristategate_93
.ENDS

.SUBCKT latch_tri_rst0_Hard_92 In Out1_tri En1 Write rst Out_latch VSS VDD_1V8
Xlatch1 Write In Out_latch rst VSS VDD_1V8 latch_92
Xtristategate1 Out_latch En1 Out1_tri VSS VDD_1V8 tristategate_92
.ENDS

.SUBCKT latch_tri_rst0_Hard_91 In Out1_tri En1 Write rst Out_latch VSS VDD_1V8
Xlatch1 Write In Out_latch rst VSS VDD_1V8 latch_91
Xtristategate1 Out_latch En1 Out1_tri VSS VDD_1V8 tristategate_91
.ENDS

.SUBCKT latch_tri_rst0_Hard_90 In Out1_tri En1 Write rst Out_latch VSS VDD_1V8
Xlatch1 Write In Out_latch rst VSS VDD_1V8 latch_90
Xtristategate1 Out_latch En1 Out1_tri VSS VDD_1V8 tristategate_90
.ENDS

.SUBCKT latch_tri_rst0_Hard_89 In Out1_tri En1 Write rst Out_latch VSS VDD_1V8
Xlatch1 Write In Out_latch rst VSS VDD_1V8 latch_89
Xtristategate1 Out_latch En1 Out1_tri VSS VDD_1V8 tristategate_89
.ENDS

.SUBCKT latch_tri_rst0_Hard_88 In Out1_tri En1 Write rst Out_latch VSS VDD_1V8
Xlatch1 Write In Out_latch rst VSS VDD_1V8 latch_88
Xtristategate1 Out_latch En1 Out1_tri VSS VDD_1V8 tristategate_88
.ENDS

.SUBCKT latch_tri_rst0_Hard_87 In Out1_tri En1 Write rst Out_latch VSS VDD_1V8
Xlatch1 Write In Out_latch rst VSS VDD_1V8 latch_87
Xtristategate1 Out_latch En1 Out1_tri VSS VDD_1V8 tristategate_87
.ENDS

.SUBCKT latch_tri_rst0_Hard_86 In Out1_tri En1 Write rst Out_latch VSS VDD_1V8
Xlatch1 Write In Out_latch rst VSS VDD_1V8 latch_86
Xtristategate1 Out_latch En1 Out1_tri VSS VDD_1V8 tristategate_86
.ENDS

.SUBCKT latch_tri_rst0_Hard_85 In Out1_tri En1 Write rst Out_latch VSS VDD_1V8
Xlatch1 Write In Out_latch rst VSS VDD_1V8 latch_85
Xtristategate1 Out_latch En1 Out1_tri VSS VDD_1V8 tristategate_85
.ENDS

.SUBCKT latch_tri_rst0_Hard_84 In Out1_tri En1 Write rst Out_latch VSS VDD_1V8
Xlatch1 Write In Out_latch rst VSS VDD_1V8 latch_84
Xtristategate1 Out_latch En1 Out1_tri VSS VDD_1V8 tristategate_84
.ENDS

.SUBCKT latch_tri_rst0_Hard_83 In Out1_tri En1 Write rst Out_latch VSS VDD_1V8
Xlatch1 Write In Out_latch rst VSS VDD_1V8 latch_83
Xtristategate1 Out_latch En1 Out1_tri VSS VDD_1V8 tristategate_83
.ENDS

.SUBCKT latch_tri_rst0_Hard_82 In Out1_tri En1 Write rst Out_latch VSS VDD_1V8
Xlatch1 Write In Out_latch rst VSS VDD_1V8 latch_82
Xtristategate1 Out_latch En1 Out1_tri VSS VDD_1V8 tristategate_82
.ENDS

.SUBCKT latch_tri_rst0_Hard_81 In Out1_tri En1 Write rst Out_latch VSS VDD_1V8
Xlatch1 Write In Out_latch rst VSS VDD_1V8 latch_81
Xtristategate1 Out_latch En1 Out1_tri VSS VDD_1V8 tristategate_81
.ENDS

.SUBCKT latch_tri_rst0_Hard_80 In Out1_tri En1 Write rst Out_latch VSS VDD_1V8
Xlatch1 Write In Out_latch rst VSS VDD_1V8 latch_80
Xtristategate1 Out_latch En1 Out1_tri VSS VDD_1V8 tristategate_80
.ENDS

.SUBCKT latch_tri_rst0_Hard_79 In Out1_tri En1 Write rst Out_latch VSS VDD_1V8
Xlatch1 Write In Out_latch rst VSS VDD_1V8 latch_79
Xtristategate1 Out_latch En1 Out1_tri VSS VDD_1V8 tristategate_79
.ENDS

.SUBCKT latch_tri_rst0_Hard_78 In Out1_tri En1 Write rst Out_latch VSS VDD_1V8
Xlatch1 Write In Out_latch rst VSS VDD_1V8 latch_78
Xtristategate1 Out_latch En1 Out1_tri VSS VDD_1V8 tristategate_78
.ENDS

.SUBCKT latch_tri_rst0_Hard_77 In Out1_tri En1 Write rst Out_latch VSS VDD_1V8
Xlatch1 Write In Out_latch rst VSS VDD_1V8 latch_77
Xtristategate1 Out_latch En1 Out1_tri VSS VDD_1V8 tristategate_77
.ENDS

.SUBCKT latch_tri_rst0_Hard_76 In Out1_tri En1 Write rst Out_latch VSS VDD_1V8
Xlatch1 Write In Out_latch rst VSS VDD_1V8 latch_76
Xtristategate1 Out_latch En1 Out1_tri VSS VDD_1V8 tristategate_76
.ENDS

.SUBCKT latch_tri_rst0_Hard_75 In Out1_tri En1 Write rst Out_latch VSS VDD_1V8
Xlatch1 Write In Out_latch rst VSS VDD_1V8 latch_75
Xtristategate1 Out_latch En1 Out1_tri VSS VDD_1V8 tristategate_75
.ENDS

.SUBCKT latch_tri_rst0_Hard_74 In Out1_tri En1 Write rst Out_latch VSS VDD_1V8
Xlatch1 Write In Out_latch rst VSS VDD_1V8 latch_74
Xtristategate1 Out_latch En1 Out1_tri VSS VDD_1V8 tristategate_74
.ENDS

.SUBCKT latch_tri_rst0_Hard_73 In Out1_tri En1 Write rst Out_latch VSS VDD_1V8
Xlatch1 Write In Out_latch rst VSS VDD_1V8 latch_73
Xtristategate1 Out_latch En1 Out1_tri VSS VDD_1V8 tristategate_73
.ENDS

.SUBCKT latch_tri_rst0_Hard_72 In Out1_tri En1 Write rst Out_latch VSS VDD_1V8
Xlatch1 Write In Out_latch rst VSS VDD_1V8 latch_72
Xtristategate1 Out_latch En1 Out1_tri VSS VDD_1V8 tristategate_72
.ENDS

.SUBCKT latch_tri_rst0_Hard_71 In Out1_tri En1 Write rst Out_latch VSS VDD_1V8
Xlatch1 Write In Out_latch rst VSS VDD_1V8 latch_71
Xtristategate1 Out_latch En1 Out1_tri VSS VDD_1V8 tristategate_71
.ENDS

.SUBCKT latch_tri_rst0_Hard_70 In Out1_tri En1 Write rst Out_latch VSS VDD_1V8
Xlatch1 Write In Out_latch rst VSS VDD_1V8 latch_70
Xtristategate1 Out_latch En1 Out1_tri VSS VDD_1V8 tristategate_70
.ENDS

.SUBCKT latch_tri_rst0_Hard_69 In Out1_tri En1 Write rst Out_latch VSS VDD_1V8
Xlatch1 Write In Out_latch rst VSS VDD_1V8 latch_69
Xtristategate1 Out_latch En1 Out1_tri VSS VDD_1V8 tristategate_69
.ENDS

.SUBCKT latch_tri_rst0_Hard_68 In Out1_tri En1 Write rst Out_latch VSS VDD_1V8
Xlatch1 Write In Out_latch rst VSS VDD_1V8 latch_68
Xtristategate1 Out_latch En1 Out1_tri VSS VDD_1V8 tristategate_68
.ENDS

.SUBCKT latch_tri_rst0_Hard_67 In Out1_tri En1 Write rst Out_latch VSS VDD_1V8
Xlatch1 Write In Out_latch rst VSS VDD_1V8 latch_67
Xtristategate1 Out_latch En1 Out1_tri VSS VDD_1V8 tristategate_67
.ENDS

.SUBCKT latch_tri_rst0_Hard_66 In Out1_tri En1 Write rst Out_latch VSS VDD_1V8
Xlatch1 Write In Out_latch rst VSS VDD_1V8 latch_66
Xtristategate1 Out_latch En1 Out1_tri VSS VDD_1V8 tristategate_66
.ENDS

.SUBCKT latch_tri_rst0_Hard_65 In Out1_tri En1 Write rst Out_latch VSS VDD_1V8
Xlatch1 Write In Out_latch rst VSS VDD_1V8 latch_65
Xtristategate1 Out_latch En1 Out1_tri VSS VDD_1V8 tristategate_65
.ENDS

.SUBCKT latch_tri_rst0_Hard_64 In Out1_tri En1 Write rst Out_latch VSS VDD_1V8
Xlatch1 Write In Out_latch rst VSS VDD_1V8 latch_64
Xtristategate1 Out_latch En1 Out1_tri VSS VDD_1V8 tristategate_64
.ENDS

.SUBCKT latch_tri_rst0_Hard_63 In Out1_tri En1 Write rst Out_latch VSS VDD_1V8
Xlatch1 Write In Out_latch rst VSS VDD_1V8 latch_63
Xtristategate1 Out_latch En1 Out1_tri VSS VDD_1V8 tristategate_63
.ENDS

.SUBCKT latch_tri_rst0_Hard_62 In Out1_tri En1 Write rst Out_latch VSS VDD_1V8
Xlatch1 Write In Out_latch rst VSS VDD_1V8 latch_62
Xtristategate1 Out_latch En1 Out1_tri VSS VDD_1V8 tristategate_62
.ENDS

.SUBCKT latch_tri_rst0_Hard_61 In Out1_tri En1 Write rst Out_latch VSS VDD_1V8
Xlatch1 Write In Out_latch rst VSS VDD_1V8 latch_61
Xtristategate1 Out_latch En1 Out1_tri VSS VDD_1V8 tristategate_61
.ENDS

.SUBCKT latch_tri_rst0_Hard_60 In Out1_tri En1 Write rst Out_latch VSS VDD_1V8
Xlatch1 Write In Out_latch rst VSS VDD_1V8 latch_60
Xtristategate1 Out_latch En1 Out1_tri VSS VDD_1V8 tristategate_60
.ENDS

.SUBCKT latch_tri_rst0_Hard_59 In Out1_tri En1 Write rst Out_latch VSS VDD_1V8
Xlatch1 Write In Out_latch rst VSS VDD_1V8 latch_59
Xtristategate1 Out_latch En1 Out1_tri VSS VDD_1V8 tristategate_59
.ENDS

.SUBCKT latch_tri_rst0_Hard_58 In Out1_tri En1 Write rst Out_latch VSS VDD_1V8
Xlatch1 Write In Out_latch rst VSS VDD_1V8 latch_58
Xtristategate1 Out_latch En1 Out1_tri VSS VDD_1V8 tristategate_58
.ENDS

.SUBCKT latch_tri_rst0_Hard_57 In Out1_tri En1 Write rst Out_latch VSS VDD_1V8
Xlatch1 Write In Out_latch rst VSS VDD_1V8 latch_57
Xtristategate1 Out_latch En1 Out1_tri VSS VDD_1V8 tristategate_57
.ENDS

.SUBCKT latch_tri_rst0_Hard_56 In Out1_tri En1 Write rst Out_latch VSS VDD_1V8
Xlatch1 Write In Out_latch rst VSS VDD_1V8 latch_56
Xtristategate1 Out_latch En1 Out1_tri VSS VDD_1V8 tristategate_56
.ENDS

.SUBCKT latch_tri_rst0_Hard_55 In Out1_tri En1 Write rst Out_latch VSS VDD_1V8
Xlatch1 Write In Out_latch rst VSS VDD_1V8 latch_55
Xtristategate1 Out_latch En1 Out1_tri VSS VDD_1V8 tristategate_55
.ENDS

.SUBCKT latch_tri_rst0_Hard_54 In Out1_tri En1 Write rst Out_latch VSS VDD_1V8
Xlatch1 Write In Out_latch rst VSS VDD_1V8 latch_54
Xtristategate1 Out_latch En1 Out1_tri VSS VDD_1V8 tristategate_54
.ENDS

.SUBCKT latch_tri_rst0_Hard_53 In Out1_tri En1 Write rst Out_latch VSS VDD_1V8
Xlatch1 Write In Out_latch rst VSS VDD_1V8 latch_53
Xtristategate1 Out_latch En1 Out1_tri VSS VDD_1V8 tristategate_53
.ENDS

.SUBCKT latch_tri_rst0_Hard_52 In Out1_tri En1 Write rst Out_latch VSS VDD_1V8
Xlatch1 Write In Out_latch rst VSS VDD_1V8 latch_52
Xtristategate1 Out_latch En1 Out1_tri VSS VDD_1V8 tristategate_52
.ENDS

.SUBCKT latch_tri_rst0_Hard_51 In Out1_tri En1 Write rst Out_latch VSS VDD_1V8
Xlatch1 Write In Out_latch rst VSS VDD_1V8 latch_51
Xtristategate1 Out_latch En1 Out1_tri VSS VDD_1V8 tristategate_51
.ENDS

.SUBCKT latch_tri_rst0_Hard_50 In Out1_tri En1 Write rst Out_latch VSS VDD_1V8
Xlatch1 Write In Out_latch rst VSS VDD_1V8 latch_50
Xtristategate1 Out_latch En1 Out1_tri VSS VDD_1V8 tristategate_50
.ENDS

.SUBCKT latch_tri_rst0_Hard_49 In Out1_tri En1 Write rst Out_latch VSS VDD_1V8
Xlatch1 Write In Out_latch rst VSS VDD_1V8 latch_49
Xtristategate1 Out_latch En1 Out1_tri VSS VDD_1V8 tristategate_49
.ENDS

.SUBCKT latch_tri_rst0_Hard_48 In Out1_tri En1 Write rst Out_latch VSS VDD_1V8
Xlatch1 Write In Out_latch rst VSS VDD_1V8 latch_48
Xtristategate1 Out_latch En1 Out1_tri VSS VDD_1V8 tristategate_48
.ENDS

.SUBCKT latch_tri_rst0_Hard_47 In Out1_tri En1 Write rst Out_latch VSS VDD_1V8
Xlatch1 Write In Out_latch rst VSS VDD_1V8 latch_47
Xtristategate1 Out_latch En1 Out1_tri VSS VDD_1V8 tristategate_47
.ENDS

.SUBCKT latch_tri_rst0_Hard_46 In Out1_tri En1 Write rst Out_latch VSS VDD_1V8
Xlatch1 Write In Out_latch rst VSS VDD_1V8 latch_46
Xtristategate1 Out_latch En1 Out1_tri VSS VDD_1V8 tristategate_46
.ENDS

.SUBCKT latch_tri_rst0_Hard_45 In Out1_tri En1 Write rst Out_latch VSS VDD_1V8
Xlatch1 Write In Out_latch rst VSS VDD_1V8 latch_45
Xtristategate1 Out_latch En1 Out1_tri VSS VDD_1V8 tristategate_45
.ENDS

.SUBCKT latch_tri_rst0_Hard_44 In Out1_tri En1 Write rst Out_latch VSS VDD_1V8
Xlatch1 Write In Out_latch rst VSS VDD_1V8 latch_44
Xtristategate1 Out_latch En1 Out1_tri VSS VDD_1V8 tristategate_44
.ENDS

.SUBCKT latch_tri_rst0_Hard_43 In Out1_tri En1 Write rst Out_latch VSS VDD_1V8
Xlatch1 Write In Out_latch rst VSS VDD_1V8 latch_43
Xtristategate1 Out_latch En1 Out1_tri VSS VDD_1V8 tristategate_43
.ENDS

.SUBCKT latch_tri_rst0_Hard_42 In Out1_tri En1 Write rst Out_latch VSS VDD_1V8
Xlatch1 Write In Out_latch rst VSS VDD_1V8 latch_42
Xtristategate1 Out_latch En1 Out1_tri VSS VDD_1V8 tristategate_42
.ENDS

.SUBCKT latch_tri_rst0_Hard_41 In Out1_tri En1 Write rst Out_latch VSS VDD_1V8
Xlatch1 Write In Out_latch rst VSS VDD_1V8 latch_41
Xtristategate1 Out_latch En1 Out1_tri VSS VDD_1V8 tristategate_41
.ENDS

.SUBCKT latch_tri_rst0_Hard_40 In Out1_tri En1 Write rst Out_latch VSS VDD_1V8
Xlatch1 Write In Out_latch rst VSS VDD_1V8 latch_40
Xtristategate1 Out_latch En1 Out1_tri VSS VDD_1V8 tristategate_40
.ENDS

.SUBCKT latch_tri_rst0_Hard_39 In Out1_tri En1 Write rst Out_latch VSS VDD_1V8
Xlatch1 Write In Out_latch rst VSS VDD_1V8 latch_39
Xtristategate1 Out_latch En1 Out1_tri VSS VDD_1V8 tristategate_39
.ENDS

.SUBCKT latch_tri_rst0_Hard_38 In Out1_tri En1 Write rst Out_latch VSS VDD_1V8
Xlatch1 Write In Out_latch rst VSS VDD_1V8 latch_38
Xtristategate1 Out_latch En1 Out1_tri VSS VDD_1V8 tristategate_38
.ENDS

.SUBCKT latch_tri_rst0_Hard_37 In Out1_tri En1 Write rst Out_latch VSS VDD_1V8
Xlatch1 Write In Out_latch rst VSS VDD_1V8 latch_37
Xtristategate1 Out_latch En1 Out1_tri VSS VDD_1V8 tristategate_37
.ENDS

.SUBCKT latch_tri_rst0_Hard_36 In Out1_tri En1 Write rst Out_latch VSS VDD_1V8
Xlatch1 Write In Out_latch rst VSS VDD_1V8 latch_36
Xtristategate1 Out_latch En1 Out1_tri VSS VDD_1V8 tristategate_36
.ENDS

.SUBCKT latch_tri_rst0_Hard_35 In Out1_tri En1 Write rst Out_latch VSS VDD_1V8
Xlatch1 Write In Out_latch rst VSS VDD_1V8 latch_35
Xtristategate1 Out_latch En1 Out1_tri VSS VDD_1V8 tristategate_35
.ENDS

.SUBCKT latch_tri_rst0_Hard_34 In Out1_tri En1 Write rst Out_latch VSS VDD_1V8
Xlatch1 Write In Out_latch rst VSS VDD_1V8 latch_34
Xtristategate1 Out_latch En1 Out1_tri VSS VDD_1V8 tristategate_34
.ENDS

.SUBCKT latch_tri_rst0_Hard_33 In Out1_tri En1 Write rst Out_latch VSS VDD_1V8
Xlatch1 Write In Out_latch rst VSS VDD_1V8 latch_33
Xtristategate1 Out_latch En1 Out1_tri VSS VDD_1V8 tristategate_33
.ENDS

.SUBCKT latch_tri_rst0_Hard_32 In Out1_tri En1 Write rst Out_latch VSS VDD_1V8
Xlatch1 Write In Out_latch rst VSS VDD_1V8 latch_32
Xtristategate1 Out_latch En1 Out1_tri VSS VDD_1V8 tristategate_32
.ENDS

.SUBCKT latch_tri_rst0_Hard_31 In Out1_tri En1 Write rst Out_latch VSS VDD_1V8
Xlatch1 Write In Out_latch rst VSS VDD_1V8 latch_31
Xtristategate1 Out_latch En1 Out1_tri VSS VDD_1V8 tristategate_31
.ENDS

.SUBCKT latch_tri_rst0_Hard_30 In Out1_tri En1 Write rst Out_latch VSS VDD_1V8
Xlatch1 Write In Out_latch rst VSS VDD_1V8 latch_30
Xtristategate1 Out_latch En1 Out1_tri VSS VDD_1V8 tristategate_30
.ENDS

.SUBCKT latch_tri_rst0_Hard_29 In Out1_tri En1 Write rst Out_latch VSS VDD_1V8
Xlatch1 Write In Out_latch rst VSS VDD_1V8 latch_29
Xtristategate1 Out_latch En1 Out1_tri VSS VDD_1V8 tristategate_29
.ENDS

.SUBCKT latch_tri_rst0_Hard_28 In Out1_tri En1 Write rst Out_latch VSS VDD_1V8
Xlatch1 Write In Out_latch rst VSS VDD_1V8 latch_28
Xtristategate1 Out_latch En1 Out1_tri VSS VDD_1V8 tristategate_28
.ENDS

.SUBCKT latch_tri_rst0_Hard_27 In Out1_tri En1 Write rst Out_latch VSS VDD_1V8
Xlatch1 Write In Out_latch rst VSS VDD_1V8 latch_27
Xtristategate1 Out_latch En1 Out1_tri VSS VDD_1V8 tristategate_27
.ENDS

.SUBCKT latch_tri_rst0_Hard_26 In Out1_tri En1 Write rst Out_latch VSS VDD_1V8
Xlatch1 Write In Out_latch rst VSS VDD_1V8 latch_26
Xtristategate1 Out_latch En1 Out1_tri VSS VDD_1V8 tristategate_26
.ENDS

.SUBCKT latch_tri_rst0_Hard_25 In Out1_tri En1 Write rst Out_latch VSS VDD_1V8
Xlatch1 Write In Out_latch rst VSS VDD_1V8 latch_25
Xtristategate1 Out_latch En1 Out1_tri VSS VDD_1V8 tristategate_25
.ENDS

.SUBCKT latch_tri_rst0_Hard_24 In Out1_tri En1 Write rst Out_latch VSS VDD_1V8
Xlatch1 Write In Out_latch rst VSS VDD_1V8 latch_24
Xtristategate1 Out_latch En1 Out1_tri VSS VDD_1V8 tristategate_24
.ENDS

.SUBCKT latch_tri_rst0_Hard_23 In Out1_tri En1 Write rst Out_latch VSS VDD_1V8
Xlatch1 Write In Out_latch rst VSS VDD_1V8 latch_23
Xtristategate1 Out_latch En1 Out1_tri VSS VDD_1V8 tristategate_23
.ENDS

.SUBCKT latch_tri_rst0_Hard_22 In Out1_tri En1 Write rst Out_latch VSS VDD_1V8
Xlatch1 Write In Out_latch rst VSS VDD_1V8 latch_22
Xtristategate1 Out_latch En1 Out1_tri VSS VDD_1V8 tristategate_22
.ENDS

.SUBCKT latch_tri_rst0_Hard_21 In Out1_tri En1 Write rst Out_latch VSS VDD_1V8
Xlatch1 Write In Out_latch rst VSS VDD_1V8 latch_21
Xtristategate1 Out_latch En1 Out1_tri VSS VDD_1V8 tristategate_21
.ENDS

.SUBCKT latch_tri_rst0_Hard_20 In Out1_tri En1 Write rst Out_latch VSS VDD_1V8
Xlatch1 Write In Out_latch rst VSS VDD_1V8 latch_20
Xtristategate1 Out_latch En1 Out1_tri VSS VDD_1V8 tristategate_20
.ENDS

.SUBCKT latch_tri_rst0_Hard_19 In Out1_tri En1 Write rst Out_latch VSS VDD_1V8
Xlatch1 Write In Out_latch rst VSS VDD_1V8 latch_19
Xtristategate1 Out_latch En1 Out1_tri VSS VDD_1V8 tristategate_19
.ENDS

.SUBCKT latch_tri_rst0_Hard_18 In Out1_tri En1 Write rst Out_latch VSS VDD_1V8
Xlatch1 Write In Out_latch rst VSS VDD_1V8 latch_18
Xtristategate1 Out_latch En1 Out1_tri VSS VDD_1V8 tristategate_18
.ENDS

.SUBCKT latch_tri_rst0_Hard_17 In Out1_tri En1 Write rst Out_latch VSS VDD_1V8
Xlatch1 Write In Out_latch rst VSS VDD_1V8 latch_17
Xtristategate1 Out_latch En1 Out1_tri VSS VDD_1V8 tristategate_17
.ENDS

.SUBCKT latch_tri_rst0_Hard_16 In Out1_tri En1 Write rst Out_latch VSS VDD_1V8
Xlatch1 Write In Out_latch rst VSS VDD_1V8 latch_16
Xtristategate1 Out_latch En1 Out1_tri VSS VDD_1V8 tristategate_16
.ENDS

.SUBCKT latch_tri_rst0_Hard_15 In Out1_tri En1 Write rst Out_latch VSS VDD_1V8
Xlatch1 Write In Out_latch rst VSS VDD_1V8 latch_15
Xtristategate1 Out_latch En1 Out1_tri VSS VDD_1V8 tristategate_15
.ENDS

.SUBCKT latch_tri_rst0_Hard_14 In Out1_tri En1 Write rst Out_latch VSS VDD_1V8
Xlatch1 Write In Out_latch rst VSS VDD_1V8 latch_14
Xtristategate1 Out_latch En1 Out1_tri VSS VDD_1V8 tristategate_14
.ENDS

.SUBCKT latch_tri_rst0_Hard_13 In Out1_tri En1 Write rst Out_latch VSS VDD_1V8
Xlatch1 Write In Out_latch rst VSS VDD_1V8 latch_13
Xtristategate1 Out_latch En1 Out1_tri VSS VDD_1V8 tristategate_13
.ENDS

.SUBCKT latch_tri_rst0_Hard_12 In Out1_tri En1 Write rst Out_latch VSS VDD_1V8
Xlatch1 Write In Out_latch rst VSS VDD_1V8 latch_12
Xtristategate1 Out_latch En1 Out1_tri VSS VDD_1V8 tristategate_12
.ENDS

.SUBCKT latch_tri_rst0_Hard_11 In Out1_tri En1 Write rst Out_latch VSS VDD_1V8
Xlatch1 Write In Out_latch rst VSS VDD_1V8 latch_11
Xtristategate1 Out_latch En1 Out1_tri VSS VDD_1V8 tristategate_11
.ENDS

.SUBCKT latch_tri_rst0_Hard_10 In Out1_tri En1 Write rst Out_latch VSS VDD_1V8
Xlatch1 Write In Out_latch rst VSS VDD_1V8 latch_10
Xtristategate1 Out_latch En1 Out1_tri VSS VDD_1V8 tristategate_10
.ENDS

.SUBCKT latch_tri_rst0_Hard_9 In Out1_tri En1 Write rst Out_latch VSS VDD_1V8
Xlatch1 Write In Out_latch rst VSS VDD_1V8 latch_9
Xtristategate1 Out_latch En1 Out1_tri VSS VDD_1V8 tristategate_9
.ENDS

.SUBCKT latch_tri_rst0_Hard_8 In Out1_tri En1 Write rst Out_latch VSS VDD_1V8
Xlatch1 Write In Out_latch rst VSS VDD_1V8 latch_8
Xtristategate1 Out_latch En1 Out1_tri VSS VDD_1V8 tristategate_8
.ENDS

.SUBCKT latch_tri_rst0_Hard_7 In Out1_tri En1 Write rst Out_latch VSS VDD_1V8
Xlatch1 Write In Out_latch rst VSS VDD_1V8 latch_7
Xtristategate1 Out_latch En1 Out1_tri VSS VDD_1V8 tristategate_7
.ENDS

.SUBCKT latch_tri_rst0_Hard_6 In Out1_tri En1 Write rst Out_latch VSS VDD_1V8
Xlatch1 Write In Out_latch rst VSS VDD_1V8 latch_6
Xtristategate1 Out_latch En1 Out1_tri VSS VDD_1V8 tristategate_6
.ENDS

.SUBCKT latch_tri_rst0_Hard_5 In Out1_tri En1 Write rst Out_latch VSS VDD_1V8
Xlatch1 Write In Out_latch rst VSS VDD_1V8 latch_5
Xtristategate1 Out_latch En1 Out1_tri VSS VDD_1V8 tristategate_5
.ENDS

.SUBCKT latch_tri_rst0_Hard_4 In Out1_tri En1 Write rst Out_latch VSS VDD_1V8
Xlatch1 Write In Out_latch rst VSS VDD_1V8 latch_4
Xtristategate1 Out_latch En1 Out1_tri VSS VDD_1V8 tristategate_4
.ENDS

.SUBCKT latch_tri_rst0_Hard_3 In Out1_tri En1 Write rst Out_latch VSS VDD_1V8
Xlatch1 Write In Out_latch rst VSS VDD_1V8 latch_3
Xtristategate1 Out_latch En1 Out1_tri VSS VDD_1V8 tristategate_3
.ENDS

.SUBCKT latch_tri_rst0_Hard_2 In Out1_tri En1 Write rst Out_latch VSS VDD_1V8
Xlatch1 Write In Out_latch rst VSS VDD_1V8 latch_2
Xtristategate1 Out_latch En1 Out1_tri VSS VDD_1V8 tristategate_2
.ENDS

.SUBCKT latch_tri_rst0_Hard_1 In Out1_tri En1 Write rst Out_latch VSS VDD_1V8
Xlatch1 Write In Out_latch rst VSS VDD_1V8 latch_1
Xtristategate1 Out_latch En1 Out1_tri VSS VDD_1V8 tristategate_1
.ENDS

.SUBCKT latch_tri_rst0_Hard_0 In Out1_tri En1 Write rst Out_latch VSS VDD_1V8
Xlatch1 Write In Out_latch rst VSS VDD_1V8 latch_0
Xtristategate1 Out_latch En1 Out1_tri VSS VDD_1V8 tristategate_0
.ENDS

.SUBCKT prll_d_reg_bits65_19 clk reset D_in[64] D_in[63] D_in[62] D_in[61] D_in[60]
+ D_in[59] D_in[58] D_in[57] D_in[56] D_in[55] D_in[54] D_in[53] D_in[52] D_in[51]
+ D_in[50] D_in[49] D_in[48] D_in[47] D_in[46] D_in[45] D_in[44] D_in[43] D_in[42]
+ D_in[41] D_in[40] D_in[39] D_in[38] D_in[37] D_in[36] D_in[35] D_in[34] D_in[33]
+ D_in[32] D_in[31] D_in[30] D_in[29] D_in[28] D_in[27] D_in[26] D_in[25] D_in[24]
+ D_in[23] D_in[22] D_in[21] D_in[20] D_in[19] D_in[18] D_in[17] D_in[16] D_in[15]
+ D_in[14] D_in[13] D_in[12] D_in[11] D_in[10] D_in[9] D_in[8] D_in[7] D_in[6] D_in[5]
+ D_in[4] D_in[3] D_in[2] D_in[1] D_in[0] D_out[64] D_out[63] D_out[62] D_out[61]
+ D_out[60] D_out[59] D_out[58] D_out[57] D_out[56] D_out[55] D_out[54] D_out[53]
+ D_out[52] D_out[51] D_out[50] D_out[49] D_out[48] D_out[47] D_out[46] D_out[45]
+ D_out[44] D_out[43] D_out[42] D_out[41] D_out[40] D_out[39] D_out[38] D_out[37]
+ D_out[36] D_out[35] D_out[34] D_out[33] D_out[32] D_out[31] D_out[30] D_out[29]
+ D_out[28] D_out[27] D_out[26] D_out[25] D_out[24] D_out[23] D_out[22] D_out[21]
+ D_out[20] D_out[19] D_out[18] D_out[17] D_out[16] D_out[15] D_out[14] D_out[13]
+ D_out[12] D_out[11] D_out[10] D_out[9] D_out[8] D_out[7] D_out[6] D_out[5] D_out[4]
+ D_out[3] D_out[2] D_out[1] D_out[0] VSS VDD_1V8
Xbit__64__prll_regstr_ D_in[64] clk n2 D_out[64] VSS VDD_1V8 dff_async_rst_1259
Xbit__63__prll_regstr_ D_in[63] clk n2 D_out[63] VSS VDD_1V8 dff_async_rst_1260
Xbit__62__prll_regstr_ D_in[62] clk n2 D_out[62] VSS VDD_1V8 dff_async_rst_1261
Xbit__61__prll_regstr_ D_in[61] clk n2 D_out[61] VSS VDD_1V8 dff_async_rst_1262
Xbit__60__prll_regstr_ D_in[60] clk n2 D_out[60] VSS VDD_1V8 dff_async_rst_1263
Xbit__59__prll_regstr_ D_in[59] n3 n1 D_out[59] VSS VDD_1V8 dff_async_rst_1264
Xbit__58__prll_regstr_ D_in[58] n3 n1 D_out[58] VSS VDD_1V8 dff_async_rst_1265
Xbit__57__prll_regstr_ D_in[57] n3 n1 D_out[57] VSS VDD_1V8 dff_async_rst_1266
Xbit__56__prll_regstr_ D_in[56] n3 n1 D_out[56] VSS VDD_1V8 dff_async_rst_1267
Xbit__55__prll_regstr_ D_in[55] n3 n1 D_out[55] VSS VDD_1V8 dff_async_rst_1268
Xbit__54__prll_regstr_ D_in[54] n3 n1 D_out[54] VSS VDD_1V8 dff_async_rst_1269
Xbit__53__prll_regstr_ D_in[53] n3 n1 D_out[53] VSS VDD_1V8 dff_async_rst_1270
Xbit__52__prll_regstr_ D_in[52] n3 n1 D_out[52] VSS VDD_1V8 dff_async_rst_1271
Xbit__51__prll_regstr_ D_in[51] n3 n1 D_out[51] VSS VDD_1V8 dff_async_rst_1272
Xbit__50__prll_regstr_ D_in[50] n3 n1 D_out[50] VSS VDD_1V8 dff_async_rst_1273
Xbit__49__prll_regstr_ D_in[49] n3 n1 D_out[49] VSS VDD_1V8 dff_async_rst_1274
Xbit__48__prll_regstr_ D_in[48] n3 n1 D_out[48] VSS VDD_1V8 dff_async_rst_1275
Xbit__47__prll_regstr_ D_in[47] n3 n1 D_out[47] VSS VDD_1V8 dff_async_rst_1276
Xbit__46__prll_regstr_ D_in[46] n3 n1 D_out[46] VSS VDD_1V8 dff_async_rst_1277
Xbit__45__prll_regstr_ D_in[45] n3 n1 D_out[45] VSS VDD_1V8 dff_async_rst_1278
Xbit__44__prll_regstr_ D_in[44] clk n2 D_out[44] VSS VDD_1V8 dff_async_rst_1279
Xbit__43__prll_regstr_ D_in[43] clk n2 D_out[43] VSS VDD_1V8 dff_async_rst_1280
Xbit__42__prll_regstr_ D_in[42] clk n2 D_out[42] VSS VDD_1V8 dff_async_rst_1281
Xbit__41__prll_regstr_ D_in[41] clk n2 D_out[41] VSS VDD_1V8 dff_async_rst_1282
Xbit__40__prll_regstr_ D_in[40] clk n2 D_out[40] VSS VDD_1V8 dff_async_rst_1283
Xbit__39__prll_regstr_ D_in[39] clk n2 D_out[39] VSS VDD_1V8 dff_async_rst_1284
Xbit__38__prll_regstr_ D_in[38] clk n2 D_out[38] VSS VDD_1V8 dff_async_rst_1285
Xbit__37__prll_regstr_ D_in[37] clk n2 D_out[37] VSS VDD_1V8 dff_async_rst_1286
Xbit__36__prll_regstr_ D_in[36] n3 n1 D_out[36] VSS VDD_1V8 dff_async_rst_1287
Xbit__35__prll_regstr_ D_in[35] n3 n1 D_out[35] VSS VDD_1V8 dff_async_rst_1288
Xbit__34__prll_regstr_ D_in[34] n3 n1 D_out[34] VSS VDD_1V8 dff_async_rst_1289
Xbit__33__prll_regstr_ D_in[33] n3 n1 D_out[33] VSS VDD_1V8 dff_async_rst_1290
Xbit__32__prll_regstr_ D_in[32] n3 n1 D_out[32] VSS VDD_1V8 dff_async_rst_1291
Xbit__31__prll_regstr_ D_in[31] n3 n1 D_out[31] VSS VDD_1V8 dff_async_rst_1292
Xbit__30__prll_regstr_ D_in[30] n3 n1 D_out[30] VSS VDD_1V8 dff_async_rst_1293
Xbit__29__prll_regstr_ D_in[29] n3 n1 D_out[29] VSS VDD_1V8 dff_async_rst_1294
Xbit__28__prll_regstr_ D_in[28] n3 n1 D_out[28] VSS VDD_1V8 dff_async_rst_1295
Xbit__27__prll_regstr_ D_in[27] n3 n1 D_out[27] VSS VDD_1V8 dff_async_rst_1296
Xbit__26__prll_regstr_ D_in[26] n3 n1 D_out[26] VSS VDD_1V8 dff_async_rst_1297
Xbit__25__prll_regstr_ D_in[25] n3 n1 D_out[25] VSS VDD_1V8 dff_async_rst_1298
Xbit__24__prll_regstr_ D_in[24] n3 n1 D_out[24] VSS VDD_1V8 dff_async_rst_1299
Xbit__23__prll_regstr_ D_in[23] n3 n1 D_out[23] VSS VDD_1V8 dff_async_rst_1300
Xbit__22__prll_regstr_ D_in[22] n3 n1 D_out[22] VSS VDD_1V8 dff_async_rst_1301
Xbit__21__prll_regstr_ D_in[21] n3 n1 D_out[21] VSS VDD_1V8 dff_async_rst_1302
Xbit__20__prll_regstr_ D_in[20] n3 n1 D_out[20] VSS VDD_1V8 dff_async_rst_1303
Xbit__19__prll_regstr_ D_in[19] n3 n1 D_out[19] VSS VDD_1V8 dff_async_rst_1304
Xbit__18__prll_regstr_ D_in[18] n3 n1 D_out[18] VSS VDD_1V8 dff_async_rst_1305
Xbit__17__prll_regstr_ D_in[17] n3 n1 D_out[17] VSS VDD_1V8 dff_async_rst_1306
Xbit__16__prll_regstr_ D_in[16] n3 n1 D_out[16] VSS VDD_1V8 dff_async_rst_1307
Xbit__15__prll_regstr_ D_in[15] n3 n1 D_out[15] VSS VDD_1V8 dff_async_rst_1308
Xbit__14__prll_regstr_ D_in[14] n3 n1 D_out[14] VSS VDD_1V8 dff_async_rst_1309
Xbit__13__prll_regstr_ D_in[13] n3 n1 D_out[13] VSS VDD_1V8 dff_async_rst_1310
Xbit__12__prll_regstr_ D_in[12] n3 n1 D_out[12] VSS VDD_1V8 dff_async_rst_1311
Xbit__11__prll_regstr_ D_in[11] n3 n1 D_out[11] VSS VDD_1V8 dff_async_rst_1312
Xbit__10__prll_regstr_ D_in[10] n3 n1 D_out[10] VSS VDD_1V8 dff_async_rst_1313
Xbit__9__prll_regstr_ D_in[9] n3 n1 D_out[9] VSS VDD_1V8 dff_async_rst_1314
Xbit__8__prll_regstr_ D_in[8] n3 n1 D_out[8] VSS VDD_1V8 dff_async_rst_1315
Xbit__7__prll_regstr_ D_in[7] n3 n1 D_out[7] VSS VDD_1V8 dff_async_rst_1316
Xbit__6__prll_regstr_ D_in[6] n3 n1 D_out[6] VSS VDD_1V8 dff_async_rst_1317
Xbit__5__prll_regstr_ D_in[5] n3 n1 D_out[5] VSS VDD_1V8 dff_async_rst_1318
Xbit__4__prll_regstr_ D_in[4] n3 n1 D_out[4] VSS VDD_1V8 dff_async_rst_1319
Xbit__3__prll_regstr_ D_in[3] n3 n1 D_out[3] VSS VDD_1V8 dff_async_rst_1320
Xbit__2__prll_regstr_ D_in[2] n3 n1 D_out[2] VSS VDD_1V8 dff_async_rst_1321
Xbit__1__prll_regstr_ D_in[1] n3 n1 D_out[1] VSS VDD_1V8 dff_async_rst_1322
Xbit__0__prll_regstr_ D_in[0] clk n2 D_out[0] VSS VDD_1V8 dff_async_rst_1323
Xplace3 VSS VDD_1V8 n3 clk BUHDLLX1
Xplace2 n2 VSS VDD_1V8 reset INHDLLX0
Xplace1 n1 VSS VDD_1V8 reset INHDLLX1
.ENDS

.SUBCKT prll_d_reg_bits65_18 clk reset D_in[64] D_in[63] D_in[62] D_in[61] D_in[60]
+ D_in[59] D_in[58] D_in[57] D_in[56] D_in[55] D_in[54] D_in[53] D_in[52] D_in[51]
+ D_in[50] D_in[49] D_in[48] D_in[47] D_in[46] D_in[45] D_in[44] D_in[43] D_in[42]
+ D_in[41] D_in[40] D_in[39] D_in[38] D_in[37] D_in[36] D_in[35] D_in[34] D_in[33]
+ D_in[32] D_in[31] D_in[30] D_in[29] D_in[28] D_in[27] D_in[26] D_in[25] D_in[24]
+ D_in[23] D_in[22] D_in[21] D_in[20] D_in[19] D_in[18] D_in[17] D_in[16] D_in[15]
+ D_in[14] D_in[13] D_in[12] D_in[11] D_in[10] D_in[9] D_in[8] D_in[7] D_in[6] D_in[5]
+ D_in[4] D_in[3] D_in[2] D_in[1] D_in[0] D_out[64] D_out[63] D_out[62] D_out[61]
+ D_out[60] D_out[59] D_out[58] D_out[57] D_out[56] D_out[55] D_out[54] D_out[53]
+ D_out[52] D_out[51] D_out[50] D_out[49] D_out[48] D_out[47] D_out[46] D_out[45]
+ D_out[44] D_out[43] D_out[42] D_out[41] D_out[40] D_out[39] D_out[38] D_out[37]
+ D_out[36] D_out[35] D_out[34] D_out[33] D_out[32] D_out[31] D_out[30] D_out[29]
+ D_out[28] D_out[27] D_out[26] D_out[25] D_out[24] D_out[23] D_out[22] D_out[21]
+ D_out[20] D_out[19] D_out[18] D_out[17] D_out[16] D_out[15] D_out[14] D_out[13]
+ D_out[12] D_out[11] D_out[10] D_out[9] D_out[8] D_out[7] D_out[6] D_out[5] D_out[4]
+ D_out[3] D_out[2] D_out[1] D_out[0] VSS VDD_1V8 IN0
Xbit__63__prll_regstr_ D_in[63] clk n6 D_out[63] VSS VDD_1V8 dff_async_rst_1195
Xbit__62__prll_regstr_ D_in[62] clk n6 D_out[62] VSS VDD_1V8 dff_async_rst_1196
Xbit__59__prll_regstr_ D_in[59] clk n6 D_out[59] VSS VDD_1V8 dff_async_rst_1199
Xbit__58__prll_regstr_ D_in[58] clk n6 D_out[58] VSS VDD_1V8 dff_async_rst_1200
Xbit__57__prll_regstr_ D_in[57] clk n6 D_out[57] VSS VDD_1V8 dff_async_rst_1201
Xbit__56__prll_regstr_ D_in[56] clk n6 D_out[56] VSS VDD_1V8 dff_async_rst_1202
Xbit__55__prll_regstr_ D_in[55] clk n6 D_out[55] VSS VDD_1V8 dff_async_rst_1203
Xbit__54__prll_regstr_ D_in[54] clk n6 D_out[54] VSS VDD_1V8 dff_async_rst_1204
Xbit__53__prll_regstr_ D_in[53] clk n6 D_out[53] VSS VDD_1V8 dff_async_rst_1205
Xbit__52__prll_regstr_ D_in[52] clk n6 D_out[52] VSS VDD_1V8 dff_async_rst_1206
Xbit__51__prll_regstr_ D_in[51] clk n6 D_out[51] VSS VDD_1V8 dff_async_rst_1207
Xbit__50__prll_regstr_ D_in[50] clk n6 D_out[50] VSS VDD_1V8 dff_async_rst_1208
Xbit__49__prll_regstr_ D_in[49] clk n6 D_out[49] VSS VDD_1V8 dff_async_rst_1209
Xbit__48__prll_regstr_ D_in[48] clk n6 D_out[48] VSS VDD_1V8 dff_async_rst_1210
Xbit__47__prll_regstr_ D_in[47] clk n6 D_out[47] VSS VDD_1V8 dff_async_rst_1211
Xbit__46__prll_regstr_ D_in[46] n1 n4 D_out[46] VSS VDD_1V8 dff_async_rst_1212
Xbit__45__prll_regstr_ D_in[45] clk n6 D_out[45] VSS VDD_1V8 dff_async_rst_1213
Xbit__44__prll_regstr_ D_in[44] clk n6 D_out[44] VSS VDD_1V8 dff_async_rst_1214
Xbit__43__prll_regstr_ D_in[43] clk n6 D_out[43] VSS VDD_1V8 dff_async_rst_1215
Xbit__42__prll_regstr_ D_in[42] n1 n4 D_out[42] VSS VDD_1V8 dff_async_rst_1216
Xbit__41__prll_regstr_ D_in[41] clk n6 D_out[41] VSS VDD_1V8 dff_async_rst_1217
Xbit__40__prll_regstr_ D_in[40] clk n6 D_out[40] VSS VDD_1V8 dff_async_rst_1218
Xbit__39__prll_regstr_ D_in[39] n1 n4 D_out[39] VSS VDD_1V8 dff_async_rst_1219
Xbit__38__prll_regstr_ D_in[38] n1 n4 D_out[38] VSS VDD_1V8 dff_async_rst_1220
Xbit__37__prll_regstr_ D_in[37] n1 n4 D_out[37] VSS VDD_1V8 dff_async_rst_1221
Xbit__36__prll_regstr_ D_in[36] n1 n4 D_out[36] VSS VDD_1V8 dff_async_rst_1222
Xbit__35__prll_regstr_ D_in[35] n1 n4 D_out[35] VSS VDD_1V8 dff_async_rst_1223
Xbit__34__prll_regstr_ D_in[34] n1 n4 D_out[34] VSS VDD_1V8 dff_async_rst_1224
Xbit__33__prll_regstr_ D_in[33] n1 n4 D_out[33] VSS VDD_1V8 dff_async_rst_1225
Xbit__32__prll_regstr_ D_in[32] n1 n4 D_out[32] VSS VDD_1V8 dff_async_rst_1226
Xbit__31__prll_regstr_ D_in[31] n1 n4 D_out[31] VSS VDD_1V8 dff_async_rst_1227
Xbit__30__prll_regstr_ D_in[30] n1 n4 D_out[30] VSS VDD_1V8 dff_async_rst_1228
Xbit__29__prll_regstr_ D_in[29] n1 n4 D_out[29] VSS VDD_1V8 dff_async_rst_1229
Xbit__28__prll_regstr_ D_in[28] n1 n4 D_out[28] VSS VDD_1V8 dff_async_rst_1230
Xbit__27__prll_regstr_ D_in[27] n1 n4 D_out[27] VSS VDD_1V8 dff_async_rst_1231
Xbit__26__prll_regstr_ D_in[26] n1 n4 D_out[26] VSS VDD_1V8 dff_async_rst_1232
Xbit__25__prll_regstr_ D_in[25] n1 n4 D_out[25] VSS VDD_1V8 dff_async_rst_1233
Xbit__24__prll_regstr_ D_in[24] n1 n4 D_out[24] VSS VDD_1V8 dff_async_rst_1234
Xbit__23__prll_regstr_ D_in[23] n1 n4 D_out[23] VSS VDD_1V8 dff_async_rst_1235
Xbit__22__prll_regstr_ D_in[22] n1 n4 D_out[22] VSS VDD_1V8 dff_async_rst_1236
Xbit__21__prll_regstr_ D_in[21] n1 n4 D_out[21] VSS VDD_1V8 dff_async_rst_1237
Xbit__20__prll_regstr_ D_in[20] n1 n4 D_out[20] VSS VDD_1V8 dff_async_rst_1238
Xbit__19__prll_regstr_ D_in[19] n1 n4 D_out[19] VSS VDD_1V8 dff_async_rst_1239
Xbit__18__prll_regstr_ D_in[18] n1 n4 D_out[18] VSS VDD_1V8 dff_async_rst_1240
Xbit__17__prll_regstr_ D_in[17] n1 n4 D_out[17] VSS VDD_1V8 dff_async_rst_1241
Xbit__16__prll_regstr_ D_in[16] n1 n4 D_out[16] VSS VDD_1V8 dff_async_rst_1242
Xbit__15__prll_regstr_ D_in[15] n1 n4 D_out[15] VSS VDD_1V8 dff_async_rst_1243
Xbit__14__prll_regstr_ D_in[14] n1 n4 D_out[14] VSS VDD_1V8 dff_async_rst_1244
Xbit__13__prll_regstr_ D_in[13] n1 n4 D_out[13] VSS VDD_1V8 dff_async_rst_1245
Xbit__12__prll_regstr_ D_in[12] n1 n4 D_out[12] VSS VDD_1V8 dff_async_rst_1246
Xbit__11__prll_regstr_ D_in[11] n1 n4 D_out[11] VSS VDD_1V8 dff_async_rst_1247
Xbit__10__prll_regstr_ D_in[10] n1 n4 D_out[10] VSS VDD_1V8 dff_async_rst_1248
Xbit__9__prll_regstr_ D_in[9] n1 n4 D_out[9] VSS VDD_1V8 dff_async_rst_1249
Xbit__8__prll_regstr_ D_in[8] n1 n4 D_out[8] VSS VDD_1V8 dff_async_rst_1250
Xbit__7__prll_regstr_ D_in[7] n1 n4 D_out[7] VSS VDD_1V8 dff_async_rst_1251
Xbit__6__prll_regstr_ D_in[6] n1 n4 D_out[6] VSS VDD_1V8 dff_async_rst_1252
Xbit__5__prll_regstr_ D_in[5] n1 n4 D_out[5] VSS VDD_1V8 dff_async_rst_1253
Xbit__4__prll_regstr_ D_in[4] n1 n4 D_out[4] VSS VDD_1V8 dff_async_rst_1254
Xbit__3__prll_regstr_ D_in[3] n1 n4 D_out[3] VSS VDD_1V8 dff_async_rst_1255
Xbit__2__prll_regstr_ D_in[2] n1 n4 D_out[2] VSS VDD_1V8 dff_async_rst_1256
Xbit__1__prll_regstr_ D_in[1] n1 n4 D_out[1] VSS VDD_1V8 dff_async_rst_1257
Xbit__0__prll_regstr_ D_in[0] n1 n4 D_out[0] VSS VDD_1V8 dff_async_rst_1258
Xplace1 VSS VDD_1V8 n1 clk BUHDLLX0
Xplace4 n6 VSS VDD_1V8 reset INHDLLX0
Xplace3 n4 VSS VDD_1V8 IN0 INHDLLX1
.ENDS

.SUBCKT Arbiter_st_Mchn_2 clk reset condition_a trn_chng_nthng_t_snd VSS VDD_1V8
Xst0 nxt_st clk reset trn_chng_nthng_t_snd VSS VDD_1V8 dff_async_rst_20
XU3 VSS VDD_1V8 nxt_st condition_a trn_chng_nthng_t_snd NO2I1HDLLX0
.ENDS

.SUBCKT prll_wt_st_mchn_2 c_w reset clk rst_w pop wrt_pre s_ds_w bs_rqst ld_w VSS
+ VDD_1V8
Xst_flop_2 ft_st[2] clk reset st[2] VSS VDD_1V8 dff_async_rst_17
Xst_flop_1 ft_st[1] clk reset st[1] VSS VDD_1V8 dff_async_rst_18
Xst_flop_0 ft_st[0] clk reset st[0] VSS VDD_1V8 dff_async_rst_19
XU16 VSS ft_st[1] VDD_1V8 st[0] c_w st[1] n5 OA211HDLLX0
XU15 VSS ft_st[2] n4 n3 VDD_1V8 NO2HDLLX0
XU14 VSS ld_w st[2] n2 VDD_1V8 NO2HDLLX1
XU13 wrt_pre VSS VDD_1V8 st[1] n5 st[0] NO3HDLLX0
XU12 VSS s_ds_w n3 n1 VDD_1V8 NO2HDLLX0
XU11 VSS pop n5 n2 VDD_1V8 NO2HDLLX0
XU10 n1 VSS c_w n3 n2 VDD_1V8 ft_st[0] ON211HDLLX0
XU9 VSS st[0] st[1] VDD_1V8 n2 NA2HDLLX0
XU8 n3 VSS n5 st[1] VDD_1V8 bs_rqst AN21HDLLX0
XU7 n5 VSS VDD_1V8 st[2] INHDLLX0
XU6 n3 VSS VDD_1V8 st[0] INHDLLX0
XU5 VSS rst_w st[0] n1 VDD_1V8 NO2HDLLX0
XU4 n1 VSS VDD_1V8 n4 INHDLLX0
XU3 VSS n4 st[2] st[1] VDD_1V8 NO2HDLLX0
.ENDS

.SUBCKT prll_rd_st_mchn_2 c_r reset clk rst_r push rdi s_ds_r VSS VDD_1V8
Xst_flop_2 ft_st[2] clk reset st[2] VSS VDD_1V8 dff_async_rst_14
Xst_flop_1 ft_st[1] clk reset st[1] VSS VDD_1V8 dff_async_rst_15
Xst_flop_0 ft_st[0] clk reset st[0] VSS VDD_1V8 dff_async_rst_16
XU12 ft_st[1] VSS s_ds_r VDD_1V8 n3 NA2I1HDLLX0
XU11 VSS c_r s_ds_r VDD_1V8 ft_st[2] AND2HDLLX0
XU10 st[2] st[0] VSS VDD_1V8 s_ds_r st[1] NO3I2HDLLX0
XU9 VSS VDD_1V8 rdi n2 st[1] NO2I1HDLLX0
XU8 VSS push st[1] st[0] VDD_1V8 st[2] AND3HDLLX0
XU7 VSS ft_st[0] VDD_1V8 n3 st[1] st[2] ON21HDLLX0
XU6 VSS c_r n2 VDD_1V8 n3 NA2HDLLX0
XU5 VSS VDD_1V8 n2 st[0] st[2] NO2I1HDLLX0
XU3 rst_r VSS VDD_1V8 st[0] st[1] st[2] NO3HDLLX0
.ENDS

.SUBCKT prll_d_reg_bits65_17 clk reset D_in[64] D_in[63] D_in[62] D_in[61] D_in[60]
+ D_in[59] D_in[58] D_in[57] D_in[56] D_in[55] D_in[54] D_in[53] D_in[52] D_in[51]
+ D_in[50] D_in[49] D_in[48] D_in[47] D_in[46] D_in[45] D_in[44] D_in[43] D_in[42]
+ D_in[41] D_in[40] D_in[39] D_in[38] D_in[37] D_in[36] D_in[35] D_in[34] D_in[33]
+ D_in[32] D_in[31] D_in[30] D_in[29] D_in[28] D_in[27] D_in[26] D_in[25] D_in[24]
+ D_in[23] D_in[22] D_in[21] D_in[20] D_in[19] D_in[18] D_in[17] D_in[16] D_in[15]
+ D_in[14] D_in[13] D_in[12] D_in[11] D_in[10] D_in[9] D_in[8] D_in[7] D_in[6] D_in[5]
+ D_in[4] D_in[3] D_in[2] D_in[1] D_in[0] D_out[64] D_out[63] D_out[62] D_out[61]
+ D_out[60] D_out[59] D_out[58] D_out[57] D_out[56] D_out[55] D_out[54] D_out[53]
+ D_out[52] D_out[51] D_out[50] D_out[49] D_out[48] D_out[47] D_out[46] D_out[45]
+ D_out[44] D_out[43] D_out[42] D_out[41] D_out[40] D_out[39] D_out[38] D_out[37]
+ D_out[36] D_out[35] D_out[34] D_out[33] D_out[32] D_out[31] D_out[30] D_out[29]
+ D_out[28] D_out[27] D_out[26] D_out[25] D_out[24] D_out[23] D_out[22] D_out[21]
+ D_out[20] D_out[19] D_out[18] D_out[17] D_out[16] D_out[15] D_out[14] D_out[13]
+ D_out[12] D_out[11] D_out[10] D_out[9] D_out[8] D_out[7] D_out[6] D_out[5] D_out[4]
+ D_out[3] D_out[2] D_out[1] D_out[0] VSS VDD_1V8
Xbit__64__prll_regstr_ D_in[64] n4 n2 D_out[64] VSS VDD_1V8 dff_async_rst_1128
Xbit__63__prll_regstr_ D_in[63] n4 n2 D_out[63] VSS VDD_1V8 dff_async_rst_1129
Xbit__62__prll_regstr_ D_in[62] n4 n2 D_out[62] VSS VDD_1V8 dff_async_rst_1130
Xbit__59__prll_regstr_ D_in[59] n4 n2 D_out[59] VSS VDD_1V8 dff_async_rst_1133
Xbit__58__prll_regstr_ D_in[58] n4 n2 D_out[58] VSS VDD_1V8 dff_async_rst_1134
Xbit__57__prll_regstr_ D_in[57] n4 n2 D_out[57] VSS VDD_1V8 dff_async_rst_1135
Xbit__54__prll_regstr_ D_in[54] n4 n2 D_out[54] VSS VDD_1V8 dff_async_rst_1138
Xbit__53__prll_regstr_ D_in[53] n4 n2 D_out[53] VSS VDD_1V8 dff_async_rst_1139
Xbit__52__prll_regstr_ D_in[52] n4 n2 D_out[52] VSS VDD_1V8 dff_async_rst_1140
Xbit__51__prll_regstr_ D_in[51] n4 n2 D_out[51] VSS VDD_1V8 dff_async_rst_1141
Xbit__50__prll_regstr_ D_in[50] n4 n2 D_out[50] VSS VDD_1V8 dff_async_rst_1142
Xbit__49__prll_regstr_ D_in[49] n4 n2 D_out[49] VSS VDD_1V8 dff_async_rst_1143
Xbit__48__prll_regstr_ D_in[48] n4 n2 D_out[48] VSS VDD_1V8 dff_async_rst_1144
Xbit__47__prll_regstr_ D_in[47] n4 n2 D_out[47] VSS VDD_1V8 dff_async_rst_1145
Xbit__46__prll_regstr_ D_in[46] clk n1 D_out[46] VSS VDD_1V8 dff_async_rst_1146
Xbit__45__prll_regstr_ D_in[45] n4 n2 D_out[45] VSS VDD_1V8 dff_async_rst_1147
Xbit__44__prll_regstr_ D_in[44] n4 n2 D_out[44] VSS VDD_1V8 dff_async_rst_1148
Xbit__43__prll_regstr_ D_in[43] n4 n2 D_out[43] VSS VDD_1V8 dff_async_rst_1149
Xbit__42__prll_regstr_ D_in[42] n4 n2 D_out[42] VSS VDD_1V8 dff_async_rst_1150
Xbit__41__prll_regstr_ D_in[41] n4 n2 D_out[41] VSS VDD_1V8 dff_async_rst_1151
Xbit__40__prll_regstr_ D_in[40] n4 n2 D_out[40] VSS VDD_1V8 dff_async_rst_1152
Xbit__39__prll_regstr_ D_in[39] n4 n2 D_out[39] VSS VDD_1V8 dff_async_rst_1153
Xbit__38__prll_regstr_ D_in[38] n4 n2 D_out[38] VSS VDD_1V8 dff_async_rst_1154
Xbit__37__prll_regstr_ D_in[37] n4 n2 D_out[37] VSS VDD_1V8 dff_async_rst_1155
Xbit__36__prll_regstr_ D_in[36] n4 n2 D_out[36] VSS VDD_1V8 dff_async_rst_1156
Xbit__35__prll_regstr_ D_in[35] n4 n2 D_out[35] VSS VDD_1V8 dff_async_rst_1157
Xbit__34__prll_regstr_ D_in[34] n4 n2 D_out[34] VSS VDD_1V8 dff_async_rst_1158
Xbit__33__prll_regstr_ D_in[33] clk n1 D_out[33] VSS VDD_1V8 dff_async_rst_1159
Xbit__32__prll_regstr_ D_in[32] clk n1 D_out[32] VSS VDD_1V8 dff_async_rst_1160
Xbit__31__prll_regstr_ D_in[31] n4 n2 D_out[31] VSS VDD_1V8 dff_async_rst_1161
Xbit__30__prll_regstr_ D_in[30] clk n1 D_out[30] VSS VDD_1V8 dff_async_rst_1162
Xbit__29__prll_regstr_ D_in[29] clk n1 D_out[29] VSS VDD_1V8 dff_async_rst_1163
Xbit__28__prll_regstr_ D_in[28] n4 n2 D_out[28] VSS VDD_1V8 dff_async_rst_1164
Xbit__27__prll_regstr_ D_in[27] clk n1 D_out[27] VSS VDD_1V8 dff_async_rst_1165
Xbit__26__prll_regstr_ D_in[26] n4 n2 D_out[26] VSS VDD_1V8 dff_async_rst_1166
Xbit__25__prll_regstr_ D_in[25] n4 n2 D_out[25] VSS VDD_1V8 dff_async_rst_1167
Xbit__24__prll_regstr_ D_in[24] clk n1 D_out[24] VSS VDD_1V8 dff_async_rst_1168
Xbit__23__prll_regstr_ D_in[23] clk n1 D_out[23] VSS VDD_1V8 dff_async_rst_1169
Xbit__22__prll_regstr_ D_in[22] clk n1 D_out[22] VSS VDD_1V8 dff_async_rst_1170
Xbit__21__prll_regstr_ D_in[21] clk n1 D_out[21] VSS VDD_1V8 dff_async_rst_1171
Xbit__20__prll_regstr_ D_in[20] clk n1 D_out[20] VSS VDD_1V8 dff_async_rst_1172
Xbit__19__prll_regstr_ D_in[19] clk n1 D_out[19] VSS VDD_1V8 dff_async_rst_1173
Xbit__18__prll_regstr_ D_in[18] clk n1 D_out[18] VSS VDD_1V8 dff_async_rst_1174
Xbit__17__prll_regstr_ D_in[17] clk n1 D_out[17] VSS VDD_1V8 dff_async_rst_1175
Xbit__16__prll_regstr_ D_in[16] clk n1 D_out[16] VSS VDD_1V8 dff_async_rst_1176
Xbit__15__prll_regstr_ D_in[15] clk n1 D_out[15] VSS VDD_1V8 dff_async_rst_1177
Xbit__14__prll_regstr_ D_in[14] clk n1 D_out[14] VSS VDD_1V8 dff_async_rst_1178
Xbit__13__prll_regstr_ D_in[13] clk n1 D_out[13] VSS VDD_1V8 dff_async_rst_1179
Xbit__12__prll_regstr_ D_in[12] clk n1 D_out[12] VSS VDD_1V8 dff_async_rst_1180
Xbit__11__prll_regstr_ D_in[11] n4 n2 D_out[11] VSS VDD_1V8 dff_async_rst_1181
Xbit__10__prll_regstr_ D_in[10] n4 n2 D_out[10] VSS VDD_1V8 dff_async_rst_1182
Xbit__9__prll_regstr_ D_in[9] clk n1 D_out[9] VSS VDD_1V8 dff_async_rst_1183
Xbit__8__prll_regstr_ D_in[8] n4 n2 D_out[8] VSS VDD_1V8 dff_async_rst_1184
Xbit__7__prll_regstr_ D_in[7] n4 n2 D_out[7] VSS VDD_1V8 dff_async_rst_1185
Xbit__6__prll_regstr_ D_in[6] n4 n2 D_out[6] VSS VDD_1V8 dff_async_rst_1186
Xbit__5__prll_regstr_ D_in[5] n4 n2 D_out[5] VSS VDD_1V8 dff_async_rst_1187
Xbit__4__prll_regstr_ D_in[4] n4 n2 D_out[4] VSS VDD_1V8 dff_async_rst_1188
Xbit__3__prll_regstr_ D_in[3] n4 n2 D_out[3] VSS VDD_1V8 dff_async_rst_1189
Xbit__2__prll_regstr_ D_in[2] n4 n2 D_out[2] VSS VDD_1V8 dff_async_rst_1190
Xbit__1__prll_regstr_ D_in[1] n4 n2 D_out[1] VSS VDD_1V8 dff_async_rst_1191
Xbit__0__prll_regstr_ D_in[0] n4 n2 D_out[0] VSS VDD_1V8 dff_async_rst_1192
Xplace4 VSS VDD_1V8 n4 clk BUHDLLX0
Xplace2 n2 VSS VDD_1V8 reset INHDLLX1
Xplace1 n1 VSS VDD_1V8 reset INHDLLX0
.ENDS

.SUBCKT prll_d_reg_bits65_16 clk reset D_in[64] D_in[63] D_in[62] D_in[61] D_in[60]
+ D_in[59] D_in[58] D_in[57] D_in[56] D_in[55] D_in[54] D_in[53] D_in[52] D_in[51]
+ D_in[50] D_in[49] D_in[48] D_in[47] D_in[46] D_in[45] D_in[44] D_in[43] D_in[42]
+ D_in[41] D_in[40] D_in[39] D_in[38] D_in[37] D_in[36] D_in[35] D_in[34] D_in[33]
+ D_in[32] D_in[31] D_in[30] D_in[29] D_in[28] D_in[27] D_in[26] D_in[25] D_in[24]
+ D_in[23] D_in[22] D_in[21] D_in[20] D_in[19] D_in[18] D_in[17] D_in[16] D_in[15]
+ D_in[14] D_in[13] D_in[12] D_in[11] D_in[10] D_in[9] D_in[8] D_in[7] D_in[6] D_in[5]
+ D_in[4] D_in[3] D_in[2] D_in[1] D_in[0] D_out[64] D_out[63] D_out[62] D_out[61]
+ D_out[60] D_out[59] D_out[58] D_out[57] D_out[56] D_out[55] D_out[54] D_out[53]
+ D_out[52] D_out[51] D_out[50] D_out[49] D_out[48] D_out[47] D_out[46] D_out[45]
+ D_out[44] D_out[43] D_out[42] D_out[41] D_out[40] D_out[39] D_out[38] D_out[37]
+ D_out[36] D_out[35] D_out[34] D_out[33] D_out[32] D_out[31] D_out[30] D_out[29]
+ D_out[28] D_out[27] D_out[26] D_out[25] D_out[24] D_out[23] D_out[22] D_out[21]
+ D_out[20] D_out[19] D_out[18] D_out[17] D_out[16] D_out[15] D_out[14] D_out[13]
+ D_out[12] D_out[11] D_out[10] D_out[9] D_out[8] D_out[7] D_out[6] D_out[5] D_out[4]
+ D_out[3] D_out[2] D_out[1] D_out[0] VSS VDD_1V8 IN0
Xbit__60__prll_regstr_ D_in[60] n1 n3 D_out[60] VSS VDD_1V8 dff_async_rst_1067
Xbit__59__prll_regstr_ D_in[59] n2 n6 D_out[59] VSS VDD_1V8 dff_async_rst_1068
Xbit__58__prll_regstr_ D_in[58] n2 n6 D_out[58] VSS VDD_1V8 dff_async_rst_1069
Xbit__57__prll_regstr_ D_in[57] n2 n6 D_out[57] VSS VDD_1V8 dff_async_rst_1070
Xbit__56__prll_regstr_ D_in[56] n2 n6 D_out[56] VSS VDD_1V8 dff_async_rst_1071
Xbit__55__prll_regstr_ D_in[55] n2 n6 D_out[55] VSS VDD_1V8 dff_async_rst_1072
Xbit__54__prll_regstr_ D_in[54] n2 n6 D_out[54] VSS VDD_1V8 dff_async_rst_1073
Xbit__53__prll_regstr_ D_in[53] n2 n6 D_out[53] VSS VDD_1V8 dff_async_rst_1074
Xbit__52__prll_regstr_ D_in[52] n2 n6 D_out[52] VSS VDD_1V8 dff_async_rst_1075
Xbit__51__prll_regstr_ D_in[51] n2 n6 D_out[51] VSS VDD_1V8 dff_async_rst_1076
Xbit__50__prll_regstr_ D_in[50] n2 n6 D_out[50] VSS VDD_1V8 dff_async_rst_1077
Xbit__49__prll_regstr_ D_in[49] n2 n6 D_out[49] VSS VDD_1V8 dff_async_rst_1078
Xbit__48__prll_regstr_ D_in[48] n2 n6 D_out[48] VSS VDD_1V8 dff_async_rst_1079
Xbit__47__prll_regstr_ D_in[47] n2 n6 D_out[47] VSS VDD_1V8 dff_async_rst_1080
Xbit__46__prll_regstr_ D_in[46] n2 n6 D_out[46] VSS VDD_1V8 dff_async_rst_1081
Xbit__45__prll_regstr_ D_in[45] n2 n6 D_out[45] VSS VDD_1V8 dff_async_rst_1082
Xbit__44__prll_regstr_ D_in[44] n2 n6 D_out[44] VSS VDD_1V8 dff_async_rst_1083
Xbit__43__prll_regstr_ D_in[43] n2 n6 D_out[43] VSS VDD_1V8 dff_async_rst_1084
Xbit__42__prll_regstr_ D_in[42] n2 n6 D_out[42] VSS VDD_1V8 dff_async_rst_1085
Xbit__41__prll_regstr_ D_in[41] n2 n6 D_out[41] VSS VDD_1V8 dff_async_rst_1086
Xbit__40__prll_regstr_ D_in[40] n2 n6 D_out[40] VSS VDD_1V8 dff_async_rst_1087
Xbit__39__prll_regstr_ D_in[39] n2 n6 D_out[39] VSS VDD_1V8 dff_async_rst_1088
Xbit__38__prll_regstr_ D_in[38] n2 n6 D_out[38] VSS VDD_1V8 dff_async_rst_1089
Xbit__37__prll_regstr_ D_in[37] n2 n6 D_out[37] VSS VDD_1V8 dff_async_rst_1090
Xbit__36__prll_regstr_ D_in[36] n2 n6 D_out[36] VSS VDD_1V8 dff_async_rst_1091
Xbit__35__prll_regstr_ D_in[35] n2 n6 D_out[35] VSS VDD_1V8 dff_async_rst_1092
Xbit__34__prll_regstr_ D_in[34] n2 n6 D_out[34] VSS VDD_1V8 dff_async_rst_1093
Xbit__33__prll_regstr_ D_in[33] n2 n6 D_out[33] VSS VDD_1V8 dff_async_rst_1094
Xbit__32__prll_regstr_ D_in[32] n2 n6 D_out[32] VSS VDD_1V8 dff_async_rst_1095
Xbit__31__prll_regstr_ D_in[31] n1 n5 D_out[31] VSS VDD_1V8 dff_async_rst_1096
Xbit__30__prll_regstr_ D_in[30] n1 n5 D_out[30] VSS VDD_1V8 dff_async_rst_1097
Xbit__29__prll_regstr_ D_in[29] n1 n5 D_out[29] VSS VDD_1V8 dff_async_rst_1098
Xbit__28__prll_regstr_ D_in[28] n1 n5 D_out[28] VSS VDD_1V8 dff_async_rst_1099
Xbit__27__prll_regstr_ D_in[27] n1 n5 D_out[27] VSS VDD_1V8 dff_async_rst_1100
Xbit__26__prll_regstr_ D_in[26] n1 n5 D_out[26] VSS VDD_1V8 dff_async_rst_1101
Xbit__25__prll_regstr_ D_in[25] n1 n3 D_out[25] VSS VDD_1V8 dff_async_rst_1102
Xbit__24__prll_regstr_ D_in[24] n1 n5 D_out[24] VSS VDD_1V8 dff_async_rst_1103
Xbit__23__prll_regstr_ D_in[23] n1 n3 D_out[23] VSS VDD_1V8 dff_async_rst_1104
Xbit__22__prll_regstr_ D_in[22] n1 n3 D_out[22] VSS VDD_1V8 dff_async_rst_1105
Xbit__21__prll_regstr_ D_in[21] n1 n3 D_out[21] VSS VDD_1V8 dff_async_rst_1106
Xbit__20__prll_regstr_ D_in[20] n1 n5 D_out[20] VSS VDD_1V8 dff_async_rst_1107
Xbit__19__prll_regstr_ D_in[19] n1 n5 D_out[19] VSS VDD_1V8 dff_async_rst_1108
Xbit__18__prll_regstr_ D_in[18] n1 n5 D_out[18] VSS VDD_1V8 dff_async_rst_1109
Xbit__17__prll_regstr_ D_in[17] n1 n5 D_out[17] VSS VDD_1V8 dff_async_rst_1110
Xbit__16__prll_regstr_ D_in[16] n1 n5 D_out[16] VSS VDD_1V8 dff_async_rst_1111
Xbit__15__prll_regstr_ D_in[15] n1 n5 D_out[15] VSS VDD_1V8 dff_async_rst_1112
Xbit__14__prll_regstr_ D_in[14] n1 n5 D_out[14] VSS VDD_1V8 dff_async_rst_1113
Xbit__13__prll_regstr_ D_in[13] n1 n5 D_out[13] VSS VDD_1V8 dff_async_rst_1114
Xbit__12__prll_regstr_ D_in[12] n1 n5 D_out[12] VSS VDD_1V8 dff_async_rst_1115
Xbit__11__prll_regstr_ D_in[11] n1 n5 D_out[11] VSS VDD_1V8 dff_async_rst_1116
Xbit__10__prll_regstr_ D_in[10] n1 n5 D_out[10] VSS VDD_1V8 dff_async_rst_1117
Xbit__9__prll_regstr_ D_in[9] n1 n3 D_out[9] VSS VDD_1V8 dff_async_rst_1118
Xbit__8__prll_regstr_ D_in[8] n1 n5 D_out[8] VSS VDD_1V8 dff_async_rst_1119
Xbit__7__prll_regstr_ D_in[7] n1 n5 D_out[7] VSS VDD_1V8 dff_async_rst_1120
Xbit__6__prll_regstr_ D_in[6] n1 n5 D_out[6] VSS VDD_1V8 dff_async_rst_1121
Xbit__5__prll_regstr_ D_in[5] n1 n5 D_out[5] VSS VDD_1V8 dff_async_rst_1122
Xbit__4__prll_regstr_ D_in[4] n1 n5 D_out[4] VSS VDD_1V8 dff_async_rst_1123
Xbit__3__prll_regstr_ D_in[3] n1 n5 D_out[3] VSS VDD_1V8 dff_async_rst_1124
Xbit__2__prll_regstr_ D_in[2] n1 n5 D_out[2] VSS VDD_1V8 dff_async_rst_1125
Xbit__1__prll_regstr_ D_in[1] n1 n5 D_out[1] VSS VDD_1V8 dff_async_rst_1126
Xbit__0__prll_regstr_ D_in[0] n1 n5 D_out[0] VSS VDD_1V8 dff_async_rst_1127
Xplace5 n3 VSS VDD_1V8 reset INHDLLX0
Xplace3 n5 VSS VDD_1V8 reset INHDLLX0
Xplace1 VSS VDD_1V8 n1 clk BUHDLLX0
Xplace2 VSS VDD_1V8 n2 clk BUHDLLX0
Xplace4 n6 VSS VDD_1V8 IN0 INHDLLX0
.ENDS

.SUBCKT Arbiter_st_Mchn_1 clk reset condition_a trn_chng_nthng_t_snd VSS VDD_1V8
Xst0 nxt_st clk reset trn_chng_nthng_t_snd VSS VDD_1V8 dff_async_rst_13
XU3 VSS VDD_1V8 nxt_st condition_a trn_chng_nthng_t_snd NO2I1HDLLX0
.ENDS

.SUBCKT prll_wt_st_mchn_1 c_w reset clk rst_w pop wrt_pre s_ds_w bs_rqst ld_w VSS
+ VDD_1V8
Xst_flop_2 ft_st[2] clk reset st[2] VSS VDD_1V8 dff_async_rst_10
Xst_flop_1 ft_st[1] clk reset st[1] VSS VDD_1V8 dff_async_rst_11
Xst_flop_0 ft_st[0] clk reset st[0] VSS VDD_1V8 dff_async_rst_12
XU16 VSS ft_st[1] VDD_1V8 st[0] c_w st[1] n5 OA211HDLLX0
XU15 VSS ft_st[2] n4 n3 VDD_1V8 NO2HDLLX0
XU14 VSS ld_w st[2] n2 VDD_1V8 NO2HDLLX1
XU13 wrt_pre VSS VDD_1V8 st[1] n5 st[0] NO3HDLLX0
XU12 VSS s_ds_w n3 n1 VDD_1V8 NO2HDLLX0
XU11 VSS pop n5 n2 VDD_1V8 NO2HDLLX0
XU10 n1 VSS c_w n3 n2 VDD_1V8 ft_st[0] ON211HDLLX0
XU9 VSS st[0] st[1] VDD_1V8 n2 NA2HDLLX0
XU8 n3 VSS n5 st[1] VDD_1V8 bs_rqst AN21HDLLX0
XU7 n5 VSS VDD_1V8 st[2] INHDLLX0
XU6 n3 VSS VDD_1V8 st[0] INHDLLX0
XU5 VSS rst_w st[0] n1 VDD_1V8 NO2HDLLX0
XU4 n1 VSS VDD_1V8 n4 INHDLLX0
XU3 VSS n4 st[2] st[1] VDD_1V8 NO2HDLLX0
.ENDS

.SUBCKT prll_rd_st_mchn_1 c_r reset clk rst_r push rdi s_ds_r VSS VDD_1V8
Xst_flop_2 ft_st[2] clk reset st[2] VSS VDD_1V8 dff_async_rst_7
Xst_flop_1 ft_st[1] clk reset st[1] VSS VDD_1V8 dff_async_rst_8
Xst_flop_0 ft_st[0] clk reset st[0] VSS VDD_1V8 dff_async_rst_9
XU12 ft_st[1] VSS s_ds_r VDD_1V8 n3 NA2I1HDLLX0
XU11 VSS c_r s_ds_r VDD_1V8 ft_st[2] AND2HDLLX0
XU10 st[2] st[0] VSS VDD_1V8 s_ds_r st[1] NO3I2HDLLX0
XU9 VSS VDD_1V8 rdi n2 st[1] NO2I1HDLLX0
XU8 VSS push st[1] st[0] VDD_1V8 st[2] AND3HDLLX0
XU7 VSS ft_st[0] VDD_1V8 n3 st[1] st[2] ON21HDLLX0
XU6 VSS c_r n2 VDD_1V8 n3 NA2HDLLX0
XU5 VSS VDD_1V8 n2 st[0] st[2] NO2I1HDLLX0
XU3 rst_r VSS VDD_1V8 st[0] st[1] st[2] NO3HDLLX0
.ENDS

.SUBCKT prll_d_reg_bits65_15 clk reset D_in[64] D_in[63] D_in[62] D_in[61] D_in[60]
+ D_in[59] D_in[58] D_in[57] D_in[56] D_in[55] D_in[54] D_in[53] D_in[52] D_in[51]
+ D_in[50] D_in[49] D_in[48] D_in[47] D_in[46] D_in[45] D_in[44] D_in[43] D_in[42]
+ D_in[41] D_in[40] D_in[39] D_in[38] D_in[37] D_in[36] D_in[35] D_in[34] D_in[33]
+ D_in[32] D_in[31] D_in[30] D_in[29] D_in[28] D_in[27] D_in[26] D_in[25] D_in[24]
+ D_in[23] D_in[22] D_in[21] D_in[20] D_in[19] D_in[18] D_in[17] D_in[16] D_in[15]
+ D_in[14] D_in[13] D_in[12] D_in[11] D_in[10] D_in[9] D_in[8] D_in[7] D_in[6] D_in[5]
+ D_in[4] D_in[3] D_in[2] D_in[1] D_in[0] D_out[64] D_out[63] D_out[62] D_out[61]
+ D_out[60] D_out[59] D_out[58] D_out[57] D_out[56] D_out[55] D_out[54] D_out[53]
+ D_out[52] D_out[51] D_out[50] D_out[49] D_out[48] D_out[47] D_out[46] D_out[45]
+ D_out[44] D_out[43] D_out[42] D_out[41] D_out[40] D_out[39] D_out[38] D_out[37]
+ D_out[36] D_out[35] D_out[34] D_out[33] D_out[32] D_out[31] D_out[30] D_out[29]
+ D_out[28] D_out[27] D_out[26] D_out[25] D_out[24] D_out[23] D_out[22] D_out[21]
+ D_out[20] D_out[19] D_out[18] D_out[17] D_out[16] D_out[15] D_out[14] D_out[13]
+ D_out[12] D_out[11] D_out[10] D_out[9] D_out[8] D_out[7] D_out[6] D_out[5] D_out[4]
+ D_out[3] D_out[2] D_out[1] D_out[0] VSS VDD_1V8
Xbit__64__prll_regstr_ D_in[64] n3 n1 D_out[64] VSS VDD_1V8 dff_async_rst_997
Xbit__63__prll_regstr_ D_in[63] n3 n1 D_out[63] VSS VDD_1V8 dff_async_rst_998
Xbit__62__prll_regstr_ D_in[62] n3 n1 D_out[62] VSS VDD_1V8 dff_async_rst_999
Xbit__61__prll_regstr_ D_in[61] clk n2 D_out[61] VSS VDD_1V8 dff_async_rst_1000
Xbit__60__prll_regstr_ D_in[60] clk n2 D_out[60] VSS VDD_1V8 dff_async_rst_1001
Xbit__59__prll_regstr_ D_in[59] n3 n1 D_out[59] VSS VDD_1V8 dff_async_rst_1002
Xbit__58__prll_regstr_ D_in[58] n3 n1 D_out[58] VSS VDD_1V8 dff_async_rst_1003
Xbit__57__prll_regstr_ D_in[57] n3 n1 D_out[57] VSS VDD_1V8 dff_async_rst_1004
Xbit__56__prll_regstr_ D_in[56] n3 n1 D_out[56] VSS VDD_1V8 dff_async_rst_1005
Xbit__55__prll_regstr_ D_in[55] n3 n1 D_out[55] VSS VDD_1V8 dff_async_rst_1006
Xbit__54__prll_regstr_ D_in[54] n3 n1 D_out[54] VSS VDD_1V8 dff_async_rst_1007
Xbit__53__prll_regstr_ D_in[53] n3 n1 D_out[53] VSS VDD_1V8 dff_async_rst_1008
Xbit__52__prll_regstr_ D_in[52] n3 n1 D_out[52] VSS VDD_1V8 dff_async_rst_1009
Xbit__51__prll_regstr_ D_in[51] n3 n1 D_out[51] VSS VDD_1V8 dff_async_rst_1010
Xbit__50__prll_regstr_ D_in[50] n3 n1 D_out[50] VSS VDD_1V8 dff_async_rst_1011
Xbit__49__prll_regstr_ D_in[49] n3 n1 D_out[49] VSS VDD_1V8 dff_async_rst_1012
Xbit__48__prll_regstr_ D_in[48] n3 n1 D_out[48] VSS VDD_1V8 dff_async_rst_1013
Xbit__47__prll_regstr_ D_in[47] n3 n1 D_out[47] VSS VDD_1V8 dff_async_rst_1014
Xbit__46__prll_regstr_ D_in[46] n3 n1 D_out[46] VSS VDD_1V8 dff_async_rst_1015
Xbit__45__prll_regstr_ D_in[45] n3 n1 D_out[45] VSS VDD_1V8 dff_async_rst_1016
Xbit__44__prll_regstr_ D_in[44] n3 n1 D_out[44] VSS VDD_1V8 dff_async_rst_1017
Xbit__43__prll_regstr_ D_in[43] n3 n1 D_out[43] VSS VDD_1V8 dff_async_rst_1018
Xbit__42__prll_regstr_ D_in[42] n3 n1 D_out[42] VSS VDD_1V8 dff_async_rst_1019
Xbit__41__prll_regstr_ D_in[41] n3 n1 D_out[41] VSS VDD_1V8 dff_async_rst_1020
Xbit__40__prll_regstr_ D_in[40] n3 n1 D_out[40] VSS VDD_1V8 dff_async_rst_1021
Xbit__39__prll_regstr_ D_in[39] n3 n1 D_out[39] VSS VDD_1V8 dff_async_rst_1022
Xbit__38__prll_regstr_ D_in[38] n3 n1 D_out[38] VSS VDD_1V8 dff_async_rst_1023
Xbit__37__prll_regstr_ D_in[37] n3 n1 D_out[37] VSS VDD_1V8 dff_async_rst_1024
Xbit__36__prll_regstr_ D_in[36] n3 n1 D_out[36] VSS VDD_1V8 dff_async_rst_1025
Xbit__35__prll_regstr_ D_in[35] n3 n1 D_out[35] VSS VDD_1V8 dff_async_rst_1026
Xbit__34__prll_regstr_ D_in[34] n3 n1 D_out[34] VSS VDD_1V8 dff_async_rst_1027
Xbit__33__prll_regstr_ D_in[33] n3 n1 D_out[33] VSS VDD_1V8 dff_async_rst_1028
Xbit__32__prll_regstr_ D_in[32] n3 n1 D_out[32] VSS VDD_1V8 dff_async_rst_1029
Xbit__31__prll_regstr_ D_in[31] clk n2 D_out[31] VSS VDD_1V8 dff_async_rst_1030
Xbit__30__prll_regstr_ D_in[30] clk n2 D_out[30] VSS VDD_1V8 dff_async_rst_1031
Xbit__29__prll_regstr_ D_in[29] clk n2 D_out[29] VSS VDD_1V8 dff_async_rst_1032
Xbit__28__prll_regstr_ D_in[28] clk n2 D_out[28] VSS VDD_1V8 dff_async_rst_1033
Xbit__27__prll_regstr_ D_in[27] clk n2 D_out[27] VSS VDD_1V8 dff_async_rst_1034
Xbit__26__prll_regstr_ D_in[26] clk n2 D_out[26] VSS VDD_1V8 dff_async_rst_1035
Xbit__25__prll_regstr_ D_in[25] clk n2 D_out[25] VSS VDD_1V8 dff_async_rst_1036
Xbit__24__prll_regstr_ D_in[24] clk n2 D_out[24] VSS VDD_1V8 dff_async_rst_1037
Xbit__23__prll_regstr_ D_in[23] clk n2 D_out[23] VSS VDD_1V8 dff_async_rst_1038
Xbit__22__prll_regstr_ D_in[22] clk n2 D_out[22] VSS VDD_1V8 dff_async_rst_1039
Xbit__21__prll_regstr_ D_in[21] clk n2 D_out[21] VSS VDD_1V8 dff_async_rst_1040
Xbit__20__prll_regstr_ D_in[20] clk n2 D_out[20] VSS VDD_1V8 dff_async_rst_1041
Xbit__19__prll_regstr_ D_in[19] clk n2 D_out[19] VSS VDD_1V8 dff_async_rst_1042
Xbit__18__prll_regstr_ D_in[18] clk n2 D_out[18] VSS VDD_1V8 dff_async_rst_1043
Xbit__17__prll_regstr_ D_in[17] clk n2 D_out[17] VSS VDD_1V8 dff_async_rst_1044
Xbit__16__prll_regstr_ D_in[16] clk n2 D_out[16] VSS VDD_1V8 dff_async_rst_1045
Xbit__15__prll_regstr_ D_in[15] clk n2 D_out[15] VSS VDD_1V8 dff_async_rst_1046
Xbit__14__prll_regstr_ D_in[14] clk n2 D_out[14] VSS VDD_1V8 dff_async_rst_1047
Xbit__13__prll_regstr_ D_in[13] clk n2 D_out[13] VSS VDD_1V8 dff_async_rst_1048
Xbit__12__prll_regstr_ D_in[12] clk n2 D_out[12] VSS VDD_1V8 dff_async_rst_1049
Xbit__11__prll_regstr_ D_in[11] clk n2 D_out[11] VSS VDD_1V8 dff_async_rst_1050
Xbit__10__prll_regstr_ D_in[10] clk n2 D_out[10] VSS VDD_1V8 dff_async_rst_1051
Xbit__9__prll_regstr_ D_in[9] clk n2 D_out[9] VSS VDD_1V8 dff_async_rst_1052
Xbit__8__prll_regstr_ D_in[8] clk n2 D_out[8] VSS VDD_1V8 dff_async_rst_1053
Xbit__7__prll_regstr_ D_in[7] n3 n1 D_out[7] VSS VDD_1V8 dff_async_rst_1054
Xbit__6__prll_regstr_ D_in[6] n3 n1 D_out[6] VSS VDD_1V8 dff_async_rst_1055
Xbit__5__prll_regstr_ D_in[5] n3 n1 D_out[5] VSS VDD_1V8 dff_async_rst_1056
Xbit__4__prll_regstr_ D_in[4] clk n2 D_out[4] VSS VDD_1V8 dff_async_rst_1057
Xbit__3__prll_regstr_ D_in[3] clk n2 D_out[3] VSS VDD_1V8 dff_async_rst_1058
Xbit__2__prll_regstr_ D_in[2] n3 n1 D_out[2] VSS VDD_1V8 dff_async_rst_1059
Xbit__1__prll_regstr_ D_in[1] clk n2 D_out[1] VSS VDD_1V8 dff_async_rst_1060
Xbit__0__prll_regstr_ D_in[0] n3 n1 D_out[0] VSS VDD_1V8 dff_async_rst_1061
Xplace3 VSS VDD_1V8 n3 clk BUHDLLX0
Xplace2 n2 VSS VDD_1V8 reset INHDLLX0
Xplace1 n1 VSS VDD_1V8 reset INHDLLX1
.ENDS

.SUBCKT prll_d_reg_bits65_14 clk reset D_in[64] D_in[63] D_in[62] D_in[61] D_in[60]
+ D_in[59] D_in[58] D_in[57] D_in[56] D_in[55] D_in[54] D_in[53] D_in[52] D_in[51]
+ D_in[50] D_in[49] D_in[48] D_in[47] D_in[46] D_in[45] D_in[44] D_in[43] D_in[42]
+ D_in[41] D_in[40] D_in[39] D_in[38] D_in[37] D_in[36] D_in[35] D_in[34] D_in[33]
+ D_in[32] D_in[31] D_in[30] D_in[29] D_in[28] D_in[27] D_in[26] D_in[25] D_in[24]
+ D_in[23] D_in[22] D_in[21] D_in[20] D_in[19] D_in[18] D_in[17] D_in[16] D_in[15]
+ D_in[14] D_in[13] D_in[12] D_in[11] D_in[10] D_in[9] D_in[8] D_in[7] D_in[6] D_in[5]
+ D_in[4] D_in[3] D_in[2] D_in[1] D_in[0] D_out[64] D_out[63] D_out[62] D_out[61]
+ D_out[60] D_out[59] D_out[58] D_out[57] D_out[56] D_out[55] D_out[54] D_out[53]
+ D_out[52] D_out[51] D_out[50] D_out[49] D_out[48] D_out[47] D_out[46] D_out[45]
+ D_out[44] D_out[43] D_out[42] D_out[41] D_out[40] D_out[39] D_out[38] D_out[37]
+ D_out[36] D_out[35] D_out[34] D_out[33] D_out[32] D_out[31] D_out[30] D_out[29]
+ D_out[28] D_out[27] D_out[26] D_out[25] D_out[24] D_out[23] D_out[22] D_out[21]
+ D_out[20] D_out[19] D_out[18] D_out[17] D_out[16] D_out[15] D_out[14] D_out[13]
+ D_out[12] D_out[11] D_out[10] D_out[9] D_out[8] D_out[7] D_out[6] D_out[5] D_out[4]
+ D_out[3] D_out[2] D_out[1] D_out[0] VSS VDD_1V8 IN0
Xbit__63__prll_regstr_ D_in[63] n1 n6 D_out[63] VSS VDD_1V8 dff_async_rst_933
Xbit__62__prll_regstr_ D_in[62] n1 n6 D_out[62] VSS VDD_1V8 dff_async_rst_934
Xbit__61__prll_regstr_ D_in[61] n1 n6 D_out[61] VSS VDD_1V8 dff_async_rst_935
Xbit__60__prll_regstr_ D_in[60] n1 n6 D_out[60] VSS VDD_1V8 dff_async_rst_936
Xbit__59__prll_regstr_ D_in[59] n1 n6 D_out[59] VSS VDD_1V8 dff_async_rst_937
Xbit__58__prll_regstr_ D_in[58] n1 n6 D_out[58] VSS VDD_1V8 dff_async_rst_938
Xbit__57__prll_regstr_ D_in[57] n1 n6 D_out[57] VSS VDD_1V8 dff_async_rst_939
Xbit__56__prll_regstr_ D_in[56] n1 n6 D_out[56] VSS VDD_1V8 dff_async_rst_940
Xbit__55__prll_regstr_ D_in[55] n1 n6 D_out[55] VSS VDD_1V8 dff_async_rst_941
Xbit__54__prll_regstr_ D_in[54] n1 n6 D_out[54] VSS VDD_1V8 dff_async_rst_942
Xbit__53__prll_regstr_ D_in[53] n1 n6 D_out[53] VSS VDD_1V8 dff_async_rst_943
Xbit__52__prll_regstr_ D_in[52] n1 n6 D_out[52] VSS VDD_1V8 dff_async_rst_944
Xbit__51__prll_regstr_ D_in[51] n1 n6 D_out[51] VSS VDD_1V8 dff_async_rst_945
Xbit__50__prll_regstr_ D_in[50] n1 n6 D_out[50] VSS VDD_1V8 dff_async_rst_946
Xbit__49__prll_regstr_ D_in[49] n1 n6 D_out[49] VSS VDD_1V8 dff_async_rst_947
Xbit__48__prll_regstr_ D_in[48] n1 n6 D_out[48] VSS VDD_1V8 dff_async_rst_948
Xbit__47__prll_regstr_ D_in[47] n1 n6 D_out[47] VSS VDD_1V8 dff_async_rst_949
Xbit__46__prll_regstr_ D_in[46] n1 n6 D_out[46] VSS VDD_1V8 dff_async_rst_950
Xbit__45__prll_regstr_ D_in[45] n1 n6 D_out[45] VSS VDD_1V8 dff_async_rst_951
Xbit__44__prll_regstr_ D_in[44] n1 n6 D_out[44] VSS VDD_1V8 dff_async_rst_952
Xbit__43__prll_regstr_ D_in[43] n1 n6 D_out[43] VSS VDD_1V8 dff_async_rst_953
Xbit__42__prll_regstr_ D_in[42] n1 n6 D_out[42] VSS VDD_1V8 dff_async_rst_954
Xbit__41__prll_regstr_ D_in[41] n1 n6 D_out[41] VSS VDD_1V8 dff_async_rst_955
Xbit__40__prll_regstr_ D_in[40] n1 n6 D_out[40] VSS VDD_1V8 dff_async_rst_956
Xbit__39__prll_regstr_ D_in[39] n1 n6 D_out[39] VSS VDD_1V8 dff_async_rst_957
Xbit__38__prll_regstr_ D_in[38] n1 n6 D_out[38] VSS VDD_1V8 dff_async_rst_958
Xbit__37__prll_regstr_ D_in[37] n1 n6 D_out[37] VSS VDD_1V8 dff_async_rst_959
Xbit__36__prll_regstr_ D_in[36] n1 n6 D_out[36] VSS VDD_1V8 dff_async_rst_960
Xbit__35__prll_regstr_ D_in[35] n1 n6 D_out[35] VSS VDD_1V8 dff_async_rst_961
Xbit__34__prll_regstr_ D_in[34] n1 n6 D_out[34] VSS VDD_1V8 dff_async_rst_962
Xbit__33__prll_regstr_ D_in[33] n1 n6 D_out[33] VSS VDD_1V8 dff_async_rst_963
Xbit__32__prll_regstr_ D_in[32] n1 n6 D_out[32] VSS VDD_1V8 dff_async_rst_964
Xbit__31__prll_regstr_ D_in[31] n1 n6 D_out[31] VSS VDD_1V8 dff_async_rst_965
Xbit__30__prll_regstr_ D_in[30] n1 n6 D_out[30] VSS VDD_1V8 dff_async_rst_966
Xbit__29__prll_regstr_ D_in[29] n1 n6 D_out[29] VSS VDD_1V8 dff_async_rst_967
Xbit__28__prll_regstr_ D_in[28] clk n4 D_out[28] VSS VDD_1V8 dff_async_rst_968
Xbit__27__prll_regstr_ D_in[27] n1 n6 D_out[27] VSS VDD_1V8 dff_async_rst_969
Xbit__26__prll_regstr_ D_in[26] n1 n6 D_out[26] VSS VDD_1V8 dff_async_rst_970
Xbit__25__prll_regstr_ D_in[25] n1 n6 D_out[25] VSS VDD_1V8 dff_async_rst_971
Xbit__24__prll_regstr_ D_in[24] n1 n6 D_out[24] VSS VDD_1V8 dff_async_rst_972
Xbit__23__prll_regstr_ D_in[23] clk n4 D_out[23] VSS VDD_1V8 dff_async_rst_973
Xbit__22__prll_regstr_ D_in[22] clk n4 D_out[22] VSS VDD_1V8 dff_async_rst_974
Xbit__21__prll_regstr_ D_in[21] clk n4 D_out[21] VSS VDD_1V8 dff_async_rst_975
Xbit__20__prll_regstr_ D_in[20] clk n4 D_out[20] VSS VDD_1V8 dff_async_rst_976
Xbit__19__prll_regstr_ D_in[19] clk n4 D_out[19] VSS VDD_1V8 dff_async_rst_977
Xbit__18__prll_regstr_ D_in[18] clk n4 D_out[18] VSS VDD_1V8 dff_async_rst_978
Xbit__17__prll_regstr_ D_in[17] clk n4 D_out[17] VSS VDD_1V8 dff_async_rst_979
Xbit__16__prll_regstr_ D_in[16] clk n4 D_out[16] VSS VDD_1V8 dff_async_rst_980
Xbit__15__prll_regstr_ D_in[15] clk n4 D_out[15] VSS VDD_1V8 dff_async_rst_981
Xbit__14__prll_regstr_ D_in[14] clk n4 D_out[14] VSS VDD_1V8 dff_async_rst_982
Xbit__13__prll_regstr_ D_in[13] clk n4 D_out[13] VSS VDD_1V8 dff_async_rst_983
Xbit__12__prll_regstr_ D_in[12] clk n4 D_out[12] VSS VDD_1V8 dff_async_rst_984
Xbit__11__prll_regstr_ D_in[11] clk n4 D_out[11] VSS VDD_1V8 dff_async_rst_985
Xbit__10__prll_regstr_ D_in[10] clk n4 D_out[10] VSS VDD_1V8 dff_async_rst_986
Xbit__9__prll_regstr_ D_in[9] clk n4 D_out[9] VSS VDD_1V8 dff_async_rst_987
Xbit__8__prll_regstr_ D_in[8] clk n4 D_out[8] VSS VDD_1V8 dff_async_rst_988
Xbit__7__prll_regstr_ D_in[7] clk n4 D_out[7] VSS VDD_1V8 dff_async_rst_989
Xbit__6__prll_regstr_ D_in[6] clk n4 D_out[6] VSS VDD_1V8 dff_async_rst_990
Xbit__5__prll_regstr_ D_in[5] clk n4 D_out[5] VSS VDD_1V8 dff_async_rst_991
Xbit__4__prll_regstr_ D_in[4] clk n4 D_out[4] VSS VDD_1V8 dff_async_rst_992
Xbit__3__prll_regstr_ D_in[3] clk n4 D_out[3] VSS VDD_1V8 dff_async_rst_993
Xbit__2__prll_regstr_ D_in[2] clk n4 D_out[2] VSS VDD_1V8 dff_async_rst_994
Xbit__1__prll_regstr_ D_in[1] clk n4 D_out[1] VSS VDD_1V8 dff_async_rst_995
Xbit__0__prll_regstr_ D_in[0] clk n4 D_out[0] VSS VDD_1V8 dff_async_rst_996
Xplace4 n6 VSS VDD_1V8 reset INHDLLX1
Xplace3 n4 VSS VDD_1V8 IN0 INHDLLX0
Xplace1 VSS VDD_1V8 n1 clk BUHDLLX0
.ENDS

.SUBCKT Arbiter_st_Mchn_0 clk reset condition_a trn_chng_nthng_t_snd VSS VDD_1V8
Xst0 nxt_st clk reset trn_chng_nthng_t_snd VSS VDD_1V8 dff_async_rst_6
XU3 VSS VDD_1V8 nxt_st condition_a trn_chng_nthng_t_snd NO2I1HDLLX0
.ENDS

.SUBCKT prll_wt_st_mchn_0 c_w reset clk rst_w pop wrt_pre s_ds_w bs_rqst ld_w VSS
+ VDD_1V8
Xst_flop_2 ft_st[2] clk reset st[2] VSS VDD_1V8 dff_async_rst_3
Xst_flop_1 ft_st[1] clk reset st[1] VSS VDD_1V8 dff_async_rst_4
Xst_flop_0 ft_st[0] clk reset st[0] VSS VDD_1V8 dff_async_rst_5
XU16 VSS ft_st[1] VDD_1V8 st[0] c_w st[1] n5 OA211HDLLX0
XU15 VSS ft_st[2] n4 n3 VDD_1V8 NO2HDLLX0
XU14 VSS ld_w st[2] n2 VDD_1V8 NO2HDLLX0
XU13 wrt_pre VSS VDD_1V8 st[1] n5 st[0] NO3HDLLX0
XU12 VSS s_ds_w n3 n1 VDD_1V8 NO2HDLLX0
XU11 VSS pop n5 n2 VDD_1V8 NO2HDLLX0
XU10 n1 VSS c_w n3 n2 VDD_1V8 ft_st[0] ON211HDLLX0
XU9 VSS st[0] st[1] VDD_1V8 n2 NA2HDLLX0
XU8 n3 VSS n5 st[1] VDD_1V8 bs_rqst AN21HDLLX0
XU7 n5 VSS VDD_1V8 st[2] INHDLLX0
XU6 n3 VSS VDD_1V8 st[0] INHDLLX0
XU5 VSS rst_w st[0] n1 VDD_1V8 NO2HDLLX0
XU4 n1 VSS VDD_1V8 n4 INHDLLX0
XU3 VSS n4 st[2] st[1] VDD_1V8 NO2HDLLX0
.ENDS

.SUBCKT prll_rd_st_mchn_0 c_r reset clk rst_r push rdi s_ds_r VSS VDD_1V8 IN0
Xst_flop_2 ft_st[2] clk IN0 st[2] VSS VDD_1V8 dff_async_rst_0
Xst_flop_1 ft_st[1] clk reset st[1] VSS VDD_1V8 dff_async_rst_1
Xst_flop_0 ft_st[0] clk reset st[0] VSS VDD_1V8 dff_async_rst_2
XU12 ft_st[1] VSS s_ds_r VDD_1V8 n3 NA2I1HDLLX0
XU11 VSS c_r s_ds_r VDD_1V8 ft_st[2] AND2HDLLX0
XU10 st[2] st[0] VSS VDD_1V8 s_ds_r st[1] NO3I2HDLLX0
XU9 VSS VDD_1V8 rdi n2 st[1] NO2I1HDLLX1
XU8 VSS push st[1] st[0] VDD_1V8 st[2] AND3HDLLX0
XU7 VSS ft_st[0] VDD_1V8 n3 st[1] st[2] ON21HDLLX0
XU6 VSS c_r n2 VDD_1V8 n3 NA2HDLLX0
XU5 VSS VDD_1V8 n2 st[0] st[2] NO2I1HDLLX0
XU3 rst_r VSS VDD_1V8 st[0] st[1] st[2] NO3HDLLX0
.ENDS

.SUBCKT prll_d_reg_bits65_13 clk reset D_in[64] D_in[63] D_in[62] D_in[61] D_in[60]
+ D_in[59] D_in[58] D_in[57] D_in[56] D_in[55] D_in[54] D_in[53] D_in[52] D_in[51]
+ D_in[50] D_in[49] D_in[48] D_in[47] D_in[46] D_in[45] D_in[44] D_in[43] D_in[42]
+ D_in[41] D_in[40] D_in[39] D_in[38] D_in[37] D_in[36] D_in[35] D_in[34] D_in[33]
+ D_in[32] D_in[31] D_in[30] D_in[29] D_in[28] D_in[27] D_in[26] D_in[25] D_in[24]
+ D_in[23] D_in[22] D_in[21] D_in[20] D_in[19] D_in[18] D_in[17] D_in[16] D_in[15]
+ D_in[14] D_in[13] D_in[12] D_in[11] D_in[10] D_in[9] D_in[8] D_in[7] D_in[6] D_in[5]
+ D_in[4] D_in[3] D_in[2] D_in[1] D_in[0] D_out[64] D_out[63] D_out[62] D_out[61]
+ D_out[60] D_out[59] D_out[58] D_out[57] D_out[56] D_out[55] D_out[54] D_out[53]
+ D_out[52] D_out[51] D_out[50] D_out[49] D_out[48] D_out[47] D_out[46] D_out[45]
+ D_out[44] D_out[43] D_out[42] D_out[41] D_out[40] D_out[39] D_out[38] D_out[37]
+ D_out[36] D_out[35] D_out[34] D_out[33] D_out[32] D_out[31] D_out[30] D_out[29]
+ D_out[28] D_out[27] D_out[26] D_out[25] D_out[24] D_out[23] D_out[22] D_out[21]
+ D_out[20] D_out[19] D_out[18] D_out[17] D_out[16] D_out[15] D_out[14] D_out[13]
+ D_out[12] D_out[11] D_out[10] D_out[9] D_out[8] D_out[7] D_out[6] D_out[5] D_out[4]
+ D_out[3] D_out[2] D_out[1] D_out[0] VSS VDD_1V8 IN0 IN1 IN2 IN3 IN4 IN5 IN6 IN7
+ IN8 IN9 IN10 IN11 IN12 IN13 IN14 IN15 IN16 IN17 IN18 IN19 IN20 IN21 IN22 IN23
+ IN24 IN25 IN26 IN27 IN28 IN29 IN30 IN31 IN32 IN33 IN34 IN35 IN36 IN37 IN38 IN39
+ IN40 IN41 IN42 IN43 IN44 IN45 IN46 IN47 IN48 IN49 IN50 IN51 IN52 IN53 IN54 clk_cts_1
+ clk_cts_2
Xbit__61__prll_regstr_ D_in[61] clk_cts_1 IN21 D_out[61] VSS VDD_1V8 dff_async_rst_869
Xbit__60__prll_regstr_ D_in[60] clk_cts_1 IN26 D_out[60] VSS VDD_1V8 dff_async_rst_870
Xbit__59__prll_regstr_ D_in[59] clk IN37 D_out[59] VSS VDD_1V8 dff_async_rst_871
Xbit__58__prll_regstr_ D_in[58] clk IN40 D_out[58] VSS VDD_1V8 dff_async_rst_872
Xbit__57__prll_regstr_ D_in[57] clk IN39 D_out[57] VSS VDD_1V8 dff_async_rst_873
Xbit__56__prll_regstr_ D_in[56] clk_cts_2 IN42 D_out[56] VSS VDD_1V8 dff_async_rst_874
Xbit__55__prll_regstr_ D_in[55] clk_cts_2 IN38 D_out[55] VSS VDD_1V8 dff_async_rst_875
Xbit__54__prll_regstr_ D_in[54] clk_cts_2 IN35 D_out[54] VSS VDD_1V8 dff_async_rst_876
Xbit__53__prll_regstr_ D_in[53] clk_cts_2 IN34 D_out[53] VSS VDD_1V8 dff_async_rst_877
Xbit__52__prll_regstr_ D_in[52] clk_cts_2 IN41 D_out[52] VSS VDD_1V8 dff_async_rst_878
Xbit__51__prll_regstr_ D_in[51] clk_cts_2 IN36 D_out[51] VSS VDD_1V8 dff_async_rst_879
Xbit__50__prll_regstr_ D_in[50] clk_cts_2 IN45 D_out[50] VSS VDD_1V8 dff_async_rst_880
Xbit__49__prll_regstr_ D_in[49] clk_cts_2 IN44 D_out[49] VSS VDD_1V8 dff_async_rst_881
Xbit__48__prll_regstr_ D_in[48] clk_cts_2 IN33 D_out[48] VSS VDD_1V8 dff_async_rst_882
Xbit__47__prll_regstr_ D_in[47] clk IN29 D_out[47] VSS VDD_1V8 dff_async_rst_883
Xbit__46__prll_regstr_ D_in[46] clk_cts_2 IN28 D_out[46] VSS VDD_1V8 dff_async_rst_884
Xbit__45__prll_regstr_ D_in[45] clk IN30 D_out[45] VSS VDD_1V8 dff_async_rst_885
Xbit__44__prll_regstr_ D_in[44] clk_cts_1 IN27 D_out[44] VSS VDD_1V8 dff_async_rst_886
Xbit__43__prll_regstr_ D_in[43] clk_cts_1 IN23 D_out[43] VSS VDD_1V8 dff_async_rst_887
Xbit__42__prll_regstr_ D_in[42] clk_cts_1 IN19 D_out[42] VSS VDD_1V8 dff_async_rst_888
Xbit__41__prll_regstr_ D_in[41] clk_cts_1 IN25 D_out[41] VSS VDD_1V8 dff_async_rst_889
Xbit__40__prll_regstr_ D_in[40] clk_cts_1 IN22 D_out[40] VSS VDD_1V8 dff_async_rst_890
Xbit__39__prll_regstr_ D_in[39] clk_cts_1 IN20 D_out[39] VSS VDD_1V8 dff_async_rst_891
Xbit__38__prll_regstr_ D_in[38] clk_cts_1 IN54 D_out[38] VSS VDD_1V8 dff_async_rst_892
Xbit__37__prll_regstr_ D_in[37] clk_cts_1 IN18 D_out[37] VSS VDD_1V8 dff_async_rst_893
Xbit__36__prll_regstr_ D_in[36] clk IN53 D_out[36] VSS VDD_1V8 dff_async_rst_894
Xbit__35__prll_regstr_ D_in[35] clk IN14 D_out[35] VSS VDD_1V8 dff_async_rst_895
Xbit__34__prll_regstr_ D_in[34] clk IN13 D_out[34] VSS VDD_1V8 dff_async_rst_896
Xbit__33__prll_regstr_ D_in[33] clk_cts_2 IN3 D_out[33] VSS VDD_1V8 dff_async_rst_897
Xbit__32__prll_regstr_ D_in[32] clk IN10 D_out[32] VSS VDD_1V8 dff_async_rst_898
Xbit__31__prll_regstr_ D_in[31] clk_cts_2 reset D_out[31] VSS VDD_1V8 dff_async_rst_899
Xbit__30__prll_regstr_ D_in[30] clk_cts_2 reset D_out[30] VSS VDD_1V8 dff_async_rst_900
Xbit__29__prll_regstr_ D_in[29] clk_cts_2 IN43 D_out[29] VSS VDD_1V8 dff_async_rst_901
Xbit__28__prll_regstr_ D_in[28] clk_cts_2 IN2 D_out[28] VSS VDD_1V8 dff_async_rst_902
Xbit__27__prll_regstr_ D_in[27] clk_cts_2 reset D_out[27] VSS VDD_1V8 dff_async_rst_903
Xbit__26__prll_regstr_ D_in[26] clk_cts_2 IN1 D_out[26] VSS VDD_1V8 dff_async_rst_904
Xbit__25__prll_regstr_ D_in[25] clk IN0 D_out[25] VSS VDD_1V8 dff_async_rst_905
Xbit__24__prll_regstr_ D_in[24] clk IN5 D_out[24] VSS VDD_1V8 dff_async_rst_906
Xbit__23__prll_regstr_ D_in[23] clk_cts_2 reset D_out[23] VSS VDD_1V8 dff_async_rst_907
Xbit__22__prll_regstr_ D_in[22] clk_cts_2 IN32 D_out[22] VSS VDD_1V8 dff_async_rst_908
Xbit__21__prll_regstr_ D_in[21] clk_cts_2 IN31 D_out[21] VSS VDD_1V8 dff_async_rst_909
Xbit__20__prll_regstr_ D_in[20] clk_cts_2 reset D_out[20] VSS VDD_1V8 dff_async_rst_910
Xbit__19__prll_regstr_ D_in[19] clk_cts_2 reset D_out[19] VSS VDD_1V8 dff_async_rst_911
Xbit__18__prll_regstr_ D_in[18] clk_cts_2 IN7 D_out[18] VSS VDD_1V8 dff_async_rst_912
Xbit__17__prll_regstr_ D_in[17] clk_cts_2 IN8 D_out[17] VSS VDD_1V8 dff_async_rst_913
Xbit__16__prll_regstr_ D_in[16] clk_cts_2 IN4 D_out[16] VSS VDD_1V8 dff_async_rst_914
Xbit__15__prll_regstr_ D_in[15] clk IN12 D_out[15] VSS VDD_1V8 dff_async_rst_915
Xbit__14__prll_regstr_ D_in[14] clk_cts_2 reset D_out[14] VSS VDD_1V8 dff_async_rst_916
Xbit__13__prll_regstr_ D_in[13] clk IN9 D_out[13] VSS VDD_1V8 dff_async_rst_917
Xbit__12__prll_regstr_ D_in[12] clk IN11 D_out[12] VSS VDD_1V8 dff_async_rst_918
Xbit__11__prll_regstr_ D_in[11] clk IN15 D_out[11] VSS VDD_1V8 dff_async_rst_919
Xbit__10__prll_regstr_ D_in[10] clk IN17 D_out[10] VSS VDD_1V8 dff_async_rst_920
Xbit__9__prll_regstr_ D_in[9] clk IN6 D_out[9] VSS VDD_1V8 dff_async_rst_921
Xbit__8__prll_regstr_ D_in[8] clk IN16 D_out[8] VSS VDD_1V8 dff_async_rst_922
Xbit__7__prll_regstr_ D_in[7] clk IN46 D_out[7] VSS VDD_1V8 dff_async_rst_923
Xbit__6__prll_regstr_ D_in[6] clk IN47 D_out[6] VSS VDD_1V8 dff_async_rst_924
Xbit__5__prll_regstr_ D_in[5] clk IN51 D_out[5] VSS VDD_1V8 dff_async_rst_925
Xbit__4__prll_regstr_ D_in[4] clk IN52 D_out[4] VSS VDD_1V8 dff_async_rst_926
Xbit__3__prll_regstr_ D_in[3] clk IN50 D_out[3] VSS VDD_1V8 dff_async_rst_927
Xbit__2__prll_regstr_ D_in[2] clk IN48 D_out[2] VSS VDD_1V8 dff_async_rst_928
Xbit__1__prll_regstr_ D_in[1] clk IN49 D_out[1] VSS VDD_1V8 dff_async_rst_929
Xbit__0__prll_regstr_ D_in[0] clk_cts_1 IN24 D_out[0] VSS VDD_1V8 dff_async_rst_930
.ENDS

.SUBCKT prll_d_reg_bits65_12 clk reset D_in[64] D_in[63] D_in[62] D_in[61] D_in[60]
+ D_in[59] D_in[58] D_in[57] D_in[56] D_in[55] D_in[54] D_in[53] D_in[52] D_in[51]
+ D_in[50] D_in[49] D_in[48] D_in[47] D_in[46] D_in[45] D_in[44] D_in[43] D_in[42]
+ D_in[41] D_in[40] D_in[39] D_in[38] D_in[37] D_in[36] D_in[35] D_in[34] D_in[33]
+ D_in[32] D_in[31] D_in[30] D_in[29] D_in[28] D_in[27] D_in[26] D_in[25] D_in[24]
+ D_in[23] D_in[22] D_in[21] D_in[20] D_in[19] D_in[18] D_in[17] D_in[16] D_in[15]
+ D_in[14] D_in[13] D_in[12] D_in[11] D_in[10] D_in[9] D_in[8] D_in[7] D_in[6] D_in[5]
+ D_in[4] D_in[3] D_in[2] D_in[1] D_in[0] D_out[64] D_out[63] D_out[62] D_out[61]
+ D_out[60] D_out[59] D_out[58] D_out[57] D_out[56] D_out[55] D_out[54] D_out[53]
+ D_out[52] D_out[51] D_out[50] D_out[49] D_out[48] D_out[47] D_out[46] D_out[45]
+ D_out[44] D_out[43] D_out[42] D_out[41] D_out[40] D_out[39] D_out[38] D_out[37]
+ D_out[36] D_out[35] D_out[34] D_out[33] D_out[32] D_out[31] D_out[30] D_out[29]
+ D_out[28] D_out[27] D_out[26] D_out[25] D_out[24] D_out[23] D_out[22] D_out[21]
+ D_out[20] D_out[19] D_out[18] D_out[17] D_out[16] D_out[15] D_out[14] D_out[13]
+ D_out[12] D_out[11] D_out[10] D_out[9] D_out[8] D_out[7] D_out[6] D_out[5] D_out[4]
+ D_out[3] D_out[2] D_out[1] D_out[0] VSS VDD_1V8 IN0 IN1 IN2 IN3 IN4 IN5 IN6 IN7
+ IN8 IN9 IN10 IN11 IN12 IN13 IN14 IN15 IN16 IN17 IN18 IN19 IN20 IN21 IN22 IN23
+ IN24 IN25 IN26 IN27 IN28 IN29 IN30 IN31 IN32 IN33 IN34 IN35 IN36 IN37 IN38 IN39
+ IN40 IN41 IN42 IN43 IN44 IN45 IN46 IN47 IN48 IN49 IN50 IN51 IN52 IN53 IN54 IN55
+ IN56 IN57 IN58 IN59 IN60 clk_cts_1 clk_cts_2
Xbit__61__prll_regstr_ D_in[61] clk_cts_1 IN56 D_out[61] VSS VDD_1V8 dff_async_rst_804
Xbit__60__prll_regstr_ D_in[60] clk_cts_1 IN28 D_out[60] VSS VDD_1V8 dff_async_rst_805
Xbit__59__prll_regstr_ D_in[59] clk_cts_2 IN38 D_out[59] VSS VDD_1V8 dff_async_rst_806
Xbit__58__prll_regstr_ D_in[58] clk IN37 D_out[58] VSS VDD_1V8 dff_async_rst_807
Xbit__57__prll_regstr_ D_in[57] clk_cts_2 IN39 D_out[57] VSS VDD_1V8 dff_async_rst_808
Xbit__56__prll_regstr_ D_in[56] clk_cts_2 IN36 D_out[56] VSS VDD_1V8 dff_async_rst_809
Xbit__55__prll_regstr_ D_in[55] clk_cts_2 IN34 D_out[55] VSS VDD_1V8 dff_async_rst_810
Xbit__54__prll_regstr_ D_in[54] clk_cts_2 IN59 D_out[54] VSS VDD_1V8 dff_async_rst_811
Xbit__53__prll_regstr_ D_in[53] clk_cts_2 IN58 D_out[53] VSS VDD_1V8 dff_async_rst_812
Xbit__52__prll_regstr_ D_in[52] clk_cts_2 IN60 D_out[52] VSS VDD_1V8 dff_async_rst_813
Xbit__51__prll_regstr_ D_in[51] clk_cts_2 reset D_out[51] VSS VDD_1V8 dff_async_rst_814
Xbit__50__prll_regstr_ D_in[50] clk_cts_2 IN35 D_out[50] VSS VDD_1V8 dff_async_rst_815
Xbit__49__prll_regstr_ D_in[49] clk_cts_2 IN0 D_out[49] VSS VDD_1V8 dff_async_rst_816
Xbit__48__prll_regstr_ D_in[48] clk_cts_2 IN57 D_out[48] VSS VDD_1V8 dff_async_rst_817
Xbit__47__prll_regstr_ D_in[47] clk_cts_2 IN43 D_out[47] VSS VDD_1V8 dff_async_rst_818
Xbit__46__prll_regstr_ D_in[46] clk_cts_2 IN42 D_out[46] VSS VDD_1V8 dff_async_rst_819
Xbit__45__prll_regstr_ D_in[45] clk IN33 D_out[45] VSS VDD_1V8 dff_async_rst_820
Xbit__44__prll_regstr_ D_in[44] clk_cts_1 IN31 D_out[44] VSS VDD_1V8 dff_async_rst_821
Xbit__43__prll_regstr_ D_in[43] clk_cts_1 IN30 D_out[43] VSS VDD_1V8 dff_async_rst_822
Xbit__42__prll_regstr_ D_in[42] clk_cts_1 IN26 D_out[42] VSS VDD_1V8 dff_async_rst_823
Xbit__41__prll_regstr_ D_in[41] clk_cts_1 IN32 D_out[41] VSS VDD_1V8 dff_async_rst_824
Xbit__40__prll_regstr_ D_in[40] clk_cts_1 IN29 D_out[40] VSS VDD_1V8 dff_async_rst_825
Xbit__39__prll_regstr_ D_in[39] clk_cts_1 IN27 D_out[39] VSS VDD_1V8 dff_async_rst_826
Xbit__38__prll_regstr_ D_in[38] clk_cts_1 IN55 D_out[38] VSS VDD_1V8 dff_async_rst_827
Xbit__37__prll_regstr_ D_in[37] clk_cts_1 IN25 D_out[37] VSS VDD_1V8 dff_async_rst_828
Xbit__36__prll_regstr_ D_in[36] clk_cts_1 IN54 D_out[36] VSS VDD_1V8 dff_async_rst_829
Xbit__35__prll_regstr_ D_in[35] clk IN22 D_out[35] VSS VDD_1V8 dff_async_rst_830
Xbit__34__prll_regstr_ D_in[34] clk IN23 D_out[34] VSS VDD_1V8 dff_async_rst_831
Xbit__33__prll_regstr_ D_in[33] clk_cts_2 IN12 D_out[33] VSS VDD_1V8 dff_async_rst_832
Xbit__32__prll_regstr_ D_in[32] clk_cts_2 IN11 D_out[32] VSS VDD_1V8 dff_async_rst_833
Xbit__31__prll_regstr_ D_in[31] clk_cts_2 IN4 D_out[31] VSS VDD_1V8 dff_async_rst_834
Xbit__30__prll_regstr_ D_in[30] clk_cts_2 IN10 D_out[30] VSS VDD_1V8 dff_async_rst_835
Xbit__29__prll_regstr_ D_in[29] clk_cts_2 IN41 D_out[29] VSS VDD_1V8 dff_async_rst_836
Xbit__28__prll_regstr_ D_in[28] clk_cts_2 IN5 D_out[28] VSS VDD_1V8 dff_async_rst_837
Xbit__27__prll_regstr_ D_in[27] clk_cts_2 IN8 D_out[27] VSS VDD_1V8 dff_async_rst_838
Xbit__26__prll_regstr_ D_in[26] clk_cts_2 IN6 D_out[26] VSS VDD_1V8 dff_async_rst_839
Xbit__25__prll_regstr_ D_in[25] clk_cts_2 IN40 D_out[25] VSS VDD_1V8 dff_async_rst_840
Xbit__24__prll_regstr_ D_in[24] clk IN17 D_out[24] VSS VDD_1V8 dff_async_rst_841
Xbit__23__prll_regstr_ D_in[23] clk_cts_2 IN2 D_out[23] VSS VDD_1V8 dff_async_rst_842
Xbit__22__prll_regstr_ D_in[22] clk_cts_2 IN14 D_out[22] VSS VDD_1V8 dff_async_rst_843
Xbit__21__prll_regstr_ D_in[21] clk_cts_2 IN9 D_out[21] VSS VDD_1V8 dff_async_rst_844
Xbit__20__prll_regstr_ D_in[20] clk_cts_2 IN1 D_out[20] VSS VDD_1V8 dff_async_rst_845
Xbit__19__prll_regstr_ D_in[19] clk_cts_2 IN7 D_out[19] VSS VDD_1V8 dff_async_rst_846
Xbit__18__prll_regstr_ D_in[18] clk_cts_2 IN16 D_out[18] VSS VDD_1V8 dff_async_rst_847
Xbit__17__prll_regstr_ D_in[17] clk_cts_2 IN13 D_out[17] VSS VDD_1V8 dff_async_rst_848
Xbit__16__prll_regstr_ D_in[16] clk_cts_2 IN15 D_out[16] VSS VDD_1V8 dff_async_rst_849
Xbit__15__prll_regstr_ D_in[15] clk IN19 D_out[15] VSS VDD_1V8 dff_async_rst_850
Xbit__14__prll_regstr_ D_in[14] clk_cts_2 IN3 D_out[14] VSS VDD_1V8 dff_async_rst_851
Xbit__13__prll_regstr_ D_in[13] clk IN21 D_out[13] VSS VDD_1V8 dff_async_rst_852
Xbit__12__prll_regstr_ D_in[12] clk IN20 D_out[12] VSS VDD_1V8 dff_async_rst_853
Xbit__11__prll_regstr_ D_in[11] clk IN45 D_out[11] VSS VDD_1V8 dff_async_rst_854
Xbit__10__prll_regstr_ D_in[10] clk IN46 D_out[10] VSS VDD_1V8 dff_async_rst_855
Xbit__9__prll_regstr_ D_in[9] clk IN18 D_out[9] VSS VDD_1V8 dff_async_rst_856
Xbit__8__prll_regstr_ D_in[8] clk IN44 D_out[8] VSS VDD_1V8 dff_async_rst_857
Xbit__7__prll_regstr_ D_in[7] clk IN50 D_out[7] VSS VDD_1V8 dff_async_rst_858
Xbit__6__prll_regstr_ D_in[6] clk IN51 D_out[6] VSS VDD_1V8 dff_async_rst_859
Xbit__5__prll_regstr_ D_in[5] clk IN47 D_out[5] VSS VDD_1V8 dff_async_rst_860
Xbit__4__prll_regstr_ D_in[4] clk IN53 D_out[4] VSS VDD_1V8 dff_async_rst_861
Xbit__3__prll_regstr_ D_in[3] clk IN52 D_out[3] VSS VDD_1V8 dff_async_rst_862
Xbit__2__prll_regstr_ D_in[2] clk IN48 D_out[2] VSS VDD_1V8 dff_async_rst_863
Xbit__1__prll_regstr_ D_in[1] clk IN49 D_out[1] VSS VDD_1V8 dff_async_rst_864
Xbit__0__prll_regstr_ D_in[0] clk_cts_1 IN24 D_out[0] VSS VDD_1V8 dff_async_rst_865
.ENDS

.SUBCKT prll_d_reg_bits65_11 clk reset D_in[64] D_in[63] D_in[62] D_in[61] D_in[60]
+ D_in[59] D_in[58] D_in[57] D_in[56] D_in[55] D_in[54] D_in[53] D_in[52] D_in[51]
+ D_in[50] D_in[49] D_in[48] D_in[47] D_in[46] D_in[45] D_in[44] D_in[43] D_in[42]
+ D_in[41] D_in[40] D_in[39] D_in[38] D_in[37] D_in[36] D_in[35] D_in[34] D_in[33]
+ D_in[32] D_in[31] D_in[30] D_in[29] D_in[28] D_in[27] D_in[26] D_in[25] D_in[24]
+ D_in[23] D_in[22] D_in[21] D_in[20] D_in[19] D_in[18] D_in[17] D_in[16] D_in[15]
+ D_in[14] D_in[13] D_in[12] D_in[11] D_in[10] D_in[9] D_in[8] D_in[7] D_in[6] D_in[5]
+ D_in[4] D_in[3] D_in[2] D_in[1] D_in[0] D_out[64] D_out[63] D_out[62] D_out[61]
+ D_out[60] D_out[59] D_out[58] D_out[57] D_out[56] D_out[55] D_out[54] D_out[53]
+ D_out[52] D_out[51] D_out[50] D_out[49] D_out[48] D_out[47] D_out[46] D_out[45]
+ D_out[44] D_out[43] D_out[42] D_out[41] D_out[40] D_out[39] D_out[38] D_out[37]
+ D_out[36] D_out[35] D_out[34] D_out[33] D_out[32] D_out[31] D_out[30] D_out[29]
+ D_out[28] D_out[27] D_out[26] D_out[25] D_out[24] D_out[23] D_out[22] D_out[21]
+ D_out[20] D_out[19] D_out[18] D_out[17] D_out[16] D_out[15] D_out[14] D_out[13]
+ D_out[12] D_out[11] D_out[10] D_out[9] D_out[8] D_out[7] D_out[6] D_out[5] D_out[4]
+ D_out[3] D_out[2] D_out[1] D_out[0] VSS VDD_1V8 IN0 IN1 IN2 IN3 IN4 IN5 IN6 IN7
+ IN8 IN9 IN10 IN11 IN12 IN13 IN14 IN15 IN16 IN17 IN18 IN19 IN20 IN21 IN22 IN23
+ IN24 IN25 IN26 IN27 IN28 IN29 IN30 IN31 IN32 IN33 IN34 IN35 IN36 IN37 IN38 IN39
+ IN40 IN41 IN42 IN43 IN44 IN45 IN46 IN47 IN48 IN49 IN50 IN51 IN52 IN53 IN54 IN55
+ IN56 IN57 IN58 IN59 IN60 clk_cts_1 clk_cts_2
Xbit__61__prll_regstr_ D_in[61] clk_cts_1 IN23 D_out[61] VSS VDD_1V8 dff_async_rst_739
Xbit__60__prll_regstr_ D_in[60] clk_cts_1 IN27 D_out[60] VSS VDD_1V8 dff_async_rst_740
Xbit__59__prll_regstr_ D_in[59] clk_cts_2 IN36 D_out[59] VSS VDD_1V8 dff_async_rst_741
Xbit__58__prll_regstr_ D_in[58] clk IN34 D_out[58] VSS VDD_1V8 dff_async_rst_742
Xbit__57__prll_regstr_ D_in[57] clk_cts_2 IN38 D_out[57] VSS VDD_1V8 dff_async_rst_743
Xbit__56__prll_regstr_ D_in[56] clk_cts_2 IN37 D_out[56] VSS VDD_1V8 dff_async_rst_744
Xbit__55__prll_regstr_ D_in[55] clk_cts_2 IN33 D_out[55] VSS VDD_1V8 dff_async_rst_745
Xbit__54__prll_regstr_ D_in[54] clk_cts_2 IN59 D_out[54] VSS VDD_1V8 dff_async_rst_746
Xbit__53__prll_regstr_ D_in[53] clk_cts_2 IN57 D_out[53] VSS VDD_1V8 dff_async_rst_747
Xbit__52__prll_regstr_ D_in[52] clk_cts_2 IN56 D_out[52] VSS VDD_1V8 dff_async_rst_748
Xbit__51__prll_regstr_ D_in[51] clk_cts_2 reset D_out[51] VSS VDD_1V8 dff_async_rst_749
Xbit__50__prll_regstr_ D_in[50] clk_cts_2 IN35 D_out[50] VSS VDD_1V8 dff_async_rst_750
Xbit__49__prll_regstr_ D_in[49] clk_cts_2 IN60 D_out[49] VSS VDD_1V8 dff_async_rst_751
Xbit__48__prll_regstr_ D_in[48] clk_cts_2 IN58 D_out[48] VSS VDD_1V8 dff_async_rst_752
Xbit__47__prll_regstr_ D_in[47] clk_cts_2 IN42 D_out[47] VSS VDD_1V8 dff_async_rst_753
Xbit__46__prll_regstr_ D_in[46] clk_cts_2 IN41 D_out[46] VSS VDD_1V8 dff_async_rst_754
Xbit__45__prll_regstr_ D_in[45] clk IN32 D_out[45] VSS VDD_1V8 dff_async_rst_755
Xbit__44__prll_regstr_ D_in[44] clk_cts_1 IN30 D_out[44] VSS VDD_1V8 dff_async_rst_756
Xbit__43__prll_regstr_ D_in[43] clk_cts_1 IN28 D_out[43] VSS VDD_1V8 dff_async_rst_757
Xbit__42__prll_regstr_ D_in[42] clk_cts_1 IN24 D_out[42] VSS VDD_1V8 dff_async_rst_758
Xbit__41__prll_regstr_ D_in[41] clk_cts_1 IN31 D_out[41] VSS VDD_1V8 dff_async_rst_759
Xbit__40__prll_regstr_ D_in[40] clk_cts_1 IN29 D_out[40] VSS VDD_1V8 dff_async_rst_760
Xbit__39__prll_regstr_ D_in[39] clk_cts_1 IN26 D_out[39] VSS VDD_1V8 dff_async_rst_761
Xbit__38__prll_regstr_ D_in[38] clk_cts_1 IN55 D_out[38] VSS VDD_1V8 dff_async_rst_762
Xbit__37__prll_regstr_ D_in[37] clk_cts_1 IN25 D_out[37] VSS VDD_1V8 dff_async_rst_763
Xbit__36__prll_regstr_ D_in[36] clk_cts_1 IN54 D_out[36] VSS VDD_1V8 dff_async_rst_764
Xbit__35__prll_regstr_ D_in[35] clk IN21 D_out[35] VSS VDD_1V8 dff_async_rst_765
Xbit__34__prll_regstr_ D_in[34] clk IN20 D_out[34] VSS VDD_1V8 dff_async_rst_766
Xbit__33__prll_regstr_ D_in[33] clk_cts_2 IN10 D_out[33] VSS VDD_1V8 dff_async_rst_767
Xbit__32__prll_regstr_ D_in[32] clk_cts_2 IN11 D_out[32] VSS VDD_1V8 dff_async_rst_768
Xbit__31__prll_regstr_ D_in[31] clk_cts_2 IN0 D_out[31] VSS VDD_1V8 dff_async_rst_769
Xbit__30__prll_regstr_ D_in[30] clk_cts_2 IN9 D_out[30] VSS VDD_1V8 dff_async_rst_770
Xbit__29__prll_regstr_ D_in[29] clk_cts_2 IN40 D_out[29] VSS VDD_1V8 dff_async_rst_771
Xbit__28__prll_regstr_ D_in[28] clk_cts_2 IN1 D_out[28] VSS VDD_1V8 dff_async_rst_772
Xbit__27__prll_regstr_ D_in[27] clk_cts_2 IN6 D_out[27] VSS VDD_1V8 dff_async_rst_773
Xbit__26__prll_regstr_ D_in[26] clk_cts_2 IN5 D_out[26] VSS VDD_1V8 dff_async_rst_774
Xbit__25__prll_regstr_ D_in[25] clk_cts_2 IN39 D_out[25] VSS VDD_1V8 dff_async_rst_775
Xbit__24__prll_regstr_ D_in[24] clk IN43 D_out[24] VSS VDD_1V8 dff_async_rst_776
Xbit__23__prll_regstr_ D_in[23] clk_cts_2 IN8 D_out[23] VSS VDD_1V8 dff_async_rst_777
Xbit__22__prll_regstr_ D_in[22] clk_cts_2 IN15 D_out[22] VSS VDD_1V8 dff_async_rst_778
Xbit__21__prll_regstr_ D_in[21] clk_cts_2 IN7 D_out[21] VSS VDD_1V8 dff_async_rst_779
Xbit__20__prll_regstr_ D_in[20] clk_cts_2 IN3 D_out[20] VSS VDD_1V8 dff_async_rst_780
Xbit__19__prll_regstr_ D_in[19] clk_cts_2 IN2 D_out[19] VSS VDD_1V8 dff_async_rst_781
Xbit__18__prll_regstr_ D_in[18] clk_cts_2 IN14 D_out[18] VSS VDD_1V8 dff_async_rst_782
Xbit__17__prll_regstr_ D_in[17] clk_cts_2 IN12 D_out[17] VSS VDD_1V8 dff_async_rst_783
Xbit__16__prll_regstr_ D_in[16] clk_cts_2 IN13 D_out[16] VSS VDD_1V8 dff_async_rst_784
Xbit__15__prll_regstr_ D_in[15] clk IN17 D_out[15] VSS VDD_1V8 dff_async_rst_785
Xbit__14__prll_regstr_ D_in[14] clk_cts_2 IN4 D_out[14] VSS VDD_1V8 dff_async_rst_786
Xbit__13__prll_regstr_ D_in[13] clk IN19 D_out[13] VSS VDD_1V8 dff_async_rst_787
Xbit__12__prll_regstr_ D_in[12] clk IN16 D_out[12] VSS VDD_1V8 dff_async_rst_788
Xbit__11__prll_regstr_ D_in[11] clk IN45 D_out[11] VSS VDD_1V8 dff_async_rst_789
Xbit__10__prll_regstr_ D_in[10] clk IN46 D_out[10] VSS VDD_1V8 dff_async_rst_790
Xbit__9__prll_regstr_ D_in[9] clk IN18 D_out[9] VSS VDD_1V8 dff_async_rst_791
Xbit__8__prll_regstr_ D_in[8] clk IN44 D_out[8] VSS VDD_1V8 dff_async_rst_792
Xbit__7__prll_regstr_ D_in[7] clk IN50 D_out[7] VSS VDD_1V8 dff_async_rst_793
Xbit__6__prll_regstr_ D_in[6] clk IN51 D_out[6] VSS VDD_1V8 dff_async_rst_794
Xbit__5__prll_regstr_ D_in[5] clk IN47 D_out[5] VSS VDD_1V8 dff_async_rst_795
Xbit__4__prll_regstr_ D_in[4] clk IN52 D_out[4] VSS VDD_1V8 dff_async_rst_796
Xbit__3__prll_regstr_ D_in[3] clk IN53 D_out[3] VSS VDD_1V8 dff_async_rst_797
Xbit__2__prll_regstr_ D_in[2] clk IN48 D_out[2] VSS VDD_1V8 dff_async_rst_798
Xbit__1__prll_regstr_ D_in[1] clk IN49 D_out[1] VSS VDD_1V8 dff_async_rst_799
Xbit__0__prll_regstr_ D_in[0] clk_cts_1 IN22 D_out[0] VSS VDD_1V8 dff_async_rst_800
.ENDS

.SUBCKT prll_d_reg_bits65_10 clk reset D_in[64] D_in[63] D_in[62] D_in[61] D_in[60]
+ D_in[59] D_in[58] D_in[57] D_in[56] D_in[55] D_in[54] D_in[53] D_in[52] D_in[51]
+ D_in[50] D_in[49] D_in[48] D_in[47] D_in[46] D_in[45] D_in[44] D_in[43] D_in[42]
+ D_in[41] D_in[40] D_in[39] D_in[38] D_in[37] D_in[36] D_in[35] D_in[34] D_in[33]
+ D_in[32] D_in[31] D_in[30] D_in[29] D_in[28] D_in[27] D_in[26] D_in[25] D_in[24]
+ D_in[23] D_in[22] D_in[21] D_in[20] D_in[19] D_in[18] D_in[17] D_in[16] D_in[15]
+ D_in[14] D_in[13] D_in[12] D_in[11] D_in[10] D_in[9] D_in[8] D_in[7] D_in[6] D_in[5]
+ D_in[4] D_in[3] D_in[2] D_in[1] D_in[0] D_out[64] D_out[63] D_out[62] D_out[61]
+ D_out[60] D_out[59] D_out[58] D_out[57] D_out[56] D_out[55] D_out[54] D_out[53]
+ D_out[52] D_out[51] D_out[50] D_out[49] D_out[48] D_out[47] D_out[46] D_out[45]
+ D_out[44] D_out[43] D_out[42] D_out[41] D_out[40] D_out[39] D_out[38] D_out[37]
+ D_out[36] D_out[35] D_out[34] D_out[33] D_out[32] D_out[31] D_out[30] D_out[29]
+ D_out[28] D_out[27] D_out[26] D_out[25] D_out[24] D_out[23] D_out[22] D_out[21]
+ D_out[20] D_out[19] D_out[18] D_out[17] D_out[16] D_out[15] D_out[14] D_out[13]
+ D_out[12] D_out[11] D_out[10] D_out[9] D_out[8] D_out[7] D_out[6] D_out[5] D_out[4]
+ D_out[3] D_out[2] D_out[1] D_out[0] VSS VDD_1V8 IN0 IN1 IN2 IN3 IN4 IN5 IN6 IN7
+ IN8 IN9 IN10 IN11 IN12 IN13 IN14 IN15 IN16 IN17 IN18 IN19 IN20 IN21 IN22 IN23
+ IN24 IN25 IN26 IN27 IN28 IN29 IN30 IN31 IN32 IN33 IN34 IN35 IN36 IN37 IN38 IN39
+ IN40 IN41 IN42 IN43 IN44 IN45 IN46 IN47 IN48 IN49 IN50 IN51 IN52 IN53 IN54 clk_cts_1
+ clk_cts_2
Xbit__63__prll_regstr_ D_in[63] clk reset D_out[63] VSS VDD_1V8 dff_async_rst_672
Xbit__62__prll_regstr_ D_in[62] clk reset D_out[62] VSS VDD_1V8 dff_async_rst_673
Xbit__59__prll_regstr_ D_in[59] clk IN52 D_out[59] VSS VDD_1V8 dff_async_rst_676
Xbit__58__prll_regstr_ D_in[58] clk reset D_out[58] VSS VDD_1V8 dff_async_rst_677
Xbit__57__prll_regstr_ D_in[57] clk IN54 D_out[57] VSS VDD_1V8 dff_async_rst_678
Xbit__56__prll_regstr_ D_in[56] clk reset D_out[56] VSS VDD_1V8 dff_async_rst_679
Xbit__55__prll_regstr_ D_in[55] clk reset D_out[55] VSS VDD_1V8 dff_async_rst_680
Xbit__54__prll_regstr_ D_in[54] clk IN18 D_out[54] VSS VDD_1V8 dff_async_rst_681
Xbit__53__prll_regstr_ D_in[53] clk IN26 D_out[53] VSS VDD_1V8 dff_async_rst_682
Xbit__52__prll_regstr_ D_in[52] clk IN20 D_out[52] VSS VDD_1V8 dff_async_rst_683
Xbit__51__prll_regstr_ D_in[51] clk IN23 D_out[51] VSS VDD_1V8 dff_async_rst_684
Xbit__50__prll_regstr_ D_in[50] clk IN49 D_out[50] VSS VDD_1V8 dff_async_rst_685
Xbit__49__prll_regstr_ D_in[49] clk IN50 D_out[49] VSS VDD_1V8 dff_async_rst_686
Xbit__48__prll_regstr_ D_in[48] clk IN27 D_out[48] VSS VDD_1V8 dff_async_rst_687
Xbit__47__prll_regstr_ D_in[47] clk IN53 D_out[47] VSS VDD_1V8 dff_async_rst_688
Xbit__46__prll_regstr_ D_in[46] clk IN28 D_out[46] VSS VDD_1V8 dff_async_rst_689
Xbit__45__prll_regstr_ D_in[45] clk IN51 D_out[45] VSS VDD_1V8 dff_async_rst_690
Xbit__44__prll_regstr_ D_in[44] clk reset D_out[44] VSS VDD_1V8 dff_async_rst_691
Xbit__43__prll_regstr_ D_in[43] clk IN32 D_out[43] VSS VDD_1V8 dff_async_rst_692
Xbit__42__prll_regstr_ D_in[42] clk IN24 D_out[42] VSS VDD_1V8 dff_async_rst_693
Xbit__41__prll_regstr_ D_in[41] clk reset D_out[41] VSS VDD_1V8 dff_async_rst_694
Xbit__40__prll_regstr_ D_in[40] clk IN31 D_out[40] VSS VDD_1V8 dff_async_rst_695
Xbit__39__prll_regstr_ D_in[39] clk IN48 D_out[39] VSS VDD_1V8 dff_async_rst_696
Xbit__38__prll_regstr_ D_in[38] clk IN25 D_out[38] VSS VDD_1V8 dff_async_rst_697
Xbit__37__prll_regstr_ D_in[37] clk IN29 D_out[37] VSS VDD_1V8 dff_async_rst_698
Xbit__36__prll_regstr_ D_in[36] clk_cts_2 IN22 D_out[36] VSS VDD_1V8 dff_async_rst_699
Xbit__35__prll_regstr_ D_in[35] clk_cts_2 IN16 D_out[35] VSS VDD_1V8 dff_async_rst_700
Xbit__34__prll_regstr_ D_in[34] clk_cts_2 IN15 D_out[34] VSS VDD_1V8 dff_async_rst_701
Xbit__33__prll_regstr_ D_in[33] clk IN17 D_out[33] VSS VDD_1V8 dff_async_rst_702
Xbit__32__prll_regstr_ D_in[32] clk_cts_2 IN21 D_out[32] VSS VDD_1V8 dff_async_rst_703
Xbit__31__prll_regstr_ D_in[31] clk_cts_1 IN40 D_out[31] VSS VDD_1V8 dff_async_rst_704
Xbit__30__prll_regstr_ D_in[30] clk_cts_1 IN41 D_out[30] VSS VDD_1V8 dff_async_rst_705
Xbit__29__prll_regstr_ D_in[29] clk_cts_1 IN4 D_out[29] VSS VDD_1V8 dff_async_rst_706
Xbit__28__prll_regstr_ D_in[28] clk_cts_1 IN0 D_out[28] VSS VDD_1V8 dff_async_rst_707
Xbit__27__prll_regstr_ D_in[27] clk_cts_1 IN1 D_out[27] VSS VDD_1V8 dff_async_rst_708
Xbit__26__prll_regstr_ D_in[26] clk_cts_1 IN5 D_out[26] VSS VDD_1V8 dff_async_rst_709
Xbit__25__prll_regstr_ D_in[25] clk_cts_1 IN6 D_out[25] VSS VDD_1V8 dff_async_rst_710
Xbit__24__prll_regstr_ D_in[24] clk_cts_1 IN8 D_out[24] VSS VDD_1V8 dff_async_rst_711
Xbit__23__prll_regstr_ D_in[23] clk_cts_1 IN3 D_out[23] VSS VDD_1V8 dff_async_rst_712
Xbit__22__prll_regstr_ D_in[22] clk_cts_1 IN13 D_out[22] VSS VDD_1V8 dff_async_rst_713
Xbit__21__prll_regstr_ D_in[21] clk_cts_1 IN9 D_out[21] VSS VDD_1V8 dff_async_rst_714
Xbit__20__prll_regstr_ D_in[20] clk_cts_1 IN2 D_out[20] VSS VDD_1V8 dff_async_rst_715
Xbit__19__prll_regstr_ D_in[19] clk_cts_1 IN7 D_out[19] VSS VDD_1V8 dff_async_rst_716
Xbit__18__prll_regstr_ D_in[18] clk_cts_1 IN11 D_out[18] VSS VDD_1V8 dff_async_rst_717
Xbit__17__prll_regstr_ D_in[17] clk_cts_1 IN14 D_out[17] VSS VDD_1V8 dff_async_rst_718
Xbit__16__prll_regstr_ D_in[16] clk_cts_1 IN12 D_out[16] VSS VDD_1V8 dff_async_rst_719
Xbit__15__prll_regstr_ D_in[15] clk_cts_2 IN43 D_out[15] VSS VDD_1V8 dff_async_rst_720
Xbit__14__prll_regstr_ D_in[14] clk_cts_1 IN10 D_out[14] VSS VDD_1V8 dff_async_rst_721
Xbit__13__prll_regstr_ D_in[13] clk_cts_2 IN44 D_out[13] VSS VDD_1V8 dff_async_rst_722
Xbit__12__prll_regstr_ D_in[12] clk_cts_2 IN46 D_out[12] VSS VDD_1V8 dff_async_rst_723
Xbit__11__prll_regstr_ D_in[11] clk_cts_2 IN42 D_out[11] VSS VDD_1V8 dff_async_rst_724
Xbit__10__prll_regstr_ D_in[10] clk_cts_2 IN19 D_out[10] VSS VDD_1V8 dff_async_rst_725
Xbit__9__prll_regstr_ D_in[9] clk_cts_2 IN45 D_out[9] VSS VDD_1V8 dff_async_rst_726
Xbit__8__prll_regstr_ D_in[8] clk_cts_2 IN47 D_out[8] VSS VDD_1V8 dff_async_rst_727
Xbit__7__prll_regstr_ D_in[7] clk_cts_2 IN35 D_out[7] VSS VDD_1V8 dff_async_rst_728
Xbit__6__prll_regstr_ D_in[6] clk_cts_2 IN33 D_out[6] VSS VDD_1V8 dff_async_rst_729
Xbit__5__prll_regstr_ D_in[5] clk_cts_2 IN39 D_out[5] VSS VDD_1V8 dff_async_rst_730
Xbit__4__prll_regstr_ D_in[4] clk_cts_2 IN38 D_out[4] VSS VDD_1V8 dff_async_rst_731
Xbit__3__prll_regstr_ D_in[3] clk_cts_2 IN37 D_out[3] VSS VDD_1V8 dff_async_rst_732
Xbit__2__prll_regstr_ D_in[2] clk_cts_2 IN34 D_out[2] VSS VDD_1V8 dff_async_rst_733
Xbit__1__prll_regstr_ D_in[1] clk_cts_2 IN30 D_out[1] VSS VDD_1V8 dff_async_rst_734
Xbit__0__prll_regstr_ D_in[0] clk IN36 D_out[0] VSS VDD_1V8 dff_async_rst_735
.ENDS

.SUBCKT prll_d_reg_bits65_9 clk reset D_in[64] D_in[63] D_in[62] D_in[61] D_in[60]
+ D_in[59] D_in[58] D_in[57] D_in[56] D_in[55] D_in[54] D_in[53] D_in[52] D_in[51]
+ D_in[50] D_in[49] D_in[48] D_in[47] D_in[46] D_in[45] D_in[44] D_in[43] D_in[42]
+ D_in[41] D_in[40] D_in[39] D_in[38] D_in[37] D_in[36] D_in[35] D_in[34] D_in[33]
+ D_in[32] D_in[31] D_in[30] D_in[29] D_in[28] D_in[27] D_in[26] D_in[25] D_in[24]
+ D_in[23] D_in[22] D_in[21] D_in[20] D_in[19] D_in[18] D_in[17] D_in[16] D_in[15]
+ D_in[14] D_in[13] D_in[12] D_in[11] D_in[10] D_in[9] D_in[8] D_in[7] D_in[6] D_in[5]
+ D_in[4] D_in[3] D_in[2] D_in[1] D_in[0] D_out[64] D_out[63] D_out[62] D_out[61]
+ D_out[60] D_out[59] D_out[58] D_out[57] D_out[56] D_out[55] D_out[54] D_out[53]
+ D_out[52] D_out[51] D_out[50] D_out[49] D_out[48] D_out[47] D_out[46] D_out[45]
+ D_out[44] D_out[43] D_out[42] D_out[41] D_out[40] D_out[39] D_out[38] D_out[37]
+ D_out[36] D_out[35] D_out[34] D_out[33] D_out[32] D_out[31] D_out[30] D_out[29]
+ D_out[28] D_out[27] D_out[26] D_out[25] D_out[24] D_out[23] D_out[22] D_out[21]
+ D_out[20] D_out[19] D_out[18] D_out[17] D_out[16] D_out[15] D_out[14] D_out[13]
+ D_out[12] D_out[11] D_out[10] D_out[9] D_out[8] D_out[7] D_out[6] D_out[5] D_out[4]
+ D_out[3] D_out[2] D_out[1] D_out[0] VSS VDD_1V8 IN0 IN1 IN2 IN3 IN4 IN5 IN6 IN7
+ IN8 IN9 IN10 IN11 IN12 IN13 IN14 IN15 IN16 IN17 IN18 IN19 IN20 IN21 IN22 IN23
+ IN24 IN25 IN26 IN27 IN28 IN29 IN30 IN31 IN32 IN33 IN34 IN35 IN36 IN37 IN38 IN39
+ IN40 IN41 IN42 IN43 IN44 IN45 IN46 IN47 IN48 clk_cts_1 clk_cts_2
Xbit__63__prll_regstr_ D_in[63] clk reset D_out[63] VSS VDD_1V8 dff_async_rst_607
Xbit__62__prll_regstr_ D_in[62] clk reset D_out[62] VSS VDD_1V8 dff_async_rst_608
Xbit__59__prll_regstr_ D_in[59] clk IN8 D_out[59] VSS VDD_1V8 dff_async_rst_611
Xbit__58__prll_regstr_ D_in[58] clk reset D_out[58] VSS VDD_1V8 dff_async_rst_612
Xbit__57__prll_regstr_ D_in[57] clk reset D_out[57] VSS VDD_1V8 dff_async_rst_613
Xbit__56__prll_regstr_ D_in[56] clk reset D_out[56] VSS VDD_1V8 dff_async_rst_614
Xbit__55__prll_regstr_ D_in[55] clk reset D_out[55] VSS VDD_1V8 dff_async_rst_615
Xbit__54__prll_regstr_ D_in[54] clk IN9 D_out[54] VSS VDD_1V8 dff_async_rst_616
Xbit__53__prll_regstr_ D_in[53] clk reset D_out[53] VSS VDD_1V8 dff_async_rst_617
Xbit__52__prll_regstr_ D_in[52] clk IN14 D_out[52] VSS VDD_1V8 dff_async_rst_618
Xbit__51__prll_regstr_ D_in[51] clk reset D_out[51] VSS VDD_1V8 dff_async_rst_619
Xbit__50__prll_regstr_ D_in[50] clk IN13 D_out[50] VSS VDD_1V8 dff_async_rst_620
Xbit__49__prll_regstr_ D_in[49] clk reset D_out[49] VSS VDD_1V8 dff_async_rst_621
Xbit__48__prll_regstr_ D_in[48] clk IN15 D_out[48] VSS VDD_1V8 dff_async_rst_622
Xbit__47__prll_regstr_ D_in[47] clk reset D_out[47] VSS VDD_1V8 dff_async_rst_623
Xbit__46__prll_regstr_ D_in[46] clk IN10 D_out[46] VSS VDD_1V8 dff_async_rst_624
Xbit__45__prll_regstr_ D_in[45] clk reset D_out[45] VSS VDD_1V8 dff_async_rst_625
Xbit__44__prll_regstr_ D_in[44] clk reset D_out[44] VSS VDD_1V8 dff_async_rst_626
Xbit__43__prll_regstr_ D_in[43] clk IN19 D_out[43] VSS VDD_1V8 dff_async_rst_627
Xbit__42__prll_regstr_ D_in[42] clk IN18 D_out[42] VSS VDD_1V8 dff_async_rst_628
Xbit__41__prll_regstr_ D_in[41] clk reset D_out[41] VSS VDD_1V8 dff_async_rst_629
Xbit__40__prll_regstr_ D_in[40] clk IN17 D_out[40] VSS VDD_1V8 dff_async_rst_630
Xbit__39__prll_regstr_ D_in[39] clk_cts_2 IN21 D_out[39] VSS VDD_1V8 dff_async_rst_631
Xbit__38__prll_regstr_ D_in[38] clk IN11 D_out[38] VSS VDD_1V8 dff_async_rst_632
Xbit__37__prll_regstr_ D_in[37] clk IN48 D_out[37] VSS VDD_1V8 dff_async_rst_633
Xbit__36__prll_regstr_ D_in[36] clk_cts_2 IN44 D_out[36] VSS VDD_1V8 dff_async_rst_634
Xbit__35__prll_regstr_ D_in[35] clk_cts_2 IN41 D_out[35] VSS VDD_1V8 dff_async_rst_635
Xbit__34__prll_regstr_ D_in[34] clk_cts_2 IN39 D_out[34] VSS VDD_1V8 dff_async_rst_636
Xbit__33__prll_regstr_ D_in[33] clk_cts_2 IN43 D_out[33] VSS VDD_1V8 dff_async_rst_637
Xbit__32__prll_regstr_ D_in[32] clk_cts_2 IN45 D_out[32] VSS VDD_1V8 dff_async_rst_638
Xbit__31__prll_regstr_ D_in[31] clk_cts_2 IN38 D_out[31] VSS VDD_1V8 dff_async_rst_639
Xbit__30__prll_regstr_ D_in[30] clk_cts_1 IN40 D_out[30] VSS VDD_1V8 dff_async_rst_640
Xbit__29__prll_regstr_ D_in[29] clk_cts_1 IN4 D_out[29] VSS VDD_1V8 dff_async_rst_641
Xbit__28__prll_regstr_ D_in[28] clk_cts_1 IN1 D_out[28] VSS VDD_1V8 dff_async_rst_642
Xbit__27__prll_regstr_ D_in[27] clk_cts_1 IN5 D_out[27] VSS VDD_1V8 dff_async_rst_643
Xbit__26__prll_regstr_ D_in[26] clk_cts_1 IN35 D_out[26] VSS VDD_1V8 dff_async_rst_644
Xbit__25__prll_regstr_ D_in[25] clk_cts_2 IN37 D_out[25] VSS VDD_1V8 dff_async_rst_645
Xbit__24__prll_regstr_ D_in[24] clk_cts_2 IN42 D_out[24] VSS VDD_1V8 dff_async_rst_646
Xbit__23__prll_regstr_ D_in[23] clk_cts_1 IN3 D_out[23] VSS VDD_1V8 dff_async_rst_647
Xbit__22__prll_regstr_ D_in[22] clk_cts_1 IN7 D_out[22] VSS VDD_1V8 dff_async_rst_648
Xbit__21__prll_regstr_ D_in[21] clk_cts_1 IN36 D_out[21] VSS VDD_1V8 dff_async_rst_649
Xbit__20__prll_regstr_ D_in[20] clk_cts_1 IN33 D_out[20] VSS VDD_1V8 dff_async_rst_650
Xbit__19__prll_regstr_ D_in[19] clk_cts_1 IN0 D_out[19] VSS VDD_1V8 dff_async_rst_651
Xbit__18__prll_regstr_ D_in[18] clk_cts_1 IN2 D_out[18] VSS VDD_1V8 dff_async_rst_652
Xbit__17__prll_regstr_ D_in[17] clk_cts_1 IN34 D_out[17] VSS VDD_1V8 dff_async_rst_653
Xbit__16__prll_regstr_ D_in[16] clk_cts_1 IN6 D_out[16] VSS VDD_1V8 dff_async_rst_654
Xbit__15__prll_regstr_ D_in[15] clk_cts_2 IN12 D_out[15] VSS VDD_1V8 dff_async_rst_655
Xbit__14__prll_regstr_ D_in[14] clk_cts_2 IN32 D_out[14] VSS VDD_1V8 dff_async_rst_656
Xbit__13__prll_regstr_ D_in[13] clk_cts_2 IN20 D_out[13] VSS VDD_1V8 dff_async_rst_657
Xbit__12__prll_regstr_ D_in[12] clk_cts_2 IN47 D_out[12] VSS VDD_1V8 dff_async_rst_658
Xbit__11__prll_regstr_ D_in[11] clk_cts_2 IN24 D_out[11] VSS VDD_1V8 dff_async_rst_659
Xbit__10__prll_regstr_ D_in[10] clk_cts_2 IN16 D_out[10] VSS VDD_1V8 dff_async_rst_660
Xbit__9__prll_regstr_ D_in[9] clk_cts_2 IN46 D_out[9] VSS VDD_1V8 dff_async_rst_661
Xbit__8__prll_regstr_ D_in[8] clk_cts_2 IN22 D_out[8] VSS VDD_1V8 dff_async_rst_662
Xbit__7__prll_regstr_ D_in[7] clk_cts_2 IN27 D_out[7] VSS VDD_1V8 dff_async_rst_663
Xbit__6__prll_regstr_ D_in[6] clk_cts_2 IN23 D_out[6] VSS VDD_1V8 dff_async_rst_664
Xbit__5__prll_regstr_ D_in[5] clk_cts_2 IN28 D_out[5] VSS VDD_1V8 dff_async_rst_665
Xbit__4__prll_regstr_ D_in[4] clk_cts_2 IN29 D_out[4] VSS VDD_1V8 dff_async_rst_666
Xbit__3__prll_regstr_ D_in[3] clk_cts_2 IN30 D_out[3] VSS VDD_1V8 dff_async_rst_667
Xbit__2__prll_regstr_ D_in[2] clk_cts_2 IN25 D_out[2] VSS VDD_1V8 dff_async_rst_668
Xbit__1__prll_regstr_ D_in[1] clk_cts_2 IN26 D_out[1] VSS VDD_1V8 dff_async_rst_669
Xbit__0__prll_regstr_ D_in[0] clk_cts_2 IN31 D_out[0] VSS VDD_1V8 dff_async_rst_670
.ENDS

.SUBCKT prll_d_reg_bits65_8 clk reset D_in[64] D_in[63] D_in[62] D_in[61] D_in[60]
+ D_in[59] D_in[58] D_in[57] D_in[56] D_in[55] D_in[54] D_in[53] D_in[52] D_in[51]
+ D_in[50] D_in[49] D_in[48] D_in[47] D_in[46] D_in[45] D_in[44] D_in[43] D_in[42]
+ D_in[41] D_in[40] D_in[39] D_in[38] D_in[37] D_in[36] D_in[35] D_in[34] D_in[33]
+ D_in[32] D_in[31] D_in[30] D_in[29] D_in[28] D_in[27] D_in[26] D_in[25] D_in[24]
+ D_in[23] D_in[22] D_in[21] D_in[20] D_in[19] D_in[18] D_in[17] D_in[16] D_in[15]
+ D_in[14] D_in[13] D_in[12] D_in[11] D_in[10] D_in[9] D_in[8] D_in[7] D_in[6] D_in[5]
+ D_in[4] D_in[3] D_in[2] D_in[1] D_in[0] D_out[64] D_out[63] D_out[62] D_out[61]
+ D_out[60] D_out[59] D_out[58] D_out[57] D_out[56] D_out[55] D_out[54] D_out[53]
+ D_out[52] D_out[51] D_out[50] D_out[49] D_out[48] D_out[47] D_out[46] D_out[45]
+ D_out[44] D_out[43] D_out[42] D_out[41] D_out[40] D_out[39] D_out[38] D_out[37]
+ D_out[36] D_out[35] D_out[34] D_out[33] D_out[32] D_out[31] D_out[30] D_out[29]
+ D_out[28] D_out[27] D_out[26] D_out[25] D_out[24] D_out[23] D_out[22] D_out[21]
+ D_out[20] D_out[19] D_out[18] D_out[17] D_out[16] D_out[15] D_out[14] D_out[13]
+ D_out[12] D_out[11] D_out[10] D_out[9] D_out[8] D_out[7] D_out[6] D_out[5] D_out[4]
+ D_out[3] D_out[2] D_out[1] D_out[0] VSS VDD_1V8 IN0 IN1 IN2 IN3 IN4 IN5 IN6 IN7
+ IN8 IN9 IN10 IN11 IN12 IN13 IN14 IN15 IN16 IN17 IN18 IN19 IN20 IN21 IN22 IN23
+ IN24 IN25 IN26 IN27 IN28 IN29 IN30 IN31 IN32 IN33 IN34 IN35 IN36 IN37 IN38 IN39
+ IN40 IN41 IN42 IN43 IN44 IN45 IN46 IN47 IN48 clk_cts_1 clk_cts_2
Xbit__63__prll_regstr_ D_in[63] clk reset D_out[63] VSS VDD_1V8 dff_async_rst_542
Xbit__62__prll_regstr_ D_in[62] clk reset D_out[62] VSS VDD_1V8 dff_async_rst_543
Xbit__59__prll_regstr_ D_in[59] clk IN10 D_out[59] VSS VDD_1V8 dff_async_rst_546
Xbit__58__prll_regstr_ D_in[58] clk reset D_out[58] VSS VDD_1V8 dff_async_rst_547
Xbit__57__prll_regstr_ D_in[57] clk reset D_out[57] VSS VDD_1V8 dff_async_rst_548
Xbit__56__prll_regstr_ D_in[56] clk reset D_out[56] VSS VDD_1V8 dff_async_rst_549
Xbit__55__prll_regstr_ D_in[55] clk reset D_out[55] VSS VDD_1V8 dff_async_rst_550
Xbit__54__prll_regstr_ D_in[54] clk IN12 D_out[54] VSS VDD_1V8 dff_async_rst_551
Xbit__53__prll_regstr_ D_in[53] clk reset D_out[53] VSS VDD_1V8 dff_async_rst_552
Xbit__52__prll_regstr_ D_in[52] clk IN16 D_out[52] VSS VDD_1V8 dff_async_rst_553
Xbit__51__prll_regstr_ D_in[51] clk reset D_out[51] VSS VDD_1V8 dff_async_rst_554
Xbit__50__prll_regstr_ D_in[50] clk IN11 D_out[50] VSS VDD_1V8 dff_async_rst_555
Xbit__49__prll_regstr_ D_in[49] clk reset D_out[49] VSS VDD_1V8 dff_async_rst_556
Xbit__48__prll_regstr_ D_in[48] clk IN17 D_out[48] VSS VDD_1V8 dff_async_rst_557
Xbit__47__prll_regstr_ D_in[47] clk reset D_out[47] VSS VDD_1V8 dff_async_rst_558
Xbit__46__prll_regstr_ D_in[46] clk_cts_2 IN15 D_out[46] VSS VDD_1V8 dff_async_rst_559
Xbit__45__prll_regstr_ D_in[45] clk reset D_out[45] VSS VDD_1V8 dff_async_rst_560
Xbit__44__prll_regstr_ D_in[44] clk reset D_out[44] VSS VDD_1V8 dff_async_rst_561
Xbit__43__prll_regstr_ D_in[43] clk IN20 D_out[43] VSS VDD_1V8 dff_async_rst_562
Xbit__42__prll_regstr_ D_in[42] clk IN25 D_out[42] VSS VDD_1V8 dff_async_rst_563
Xbit__41__prll_regstr_ D_in[41] clk reset D_out[41] VSS VDD_1V8 dff_async_rst_564
Xbit__40__prll_regstr_ D_in[40] clk IN19 D_out[40] VSS VDD_1V8 dff_async_rst_565
Xbit__39__prll_regstr_ D_in[39] clk_cts_2 IN22 D_out[39] VSS VDD_1V8 dff_async_rst_566
Xbit__38__prll_regstr_ D_in[38] clk IN13 D_out[38] VSS VDD_1V8 dff_async_rst_567
Xbit__37__prll_regstr_ D_in[37] clk_cts_2 IN47 D_out[37] VSS VDD_1V8 dff_async_rst_568
Xbit__36__prll_regstr_ D_in[36] clk_cts_2 IN43 D_out[36] VSS VDD_1V8 dff_async_rst_569
Xbit__35__prll_regstr_ D_in[35] clk_cts_1 IN40 D_out[35] VSS VDD_1V8 dff_async_rst_570
Xbit__34__prll_regstr_ D_in[34] clk_cts_2 IN38 D_out[34] VSS VDD_1V8 dff_async_rst_571
Xbit__33__prll_regstr_ D_in[33] clk_cts_2 IN41 D_out[33] VSS VDD_1V8 dff_async_rst_572
Xbit__32__prll_regstr_ D_in[32] clk_cts_2 IN44 D_out[32] VSS VDD_1V8 dff_async_rst_573
Xbit__31__prll_regstr_ D_in[31] clk_cts_2 IN37 D_out[31] VSS VDD_1V8 dff_async_rst_574
Xbit__30__prll_regstr_ D_in[30] clk_cts_1 IN39 D_out[30] VSS VDD_1V8 dff_async_rst_575
Xbit__29__prll_regstr_ D_in[29] clk_cts_1 IN3 D_out[29] VSS VDD_1V8 dff_async_rst_576
Xbit__28__prll_regstr_ D_in[28] clk_cts_1 IN2 D_out[28] VSS VDD_1V8 dff_async_rst_577
Xbit__27__prll_regstr_ D_in[27] clk_cts_1 IN6 D_out[27] VSS VDD_1V8 dff_async_rst_578
Xbit__26__prll_regstr_ D_in[26] clk_cts_1 IN0 D_out[26] VSS VDD_1V8 dff_async_rst_579
Xbit__25__prll_regstr_ D_in[25] clk_cts_2 IN36 D_out[25] VSS VDD_1V8 dff_async_rst_580
Xbit__24__prll_regstr_ D_in[24] clk_cts_2 IN42 D_out[24] VSS VDD_1V8 dff_async_rst_581
Xbit__23__prll_regstr_ D_in[23] clk_cts_1 IN5 D_out[23] VSS VDD_1V8 dff_async_rst_582
Xbit__22__prll_regstr_ D_in[22] clk_cts_1 IN9 D_out[22] VSS VDD_1V8 dff_async_rst_583
Xbit__21__prll_regstr_ D_in[21] clk_cts_1 IN35 D_out[21] VSS VDD_1V8 dff_async_rst_584
Xbit__20__prll_regstr_ D_in[20] clk_cts_1 IN8 D_out[20] VSS VDD_1V8 dff_async_rst_585
Xbit__19__prll_regstr_ D_in[19] clk_cts_1 IN1 D_out[19] VSS VDD_1V8 dff_async_rst_586
Xbit__18__prll_regstr_ D_in[18] clk_cts_1 IN4 D_out[18] VSS VDD_1V8 dff_async_rst_587
Xbit__17__prll_regstr_ D_in[17] clk_cts_1 IN34 D_out[17] VSS VDD_1V8 dff_async_rst_588
Xbit__16__prll_regstr_ D_in[16] clk_cts_1 IN7 D_out[16] VSS VDD_1V8 dff_async_rst_589
Xbit__15__prll_regstr_ D_in[15] clk_cts_2 IN14 D_out[15] VSS VDD_1V8 dff_async_rst_590
Xbit__14__prll_regstr_ D_in[14] clk_cts_1 IN33 D_out[14] VSS VDD_1V8 dff_async_rst_591
Xbit__13__prll_regstr_ D_in[13] clk_cts_2 IN48 D_out[13] VSS VDD_1V8 dff_async_rst_592
Xbit__12__prll_regstr_ D_in[12] clk_cts_2 IN46 D_out[12] VSS VDD_1V8 dff_async_rst_593
Xbit__11__prll_regstr_ D_in[11] clk_cts_2 IN24 D_out[11] VSS VDD_1V8 dff_async_rst_594
Xbit__10__prll_regstr_ D_in[10] clk_cts_2 IN18 D_out[10] VSS VDD_1V8 dff_async_rst_595
Xbit__9__prll_regstr_ D_in[9] clk_cts_2 IN45 D_out[9] VSS VDD_1V8 dff_async_rst_596
Xbit__8__prll_regstr_ D_in[8] clk_cts_2 IN21 D_out[8] VSS VDD_1V8 dff_async_rst_597
Xbit__7__prll_regstr_ D_in[7] clk_cts_2 IN28 D_out[7] VSS VDD_1V8 dff_async_rst_598
Xbit__6__prll_regstr_ D_in[6] clk_cts_2 IN23 D_out[6] VSS VDD_1V8 dff_async_rst_599
Xbit__5__prll_regstr_ D_in[5] clk_cts_2 IN29 D_out[5] VSS VDD_1V8 dff_async_rst_600
Xbit__4__prll_regstr_ D_in[4] clk_cts_2 IN32 D_out[4] VSS VDD_1V8 dff_async_rst_601
Xbit__3__prll_regstr_ D_in[3] clk_cts_2 IN31 D_out[3] VSS VDD_1V8 dff_async_rst_602
Xbit__2__prll_regstr_ D_in[2] clk_cts_2 IN26 D_out[2] VSS VDD_1V8 dff_async_rst_603
Xbit__1__prll_regstr_ D_in[1] clk_cts_2 IN27 D_out[1] VSS VDD_1V8 dff_async_rst_604
Xbit__0__prll_regstr_ D_in[0] clk_cts_2 IN30 D_out[0] VSS VDD_1V8 dff_async_rst_605
.ENDS

.SUBCKT prll_d_reg_bits65_7 clk reset D_in[64] D_in[63] D_in[62] D_in[61] D_in[60]
+ D_in[59] D_in[58] D_in[57] D_in[56] D_in[55] D_in[54] D_in[53] D_in[52] D_in[51]
+ D_in[50] D_in[49] D_in[48] D_in[47] D_in[46] D_in[45] D_in[44] D_in[43] D_in[42]
+ D_in[41] D_in[40] D_in[39] D_in[38] D_in[37] D_in[36] D_in[35] D_in[34] D_in[33]
+ D_in[32] D_in[31] D_in[30] D_in[29] D_in[28] D_in[27] D_in[26] D_in[25] D_in[24]
+ D_in[23] D_in[22] D_in[21] D_in[20] D_in[19] D_in[18] D_in[17] D_in[16] D_in[15]
+ D_in[14] D_in[13] D_in[12] D_in[11] D_in[10] D_in[9] D_in[8] D_in[7] D_in[6] D_in[5]
+ D_in[4] D_in[3] D_in[2] D_in[1] D_in[0] D_out[64] D_out[63] D_out[62] D_out[61]
+ D_out[60] D_out[59] D_out[58] D_out[57] D_out[56] D_out[55] D_out[54] D_out[53]
+ D_out[52] D_out[51] D_out[50] D_out[49] D_out[48] D_out[47] D_out[46] D_out[45]
+ D_out[44] D_out[43] D_out[42] D_out[41] D_out[40] D_out[39] D_out[38] D_out[37]
+ D_out[36] D_out[35] D_out[34] D_out[33] D_out[32] D_out[31] D_out[30] D_out[29]
+ D_out[28] D_out[27] D_out[26] D_out[25] D_out[24] D_out[23] D_out[22] D_out[21]
+ D_out[20] D_out[19] D_out[18] D_out[17] D_out[16] D_out[15] D_out[14] D_out[13]
+ D_out[12] D_out[11] D_out[10] D_out[9] D_out[8] D_out[7] D_out[6] D_out[5] D_out[4]
+ D_out[3] D_out[2] D_out[1] D_out[0] VSS VDD_1V8 IN0 IN1 IN2 IN3 IN4 IN5 IN6 IN7
+ IN8 IN9 IN10 IN11 IN12 IN13 IN14 IN15 IN16 IN17 IN18 IN19 IN20 IN21 IN22 IN23
+ IN24 IN25 IN26 IN27 IN28 IN29 IN30 IN31 IN32 IN33 clk_cts_1
Xbit__64__prll_regstr_ D_in[64] clk IN20 D_out[64] VSS VDD_1V8 dff_async_rst_476
Xbit__63__prll_regstr_ D_in[63] clk IN11 D_out[63] VSS VDD_1V8 dff_async_rst_477
Xbit__62__prll_regstr_ D_in[62] clk IN14 D_out[62] VSS VDD_1V8 dff_async_rst_478
Xbit__59__prll_regstr_ D_in[59] clk_cts_1 IN33 D_out[59] VSS VDD_1V8 dff_async_rst_481
Xbit__58__prll_regstr_ D_in[58] clk_cts_1 IN30 D_out[58] VSS VDD_1V8 dff_async_rst_482
Xbit__57__prll_regstr_ D_in[57] clk_cts_1 IN32 D_out[57] VSS VDD_1V8 dff_async_rst_483
Xbit__54__prll_regstr_ D_in[54] clk IN10 D_out[54] VSS VDD_1V8 dff_async_rst_486
Xbit__53__prll_regstr_ D_in[53] clk_cts_1 IN23 D_out[53] VSS VDD_1V8 dff_async_rst_487
Xbit__52__prll_regstr_ D_in[52] clk IN13 D_out[52] VSS VDD_1V8 dff_async_rst_488
Xbit__51__prll_regstr_ D_in[51] clk_cts_1 IN9 D_out[51] VSS VDD_1V8 dff_async_rst_489
Xbit__50__prll_regstr_ D_in[50] clk_cts_1 IN17 D_out[50] VSS VDD_1V8 dff_async_rst_490
Xbit__49__prll_regstr_ D_in[49] clk_cts_1 IN15 D_out[49] VSS VDD_1V8 dff_async_rst_491
Xbit__48__prll_regstr_ D_in[48] clk_cts_1 IN19 D_out[48] VSS VDD_1V8 dff_async_rst_492
Xbit__47__prll_regstr_ D_in[47] clk_cts_1 IN18 D_out[47] VSS VDD_1V8 dff_async_rst_493
Xbit__46__prll_regstr_ D_in[46] clk IN6 D_out[46] VSS VDD_1V8 dff_async_rst_494
Xbit__45__prll_regstr_ D_in[45] clk_cts_1 IN24 D_out[45] VSS VDD_1V8 dff_async_rst_495
Xbit__44__prll_regstr_ D_in[44] clk_cts_1 IN25 D_out[44] VSS VDD_1V8 dff_async_rst_496
Xbit__43__prll_regstr_ D_in[43] clk_cts_1 IN26 D_out[43] VSS VDD_1V8 dff_async_rst_497
Xbit__42__prll_regstr_ D_in[42] clk_cts_1 IN28 D_out[42] VSS VDD_1V8 dff_async_rst_498
Xbit__41__prll_regstr_ D_in[41] clk_cts_1 IN7 D_out[41] VSS VDD_1V8 dff_async_rst_499
Xbit__40__prll_regstr_ D_in[40] clk_cts_1 IN21 D_out[40] VSS VDD_1V8 dff_async_rst_500
Xbit__39__prll_regstr_ D_in[39] clk_cts_1 IN31 D_out[39] VSS VDD_1V8 dff_async_rst_501
Xbit__38__prll_regstr_ D_in[38] clk_cts_1 IN29 D_out[38] VSS VDD_1V8 dff_async_rst_502
Xbit__37__prll_regstr_ D_in[37] clk_cts_1 IN27 D_out[37] VSS VDD_1V8 dff_async_rst_503
Xbit__36__prll_regstr_ D_in[36] clk reset D_out[36] VSS VDD_1V8 dff_async_rst_504
Xbit__35__prll_regstr_ D_in[35] clk reset D_out[35] VSS VDD_1V8 dff_async_rst_505
Xbit__34__prll_regstr_ D_in[34] clk_cts_1 IN8 D_out[34] VSS VDD_1V8 dff_async_rst_506
Xbit__33__prll_regstr_ D_in[33] clk reset D_out[33] VSS VDD_1V8 dff_async_rst_507
Xbit__32__prll_regstr_ D_in[32] clk reset D_out[32] VSS VDD_1V8 dff_async_rst_508
Xbit__31__prll_regstr_ D_in[31] clk reset D_out[31] VSS VDD_1V8 dff_async_rst_509
Xbit__30__prll_regstr_ D_in[30] clk reset D_out[30] VSS VDD_1V8 dff_async_rst_510
Xbit__29__prll_regstr_ D_in[29] clk reset D_out[29] VSS VDD_1V8 dff_async_rst_511
Xbit__28__prll_regstr_ D_in[28] clk reset D_out[28] VSS VDD_1V8 dff_async_rst_512
Xbit__27__prll_regstr_ D_in[27] clk reset D_out[27] VSS VDD_1V8 dff_async_rst_513
Xbit__26__prll_regstr_ D_in[26] clk reset D_out[26] VSS VDD_1V8 dff_async_rst_514
Xbit__25__prll_regstr_ D_in[25] clk reset D_out[25] VSS VDD_1V8 dff_async_rst_515
Xbit__24__prll_regstr_ D_in[24] clk reset D_out[24] VSS VDD_1V8 dff_async_rst_516
Xbit__23__prll_regstr_ D_in[23] clk reset D_out[23] VSS VDD_1V8 dff_async_rst_517
Xbit__22__prll_regstr_ D_in[22] clk reset D_out[22] VSS VDD_1V8 dff_async_rst_518
Xbit__21__prll_regstr_ D_in[21] clk reset D_out[21] VSS VDD_1V8 dff_async_rst_519
Xbit__20__prll_regstr_ D_in[20] clk reset D_out[20] VSS VDD_1V8 dff_async_rst_520
Xbit__19__prll_regstr_ D_in[19] clk reset D_out[19] VSS VDD_1V8 dff_async_rst_521
Xbit__18__prll_regstr_ D_in[18] clk reset D_out[18] VSS VDD_1V8 dff_async_rst_522
Xbit__17__prll_regstr_ D_in[17] clk reset D_out[17] VSS VDD_1V8 dff_async_rst_523
Xbit__16__prll_regstr_ D_in[16] clk reset D_out[16] VSS VDD_1V8 dff_async_rst_524
Xbit__15__prll_regstr_ D_in[15] clk reset D_out[15] VSS VDD_1V8 dff_async_rst_525
Xbit__14__prll_regstr_ D_in[14] clk reset D_out[14] VSS VDD_1V8 dff_async_rst_526
Xbit__13__prll_regstr_ D_in[13] clk reset D_out[13] VSS VDD_1V8 dff_async_rst_527
Xbit__12__prll_regstr_ D_in[12] clk reset D_out[12] VSS VDD_1V8 dff_async_rst_528
Xbit__11__prll_regstr_ D_in[11] clk reset D_out[11] VSS VDD_1V8 dff_async_rst_529
Xbit__10__prll_regstr_ D_in[10] clk reset D_out[10] VSS VDD_1V8 dff_async_rst_530
Xbit__9__prll_regstr_ D_in[9] clk reset D_out[9] VSS VDD_1V8 dff_async_rst_531
Xbit__8__prll_regstr_ D_in[8] clk IN1 D_out[8] VSS VDD_1V8 dff_async_rst_532
Xbit__7__prll_regstr_ D_in[7] clk_cts_1 IN0 D_out[7] VSS VDD_1V8 dff_async_rst_533
Xbit__6__prll_regstr_ D_in[6] clk IN12 D_out[6] VSS VDD_1V8 dff_async_rst_534
Xbit__5__prll_regstr_ D_in[5] clk_cts_1 IN5 D_out[5] VSS VDD_1V8 dff_async_rst_535
Xbit__4__prll_regstr_ D_in[4] clk IN2 D_out[4] VSS VDD_1V8 dff_async_rst_536
Xbit__3__prll_regstr_ D_in[3] clk_cts_1 IN22 D_out[3] VSS VDD_1V8 dff_async_rst_537
Xbit__2__prll_regstr_ D_in[2] clk IN16 D_out[2] VSS VDD_1V8 dff_async_rst_538
Xbit__1__prll_regstr_ D_in[1] clk IN4 D_out[1] VSS VDD_1V8 dff_async_rst_539
Xbit__0__prll_regstr_ D_in[0] clk IN3 D_out[0] VSS VDD_1V8 dff_async_rst_540
.ENDS

.SUBCKT prll_d_reg_bits65_6 clk reset D_in[64] D_in[63] D_in[62] D_in[61] D_in[60]
+ D_in[59] D_in[58] D_in[57] D_in[56] D_in[55] D_in[54] D_in[53] D_in[52] D_in[51]
+ D_in[50] D_in[49] D_in[48] D_in[47] D_in[46] D_in[45] D_in[44] D_in[43] D_in[42]
+ D_in[41] D_in[40] D_in[39] D_in[38] D_in[37] D_in[36] D_in[35] D_in[34] D_in[33]
+ D_in[32] D_in[31] D_in[30] D_in[29] D_in[28] D_in[27] D_in[26] D_in[25] D_in[24]
+ D_in[23] D_in[22] D_in[21] D_in[20] D_in[19] D_in[18] D_in[17] D_in[16] D_in[15]
+ D_in[14] D_in[13] D_in[12] D_in[11] D_in[10] D_in[9] D_in[8] D_in[7] D_in[6] D_in[5]
+ D_in[4] D_in[3] D_in[2] D_in[1] D_in[0] D_out[64] D_out[63] D_out[62] D_out[61]
+ D_out[60] D_out[59] D_out[58] D_out[57] D_out[56] D_out[55] D_out[54] D_out[53]
+ D_out[52] D_out[51] D_out[50] D_out[49] D_out[48] D_out[47] D_out[46] D_out[45]
+ D_out[44] D_out[43] D_out[42] D_out[41] D_out[40] D_out[39] D_out[38] D_out[37]
+ D_out[36] D_out[35] D_out[34] D_out[33] D_out[32] D_out[31] D_out[30] D_out[29]
+ D_out[28] D_out[27] D_out[26] D_out[25] D_out[24] D_out[23] D_out[22] D_out[21]
+ D_out[20] D_out[19] D_out[18] D_out[17] D_out[16] D_out[15] D_out[14] D_out[13]
+ D_out[12] D_out[11] D_out[10] D_out[9] D_out[8] D_out[7] D_out[6] D_out[5] D_out[4]
+ D_out[3] D_out[2] D_out[1] D_out[0] VSS VDD_1V8 IN0 IN1 IN2 IN3 IN4 IN5 IN6 IN7
+ IN8 IN9 IN10 IN11 IN12 IN13 IN14 IN15 IN16 IN17 IN18 IN19 IN20 IN21 IN22 IN23
+ IN24 IN25 IN26 IN27 IN28 IN29 IN30 IN31 IN32 clk_cts_1
Xbit__64__prll_regstr_ D_in[64] clk reset D_out[64] VSS VDD_1V8 dff_async_rst_411
Xbit__63__prll_regstr_ D_in[63] clk IN7 D_out[63] VSS VDD_1V8 dff_async_rst_412
Xbit__62__prll_regstr_ D_in[62] clk IN10 D_out[62] VSS VDD_1V8 dff_async_rst_413
Xbit__59__prll_regstr_ D_in[59] clk_cts_1 IN30 D_out[59] VSS VDD_1V8 dff_async_rst_416
Xbit__58__prll_regstr_ D_in[58] clk_cts_1 IN26 D_out[58] VSS VDD_1V8 dff_async_rst_417
Xbit__57__prll_regstr_ D_in[57] clk_cts_1 IN31 D_out[57] VSS VDD_1V8 dff_async_rst_418
Xbit__54__prll_regstr_ D_in[54] clk reset D_out[54] VSS VDD_1V8 dff_async_rst_421
Xbit__53__prll_regstr_ D_in[53] clk_cts_1 IN23 D_out[53] VSS VDD_1V8 dff_async_rst_422
Xbit__52__prll_regstr_ D_in[52] clk IN1 D_out[52] VSS VDD_1V8 dff_async_rst_423
Xbit__51__prll_regstr_ D_in[51] clk IN11 D_out[51] VSS VDD_1V8 dff_async_rst_424
Xbit__50__prll_regstr_ D_in[50] clk_cts_1 IN20 D_out[50] VSS VDD_1V8 dff_async_rst_425
Xbit__49__prll_regstr_ D_in[49] clk_cts_1 IN13 D_out[49] VSS VDD_1V8 dff_async_rst_426
Xbit__48__prll_regstr_ D_in[48] clk_cts_1 IN21 D_out[48] VSS VDD_1V8 dff_async_rst_427
Xbit__47__prll_regstr_ D_in[47] clk_cts_1 IN19 D_out[47] VSS VDD_1V8 dff_async_rst_428
Xbit__46__prll_regstr_ D_in[46] clk IN2 D_out[46] VSS VDD_1V8 dff_async_rst_429
Xbit__45__prll_regstr_ D_in[45] clk_cts_1 IN24 D_out[45] VSS VDD_1V8 dff_async_rst_430
Xbit__44__prll_regstr_ D_in[44] clk_cts_1 IN22 D_out[44] VSS VDD_1V8 dff_async_rst_431
Xbit__43__prll_regstr_ D_in[43] clk_cts_1 IN25 D_out[43] VSS VDD_1V8 dff_async_rst_432
Xbit__42__prll_regstr_ D_in[42] clk_cts_1 IN28 D_out[42] VSS VDD_1V8 dff_async_rst_433
Xbit__41__prll_regstr_ D_in[41] clk_cts_1 IN5 D_out[41] VSS VDD_1V8 dff_async_rst_434
Xbit__40__prll_regstr_ D_in[40] clk_cts_1 IN15 D_out[40] VSS VDD_1V8 dff_async_rst_435
Xbit__39__prll_regstr_ D_in[39] clk_cts_1 IN32 D_out[39] VSS VDD_1V8 dff_async_rst_436
Xbit__38__prll_regstr_ D_in[38] clk_cts_1 IN29 D_out[38] VSS VDD_1V8 dff_async_rst_437
Xbit__37__prll_regstr_ D_in[37] clk_cts_1 IN27 D_out[37] VSS VDD_1V8 dff_async_rst_438
Xbit__36__prll_regstr_ D_in[36] clk IN0 D_out[36] VSS VDD_1V8 dff_async_rst_439
Xbit__35__prll_regstr_ D_in[35] clk reset D_out[35] VSS VDD_1V8 dff_async_rst_440
Xbit__34__prll_regstr_ D_in[34] clk IN4 D_out[34] VSS VDD_1V8 dff_async_rst_441
Xbit__33__prll_regstr_ D_in[33] clk reset D_out[33] VSS VDD_1V8 dff_async_rst_442
Xbit__32__prll_regstr_ D_in[32] clk reset D_out[32] VSS VDD_1V8 dff_async_rst_443
Xbit__31__prll_regstr_ D_in[31] clk reset D_out[31] VSS VDD_1V8 dff_async_rst_444
Xbit__30__prll_regstr_ D_in[30] clk reset D_out[30] VSS VDD_1V8 dff_async_rst_445
Xbit__29__prll_regstr_ D_in[29] clk reset D_out[29] VSS VDD_1V8 dff_async_rst_446
Xbit__28__prll_regstr_ D_in[28] clk reset D_out[28] VSS VDD_1V8 dff_async_rst_447
Xbit__27__prll_regstr_ D_in[27] clk reset D_out[27] VSS VDD_1V8 dff_async_rst_448
Xbit__26__prll_regstr_ D_in[26] clk reset D_out[26] VSS VDD_1V8 dff_async_rst_449
Xbit__25__prll_regstr_ D_in[25] clk reset D_out[25] VSS VDD_1V8 dff_async_rst_450
Xbit__24__prll_regstr_ D_in[24] clk reset D_out[24] VSS VDD_1V8 dff_async_rst_451
Xbit__23__prll_regstr_ D_in[23] clk reset D_out[23] VSS VDD_1V8 dff_async_rst_452
Xbit__22__prll_regstr_ D_in[22] clk reset D_out[22] VSS VDD_1V8 dff_async_rst_453
Xbit__21__prll_regstr_ D_in[21] clk reset D_out[21] VSS VDD_1V8 dff_async_rst_454
Xbit__20__prll_regstr_ D_in[20] clk reset D_out[20] VSS VDD_1V8 dff_async_rst_455
Xbit__19__prll_regstr_ D_in[19] clk reset D_out[19] VSS VDD_1V8 dff_async_rst_456
Xbit__18__prll_regstr_ D_in[18] clk reset D_out[18] VSS VDD_1V8 dff_async_rst_457
Xbit__17__prll_regstr_ D_in[17] clk reset D_out[17] VSS VDD_1V8 dff_async_rst_458
Xbit__16__prll_regstr_ D_in[16] clk reset D_out[16] VSS VDD_1V8 dff_async_rst_459
Xbit__15__prll_regstr_ D_in[15] clk reset D_out[15] VSS VDD_1V8 dff_async_rst_460
Xbit__14__prll_regstr_ D_in[14] clk reset D_out[14] VSS VDD_1V8 dff_async_rst_461
Xbit__13__prll_regstr_ D_in[13] clk reset D_out[13] VSS VDD_1V8 dff_async_rst_462
Xbit__12__prll_regstr_ D_in[12] clk reset D_out[12] VSS VDD_1V8 dff_async_rst_463
Xbit__11__prll_regstr_ D_in[11] clk reset D_out[11] VSS VDD_1V8 dff_async_rst_464
Xbit__10__prll_regstr_ D_in[10] clk reset D_out[10] VSS VDD_1V8 dff_async_rst_465
Xbit__9__prll_regstr_ D_in[9] clk reset D_out[9] VSS VDD_1V8 dff_async_rst_466
Xbit__8__prll_regstr_ D_in[8] clk IN3 D_out[8] VSS VDD_1V8 dff_async_rst_467
Xbit__7__prll_regstr_ D_in[7] clk_cts_1 IN18 D_out[7] VSS VDD_1V8 dff_async_rst_468
Xbit__6__prll_regstr_ D_in[6] clk IN14 D_out[6] VSS VDD_1V8 dff_async_rst_469
Xbit__5__prll_regstr_ D_in[5] clk_cts_1 IN16 D_out[5] VSS VDD_1V8 dff_async_rst_470
Xbit__4__prll_regstr_ D_in[4] clk IN6 D_out[4] VSS VDD_1V8 dff_async_rst_471
Xbit__3__prll_regstr_ D_in[3] clk_cts_1 IN17 D_out[3] VSS VDD_1V8 dff_async_rst_472
Xbit__2__prll_regstr_ D_in[2] clk IN9 D_out[2] VSS VDD_1V8 dff_async_rst_473
Xbit__1__prll_regstr_ D_in[1] clk IN8 D_out[1] VSS VDD_1V8 dff_async_rst_474
Xbit__0__prll_regstr_ D_in[0] clk IN12 D_out[0] VSS VDD_1V8 dff_async_rst_475
.ENDS

.SUBCKT prll_d_reg_bits65_5 clk reset D_in[64] D_in[63] D_in[62] D_in[61] D_in[60]
+ D_in[59] D_in[58] D_in[57] D_in[56] D_in[55] D_in[54] D_in[53] D_in[52] D_in[51]
+ D_in[50] D_in[49] D_in[48] D_in[47] D_in[46] D_in[45] D_in[44] D_in[43] D_in[42]
+ D_in[41] D_in[40] D_in[39] D_in[38] D_in[37] D_in[36] D_in[35] D_in[34] D_in[33]
+ D_in[32] D_in[31] D_in[30] D_in[29] D_in[28] D_in[27] D_in[26] D_in[25] D_in[24]
+ D_in[23] D_in[22] D_in[21] D_in[20] D_in[19] D_in[18] D_in[17] D_in[16] D_in[15]
+ D_in[14] D_in[13] D_in[12] D_in[11] D_in[10] D_in[9] D_in[8] D_in[7] D_in[6] D_in[5]
+ D_in[4] D_in[3] D_in[2] D_in[1] D_in[0] D_out[64] D_out[63] D_out[62] D_out[61]
+ D_out[60] D_out[59] D_out[58] D_out[57] D_out[56] D_out[55] D_out[54] D_out[53]
+ D_out[52] D_out[51] D_out[50] D_out[49] D_out[48] D_out[47] D_out[46] D_out[45]
+ D_out[44] D_out[43] D_out[42] D_out[41] D_out[40] D_out[39] D_out[38] D_out[37]
+ D_out[36] D_out[35] D_out[34] D_out[33] D_out[32] D_out[31] D_out[30] D_out[29]
+ D_out[28] D_out[27] D_out[26] D_out[25] D_out[24] D_out[23] D_out[22] D_out[21]
+ D_out[20] D_out[19] D_out[18] D_out[17] D_out[16] D_out[15] D_out[14] D_out[13]
+ D_out[12] D_out[11] D_out[10] D_out[9] D_out[8] D_out[7] D_out[6] D_out[5] D_out[4]
+ D_out[3] D_out[2] D_out[1] D_out[0] VSS VDD_1V8 IN0 IN1 IN2 IN3 IN4 IN5 IN6 IN7
+ IN8 IN9 IN10 IN11 IN12 IN13 IN14 IN15 IN16 IN17 IN18 IN19 IN20 IN21 IN22 IN23
+ IN24 IN25 IN26 IN27 IN28 IN29 IN30 IN31 IN32 IN33 IN34 IN35 IN36 IN37 IN38 IN39
+ IN40 clk_cts_1
Xbit__60__prll_regstr_ D_in[60] clk IN0 D_out[60] VSS VDD_1V8 dff_async_rst_350
Xbit__59__prll_regstr_ D_in[59] clk_cts_1 reset D_out[59] VSS VDD_1V8 dff_async_rst_351
Xbit__58__prll_regstr_ D_in[58] clk_cts_1 reset D_out[58] VSS VDD_1V8 dff_async_rst_352
Xbit__57__prll_regstr_ D_in[57] clk_cts_1 reset D_out[57] VSS VDD_1V8 dff_async_rst_353
Xbit__56__prll_regstr_ D_in[56] clk_cts_1 reset D_out[56] VSS VDD_1V8 dff_async_rst_354
Xbit__55__prll_regstr_ D_in[55] clk_cts_1 reset D_out[55] VSS VDD_1V8 dff_async_rst_355
Xbit__54__prll_regstr_ D_in[54] clk_cts_1 reset D_out[54] VSS VDD_1V8 dff_async_rst_356
Xbit__53__prll_regstr_ D_in[53] clk_cts_1 reset D_out[53] VSS VDD_1V8 dff_async_rst_357
Xbit__52__prll_regstr_ D_in[52] clk_cts_1 IN37 D_out[52] VSS VDD_1V8 dff_async_rst_358
Xbit__51__prll_regstr_ D_in[51] clk_cts_1 reset D_out[51] VSS VDD_1V8 dff_async_rst_359
Xbit__50__prll_regstr_ D_in[50] clk_cts_1 reset D_out[50] VSS VDD_1V8 dff_async_rst_360
Xbit__49__prll_regstr_ D_in[49] clk_cts_1 reset D_out[49] VSS VDD_1V8 dff_async_rst_361
Xbit__48__prll_regstr_ D_in[48] clk_cts_1 reset D_out[48] VSS VDD_1V8 dff_async_rst_362
Xbit__47__prll_regstr_ D_in[47] clk_cts_1 reset D_out[47] VSS VDD_1V8 dff_async_rst_363
Xbit__46__prll_regstr_ D_in[46] clk_cts_1 IN39 D_out[46] VSS VDD_1V8 dff_async_rst_364
Xbit__45__prll_regstr_ D_in[45] clk_cts_1 reset D_out[45] VSS VDD_1V8 dff_async_rst_365
Xbit__44__prll_regstr_ D_in[44] clk_cts_1 reset D_out[44] VSS VDD_1V8 dff_async_rst_366
Xbit__43__prll_regstr_ D_in[43] clk_cts_1 reset D_out[43] VSS VDD_1V8 dff_async_rst_367
Xbit__42__prll_regstr_ D_in[42] clk_cts_1 reset D_out[42] VSS VDD_1V8 dff_async_rst_368
Xbit__41__prll_regstr_ D_in[41] clk_cts_1 IN34 D_out[41] VSS VDD_1V8 dff_async_rst_369
Xbit__40__prll_regstr_ D_in[40] clk_cts_1 reset D_out[40] VSS VDD_1V8 dff_async_rst_370
Xbit__39__prll_regstr_ D_in[39] clk_cts_1 reset D_out[39] VSS VDD_1V8 dff_async_rst_371
Xbit__38__prll_regstr_ D_in[38] clk_cts_1 reset D_out[38] VSS VDD_1V8 dff_async_rst_372
Xbit__37__prll_regstr_ D_in[37] clk_cts_1 reset D_out[37] VSS VDD_1V8 dff_async_rst_373
Xbit__36__prll_regstr_ D_in[36] clk_cts_1 IN36 D_out[36] VSS VDD_1V8 dff_async_rst_374
Xbit__35__prll_regstr_ D_in[35] clk_cts_1 IN33 D_out[35] VSS VDD_1V8 dff_async_rst_375
Xbit__34__prll_regstr_ D_in[34] clk_cts_1 IN38 D_out[34] VSS VDD_1V8 dff_async_rst_376
Xbit__33__prll_regstr_ D_in[33] clk_cts_1 IN35 D_out[33] VSS VDD_1V8 dff_async_rst_377
Xbit__32__prll_regstr_ D_in[32] clk_cts_1 IN40 D_out[32] VSS VDD_1V8 dff_async_rst_378
Xbit__31__prll_regstr_ D_in[31] clk IN23 D_out[31] VSS VDD_1V8 dff_async_rst_379
Xbit__30__prll_regstr_ D_in[30] clk IN29 D_out[30] VSS VDD_1V8 dff_async_rst_380
Xbit__29__prll_regstr_ D_in[29] clk IN26 D_out[29] VSS VDD_1V8 dff_async_rst_381
Xbit__28__prll_regstr_ D_in[28] clk IN32 D_out[28] VSS VDD_1V8 dff_async_rst_382
Xbit__27__prll_regstr_ D_in[27] clk IN5 D_out[27] VSS VDD_1V8 dff_async_rst_383
Xbit__26__prll_regstr_ D_in[26] clk IN3 D_out[26] VSS VDD_1V8 dff_async_rst_384
Xbit__25__prll_regstr_ D_in[25] clk IN2 D_out[25] VSS VDD_1V8 dff_async_rst_385
Xbit__24__prll_regstr_ D_in[24] clk IN1 D_out[24] VSS VDD_1V8 dff_async_rst_386
Xbit__23__prll_regstr_ D_in[23] clk IN13 D_out[23] VSS VDD_1V8 dff_async_rst_387
Xbit__22__prll_regstr_ D_in[22] clk IN10 D_out[22] VSS VDD_1V8 dff_async_rst_388
Xbit__21__prll_regstr_ D_in[21] clk IN12 D_out[21] VSS VDD_1V8 dff_async_rst_389
Xbit__20__prll_regstr_ D_in[20] clk IN17 D_out[20] VSS VDD_1V8 dff_async_rst_390
Xbit__19__prll_regstr_ D_in[19] clk IN31 D_out[19] VSS VDD_1V8 dff_async_rst_391
Xbit__18__prll_regstr_ D_in[18] clk IN30 D_out[18] VSS VDD_1V8 dff_async_rst_392
Xbit__17__prll_regstr_ D_in[17] clk IN22 D_out[17] VSS VDD_1V8 dff_async_rst_393
Xbit__16__prll_regstr_ D_in[16] clk IN21 D_out[16] VSS VDD_1V8 dff_async_rst_394
Xbit__15__prll_regstr_ D_in[15] clk IN27 D_out[15] VSS VDD_1V8 dff_async_rst_395
Xbit__14__prll_regstr_ D_in[14] clk IN16 D_out[14] VSS VDD_1V8 dff_async_rst_396
Xbit__13__prll_regstr_ D_in[13] clk IN9 D_out[13] VSS VDD_1V8 dff_async_rst_397
Xbit__12__prll_regstr_ D_in[12] clk IN15 D_out[12] VSS VDD_1V8 dff_async_rst_398
Xbit__11__prll_regstr_ D_in[11] clk IN11 D_out[11] VSS VDD_1V8 dff_async_rst_399
Xbit__10__prll_regstr_ D_in[10] clk IN14 D_out[10] VSS VDD_1V8 dff_async_rst_400
Xbit__9__prll_regstr_ D_in[9] clk IN8 D_out[9] VSS VDD_1V8 dff_async_rst_401
Xbit__8__prll_regstr_ D_in[8] clk IN19 D_out[8] VSS VDD_1V8 dff_async_rst_402
Xbit__7__prll_regstr_ D_in[7] clk IN6 D_out[7] VSS VDD_1V8 dff_async_rst_403
Xbit__6__prll_regstr_ D_in[6] clk IN7 D_out[6] VSS VDD_1V8 dff_async_rst_404
Xbit__5__prll_regstr_ D_in[5] clk IN28 D_out[5] VSS VDD_1V8 dff_async_rst_405
Xbit__4__prll_regstr_ D_in[4] clk IN4 D_out[4] VSS VDD_1V8 dff_async_rst_406
Xbit__3__prll_regstr_ D_in[3] clk IN25 D_out[3] VSS VDD_1V8 dff_async_rst_407
Xbit__2__prll_regstr_ D_in[2] clk IN18 D_out[2] VSS VDD_1V8 dff_async_rst_408
Xbit__1__prll_regstr_ D_in[1] clk IN20 D_out[1] VSS VDD_1V8 dff_async_rst_409
Xbit__0__prll_regstr_ D_in[0] clk IN24 D_out[0] VSS VDD_1V8 dff_async_rst_410
.ENDS

.SUBCKT prll_d_reg_bits65_4 clk reset D_in[64] D_in[63] D_in[62] D_in[61] D_in[60]
+ D_in[59] D_in[58] D_in[57] D_in[56] D_in[55] D_in[54] D_in[53] D_in[52] D_in[51]
+ D_in[50] D_in[49] D_in[48] D_in[47] D_in[46] D_in[45] D_in[44] D_in[43] D_in[42]
+ D_in[41] D_in[40] D_in[39] D_in[38] D_in[37] D_in[36] D_in[35] D_in[34] D_in[33]
+ D_in[32] D_in[31] D_in[30] D_in[29] D_in[28] D_in[27] D_in[26] D_in[25] D_in[24]
+ D_in[23] D_in[22] D_in[21] D_in[20] D_in[19] D_in[18] D_in[17] D_in[16] D_in[15]
+ D_in[14] D_in[13] D_in[12] D_in[11] D_in[10] D_in[9] D_in[8] D_in[7] D_in[6] D_in[5]
+ D_in[4] D_in[3] D_in[2] D_in[1] D_in[0] D_out[64] D_out[63] D_out[62] D_out[61]
+ D_out[60] D_out[59] D_out[58] D_out[57] D_out[56] D_out[55] D_out[54] D_out[53]
+ D_out[52] D_out[51] D_out[50] D_out[49] D_out[48] D_out[47] D_out[46] D_out[45]
+ D_out[44] D_out[43] D_out[42] D_out[41] D_out[40] D_out[39] D_out[38] D_out[37]
+ D_out[36] D_out[35] D_out[34] D_out[33] D_out[32] D_out[31] D_out[30] D_out[29]
+ D_out[28] D_out[27] D_out[26] D_out[25] D_out[24] D_out[23] D_out[22] D_out[21]
+ D_out[20] D_out[19] D_out[18] D_out[17] D_out[16] D_out[15] D_out[14] D_out[13]
+ D_out[12] D_out[11] D_out[10] D_out[9] D_out[8] D_out[7] D_out[6] D_out[5] D_out[4]
+ D_out[3] D_out[2] D_out[1] D_out[0] VSS VDD_1V8 IN0 IN1 IN2 IN3 IN4 IN5 IN6 IN7
+ IN8 IN9 IN10 IN11 IN12 IN13 IN14 IN15 IN16 IN17 IN18 IN19 IN20 IN21 IN22 IN23
+ IN24 IN25 IN26 IN27 IN28 IN29 IN30 IN31 IN32 IN33 IN34 IN35 IN36 IN37 clk_cts_1
Xbit__60__prll_regstr_ D_in[60] clk IN0 D_out[60] VSS VDD_1V8 dff_async_rst_285
Xbit__59__prll_regstr_ D_in[59] clk_cts_1 reset D_out[59] VSS VDD_1V8 dff_async_rst_286
Xbit__58__prll_regstr_ D_in[58] clk_cts_1 reset D_out[58] VSS VDD_1V8 dff_async_rst_287
Xbit__57__prll_regstr_ D_in[57] clk_cts_1 reset D_out[57] VSS VDD_1V8 dff_async_rst_288
Xbit__56__prll_regstr_ D_in[56] clk_cts_1 reset D_out[56] VSS VDD_1V8 dff_async_rst_289
Xbit__55__prll_regstr_ D_in[55] clk_cts_1 reset D_out[55] VSS VDD_1V8 dff_async_rst_290
Xbit__54__prll_regstr_ D_in[54] clk_cts_1 reset D_out[54] VSS VDD_1V8 dff_async_rst_291
Xbit__53__prll_regstr_ D_in[53] clk_cts_1 reset D_out[53] VSS VDD_1V8 dff_async_rst_292
Xbit__52__prll_regstr_ D_in[52] clk_cts_1 IN36 D_out[52] VSS VDD_1V8 dff_async_rst_293
Xbit__51__prll_regstr_ D_in[51] clk_cts_1 reset D_out[51] VSS VDD_1V8 dff_async_rst_294
Xbit__50__prll_regstr_ D_in[50] clk_cts_1 reset D_out[50] VSS VDD_1V8 dff_async_rst_295
Xbit__49__prll_regstr_ D_in[49] clk_cts_1 reset D_out[49] VSS VDD_1V8 dff_async_rst_296
Xbit__48__prll_regstr_ D_in[48] clk_cts_1 reset D_out[48] VSS VDD_1V8 dff_async_rst_297
Xbit__47__prll_regstr_ D_in[47] clk_cts_1 reset D_out[47] VSS VDD_1V8 dff_async_rst_298
Xbit__46__prll_regstr_ D_in[46] clk_cts_1 IN34 D_out[46] VSS VDD_1V8 dff_async_rst_299
Xbit__45__prll_regstr_ D_in[45] clk_cts_1 reset D_out[45] VSS VDD_1V8 dff_async_rst_300
Xbit__44__prll_regstr_ D_in[44] clk_cts_1 reset D_out[44] VSS VDD_1V8 dff_async_rst_301
Xbit__43__prll_regstr_ D_in[43] clk_cts_1 reset D_out[43] VSS VDD_1V8 dff_async_rst_302
Xbit__42__prll_regstr_ D_in[42] clk_cts_1 reset D_out[42] VSS VDD_1V8 dff_async_rst_303
Xbit__41__prll_regstr_ D_in[41] clk_cts_1 reset D_out[41] VSS VDD_1V8 dff_async_rst_304
Xbit__40__prll_regstr_ D_in[40] clk_cts_1 reset D_out[40] VSS VDD_1V8 dff_async_rst_305
Xbit__39__prll_regstr_ D_in[39] clk_cts_1 reset D_out[39] VSS VDD_1V8 dff_async_rst_306
Xbit__38__prll_regstr_ D_in[38] clk_cts_1 reset D_out[38] VSS VDD_1V8 dff_async_rst_307
Xbit__37__prll_regstr_ D_in[37] clk_cts_1 reset D_out[37] VSS VDD_1V8 dff_async_rst_308
Xbit__36__prll_regstr_ D_in[36] clk_cts_1 reset D_out[36] VSS VDD_1V8 dff_async_rst_309
Xbit__35__prll_regstr_ D_in[35] clk_cts_1 IN33 D_out[35] VSS VDD_1V8 dff_async_rst_310
Xbit__34__prll_regstr_ D_in[34] clk_cts_1 reset D_out[34] VSS VDD_1V8 dff_async_rst_311
Xbit__33__prll_regstr_ D_in[33] clk_cts_1 IN35 D_out[33] VSS VDD_1V8 dff_async_rst_312
Xbit__32__prll_regstr_ D_in[32] clk_cts_1 IN37 D_out[32] VSS VDD_1V8 dff_async_rst_313
Xbit__31__prll_regstr_ D_in[31] clk IN28 D_out[31] VSS VDD_1V8 dff_async_rst_314
Xbit__30__prll_regstr_ D_in[30] clk IN20 D_out[30] VSS VDD_1V8 dff_async_rst_315
Xbit__29__prll_regstr_ D_in[29] clk IN31 D_out[29] VSS VDD_1V8 dff_async_rst_316
Xbit__28__prll_regstr_ D_in[28] clk IN32 D_out[28] VSS VDD_1V8 dff_async_rst_317
Xbit__27__prll_regstr_ D_in[27] clk IN4 D_out[27] VSS VDD_1V8 dff_async_rst_318
Xbit__26__prll_regstr_ D_in[26] clk IN6 D_out[26] VSS VDD_1V8 dff_async_rst_319
Xbit__25__prll_regstr_ D_in[25] clk IN1 D_out[25] VSS VDD_1V8 dff_async_rst_320
Xbit__24__prll_regstr_ D_in[24] clk IN2 D_out[24] VSS VDD_1V8 dff_async_rst_321
Xbit__23__prll_regstr_ D_in[23] clk IN12 D_out[23] VSS VDD_1V8 dff_async_rst_322
Xbit__22__prll_regstr_ D_in[22] clk IN10 D_out[22] VSS VDD_1V8 dff_async_rst_323
Xbit__21__prll_regstr_ D_in[21] clk IN11 D_out[21] VSS VDD_1V8 dff_async_rst_324
Xbit__20__prll_regstr_ D_in[20] clk IN13 D_out[20] VSS VDD_1V8 dff_async_rst_325
Xbit__19__prll_regstr_ D_in[19] clk IN27 D_out[19] VSS VDD_1V8 dff_async_rst_326
Xbit__18__prll_regstr_ D_in[18] clk IN22 D_out[18] VSS VDD_1V8 dff_async_rst_327
Xbit__17__prll_regstr_ D_in[17] clk IN29 D_out[17] VSS VDD_1V8 dff_async_rst_328
Xbit__16__prll_regstr_ D_in[16] clk IN15 D_out[16] VSS VDD_1V8 dff_async_rst_329
Xbit__15__prll_regstr_ D_in[15] clk IN23 D_out[15] VSS VDD_1V8 dff_async_rst_330
Xbit__14__prll_regstr_ D_in[14] clk IN18 D_out[14] VSS VDD_1V8 dff_async_rst_331
Xbit__13__prll_regstr_ D_in[13] clk IN9 D_out[13] VSS VDD_1V8 dff_async_rst_332
Xbit__12__prll_regstr_ D_in[12] clk IN17 D_out[12] VSS VDD_1V8 dff_async_rst_333
Xbit__11__prll_regstr_ D_in[11] clk IN14 D_out[11] VSS VDD_1V8 dff_async_rst_334
Xbit__10__prll_regstr_ D_in[10] clk IN21 D_out[10] VSS VDD_1V8 dff_async_rst_335
Xbit__9__prll_regstr_ D_in[9] clk IN8 D_out[9] VSS VDD_1V8 dff_async_rst_336
Xbit__8__prll_regstr_ D_in[8] clk IN16 D_out[8] VSS VDD_1V8 dff_async_rst_337
Xbit__7__prll_regstr_ D_in[7] clk IN7 D_out[7] VSS VDD_1V8 dff_async_rst_338
Xbit__6__prll_regstr_ D_in[6] clk IN5 D_out[6] VSS VDD_1V8 dff_async_rst_339
Xbit__5__prll_regstr_ D_in[5] clk IN30 D_out[5] VSS VDD_1V8 dff_async_rst_340
Xbit__4__prll_regstr_ D_in[4] clk IN3 D_out[4] VSS VDD_1V8 dff_async_rst_341
Xbit__3__prll_regstr_ D_in[3] clk IN19 D_out[3] VSS VDD_1V8 dff_async_rst_342
Xbit__2__prll_regstr_ D_in[2] clk IN24 D_out[2] VSS VDD_1V8 dff_async_rst_343
Xbit__1__prll_regstr_ D_in[1] clk IN25 D_out[1] VSS VDD_1V8 dff_async_rst_344
Xbit__0__prll_regstr_ D_in[0] clk IN26 D_out[0] VSS VDD_1V8 dff_async_rst_345
.ENDS

.SUBCKT prll_d_reg_bits65_3 clk reset D_in[64] D_in[63] D_in[62] D_in[61] D_in[60]
+ D_in[59] D_in[58] D_in[57] D_in[56] D_in[55] D_in[54] D_in[53] D_in[52] D_in[51]
+ D_in[50] D_in[49] D_in[48] D_in[47] D_in[46] D_in[45] D_in[44] D_in[43] D_in[42]
+ D_in[41] D_in[40] D_in[39] D_in[38] D_in[37] D_in[36] D_in[35] D_in[34] D_in[33]
+ D_in[32] D_in[31] D_in[30] D_in[29] D_in[28] D_in[27] D_in[26] D_in[25] D_in[24]
+ D_in[23] D_in[22] D_in[21] D_in[20] D_in[19] D_in[18] D_in[17] D_in[16] D_in[15]
+ D_in[14] D_in[13] D_in[12] D_in[11] D_in[10] D_in[9] D_in[8] D_in[7] D_in[6] D_in[5]
+ D_in[4] D_in[3] D_in[2] D_in[1] D_in[0] D_out[64] D_out[63] D_out[62] D_out[61]
+ D_out[60] D_out[59] D_out[58] D_out[57] D_out[56] D_out[55] D_out[54] D_out[53]
+ D_out[52] D_out[51] D_out[50] D_out[49] D_out[48] D_out[47] D_out[46] D_out[45]
+ D_out[44] D_out[43] D_out[42] D_out[41] D_out[40] D_out[39] D_out[38] D_out[37]
+ D_out[36] D_out[35] D_out[34] D_out[33] D_out[32] D_out[31] D_out[30] D_out[29]
+ D_out[28] D_out[27] D_out[26] D_out[25] D_out[24] D_out[23] D_out[22] D_out[21]
+ D_out[20] D_out[19] D_out[18] D_out[17] D_out[16] D_out[15] D_out[14] D_out[13]
+ D_out[12] D_out[11] D_out[10] D_out[9] D_out[8] D_out[7] D_out[6] D_out[5] D_out[4]
+ D_out[3] D_out[2] D_out[1] D_out[0] VSS VDD_1V8 IN0 IN1 IN2 IN3 IN4 IN5 IN6 IN7
+ IN8 IN9 IN10 IN11 IN12 IN13 IN14 IN15 IN16 IN17 IN18 IN19 IN20 IN21 IN22 IN23
+ IN24 IN25 IN26 IN27 IN28 IN29 IN30 IN31 IN32 IN33 IN34 IN35 IN36 IN37 IN38 IN39
+ IN40 IN41 IN42 IN43 IN44 IN45 IN46 IN47 IN48 IN49 IN50 IN51 IN52 IN53 IN54 IN55
+ IN56 IN57 IN58 clk_cts_1
Xbit__63__prll_regstr_ D_in[63] clk IN44 D_out[63] VSS VDD_1V8 dff_async_rst_217
Xbit__62__prll_regstr_ D_in[62] clk IN17 D_out[62] VSS VDD_1V8 dff_async_rst_218
Xbit__61__prll_regstr_ D_in[61] clk_cts_1 IN18 D_out[61] VSS VDD_1V8 dff_async_rst_219
Xbit__60__prll_regstr_ D_in[60] clk IN41 D_out[60] VSS VDD_1V8 dff_async_rst_220
Xbit__59__prll_regstr_ D_in[59] clk IN48 D_out[59] VSS VDD_1V8 dff_async_rst_221
Xbit__58__prll_regstr_ D_in[58] clk IN43 D_out[58] VSS VDD_1V8 dff_async_rst_222
Xbit__57__prll_regstr_ D_in[57] clk IN39 D_out[57] VSS VDD_1V8 dff_async_rst_223
Xbit__56__prll_regstr_ D_in[56] clk IN24 D_out[56] VSS VDD_1V8 dff_async_rst_224
Xbit__55__prll_regstr_ D_in[55] clk IN38 D_out[55] VSS VDD_1V8 dff_async_rst_225
Xbit__54__prll_regstr_ D_in[54] clk IN28 D_out[54] VSS VDD_1V8 dff_async_rst_226
Xbit__53__prll_regstr_ D_in[53] clk IN37 D_out[53] VSS VDD_1V8 dff_async_rst_227
Xbit__52__prll_regstr_ D_in[52] clk IN22 D_out[52] VSS VDD_1V8 dff_async_rst_228
Xbit__51__prll_regstr_ D_in[51] clk IN42 D_out[51] VSS VDD_1V8 dff_async_rst_229
Xbit__50__prll_regstr_ D_in[50] clk IN30 D_out[50] VSS VDD_1V8 dff_async_rst_230
Xbit__49__prll_regstr_ D_in[49] clk IN35 D_out[49] VSS VDD_1V8 dff_async_rst_231
Xbit__48__prll_regstr_ D_in[48] clk IN33 D_out[48] VSS VDD_1V8 dff_async_rst_232
Xbit__47__prll_regstr_ D_in[47] clk IN26 D_out[47] VSS VDD_1V8 dff_async_rst_233
Xbit__46__prll_regstr_ D_in[46] clk IN27 D_out[46] VSS VDD_1V8 dff_async_rst_234
Xbit__45__prll_regstr_ D_in[45] clk IN36 D_out[45] VSS VDD_1V8 dff_async_rst_235
Xbit__44__prll_regstr_ D_in[44] clk IN31 D_out[44] VSS VDD_1V8 dff_async_rst_236
Xbit__43__prll_regstr_ D_in[43] clk IN47 D_out[43] VSS VDD_1V8 dff_async_rst_237
Xbit__42__prll_regstr_ D_in[42] clk IN23 D_out[42] VSS VDD_1V8 dff_async_rst_238
Xbit__41__prll_regstr_ D_in[41] clk IN46 D_out[41] VSS VDD_1V8 dff_async_rst_239
Xbit__40__prll_regstr_ D_in[40] clk IN25 D_out[40] VSS VDD_1V8 dff_async_rst_240
Xbit__39__prll_regstr_ D_in[39] clk IN49 D_out[39] VSS VDD_1V8 dff_async_rst_241
Xbit__38__prll_regstr_ D_in[38] clk IN40 D_out[38] VSS VDD_1V8 dff_async_rst_242
Xbit__37__prll_regstr_ D_in[37] clk IN32 D_out[37] VSS VDD_1V8 dff_async_rst_243
Xbit__36__prll_regstr_ D_in[36] clk IN45 D_out[36] VSS VDD_1V8 dff_async_rst_244
Xbit__35__prll_regstr_ D_in[35] clk IN29 D_out[35] VSS VDD_1V8 dff_async_rst_245
Xbit__34__prll_regstr_ D_in[34] clk IN34 D_out[34] VSS VDD_1V8 dff_async_rst_246
Xbit__33__prll_regstr_ D_in[33] clk IN15 D_out[33] VSS VDD_1V8 dff_async_rst_247
Xbit__32__prll_regstr_ D_in[32] clk IN19 D_out[32] VSS VDD_1V8 dff_async_rst_248
Xbit__31__prll_regstr_ D_in[31] clk_cts_1 reset D_out[31] VSS VDD_1V8 dff_async_rst_249
Xbit__30__prll_regstr_ D_in[30] clk_cts_1 IN53 D_out[30] VSS VDD_1V8 dff_async_rst_250
Xbit__29__prll_regstr_ D_in[29] clk_cts_1 IN52 D_out[29] VSS VDD_1V8 dff_async_rst_251
Xbit__28__prll_regstr_ D_in[28] clk_cts_1 reset D_out[28] VSS VDD_1V8 dff_async_rst_252
Xbit__27__prll_regstr_ D_in[27] clk_cts_1 IN51 D_out[27] VSS VDD_1V8 dff_async_rst_253
Xbit__26__prll_regstr_ D_in[26] clk_cts_1 IN9 D_out[26] VSS VDD_1V8 dff_async_rst_254
Xbit__25__prll_regstr_ D_in[25] clk_cts_1 reset D_out[25] VSS VDD_1V8 dff_async_rst_255
Xbit__24__prll_regstr_ D_in[24] clk_cts_1 IN55 D_out[24] VSS VDD_1V8 dff_async_rst_256
Xbit__23__prll_regstr_ D_in[23] clk IN7 D_out[23] VSS VDD_1V8 dff_async_rst_257
Xbit__22__prll_regstr_ D_in[22] clk_cts_1 IN0 D_out[22] VSS VDD_1V8 dff_async_rst_258
Xbit__21__prll_regstr_ D_in[21] clk_cts_1 IN3 D_out[21] VSS VDD_1V8 dff_async_rst_259
Xbit__20__prll_regstr_ D_in[20] clk IN6 D_out[20] VSS VDD_1V8 dff_async_rst_260
Xbit__19__prll_regstr_ D_in[19] clk_cts_1 IN5 D_out[19] VSS VDD_1V8 dff_async_rst_261
Xbit__18__prll_regstr_ D_in[18] clk_cts_1 IN56 D_out[18] VSS VDD_1V8 dff_async_rst_262
Xbit__17__prll_regstr_ D_in[17] clk IN1 D_out[17] VSS VDD_1V8 dff_async_rst_263
Xbit__16__prll_regstr_ D_in[16] clk IN2 D_out[16] VSS VDD_1V8 dff_async_rst_264
Xbit__15__prll_regstr_ D_in[15] clk_cts_1 IN58 D_out[15] VSS VDD_1V8 dff_async_rst_265
Xbit__14__prll_regstr_ D_in[14] clk_cts_1 IN50 D_out[14] VSS VDD_1V8 dff_async_rst_266
Xbit__13__prll_regstr_ D_in[13] clk_cts_1 IN54 D_out[13] VSS VDD_1V8 dff_async_rst_267
Xbit__12__prll_regstr_ D_in[12] clk_cts_1 IN57 D_out[12] VSS VDD_1V8 dff_async_rst_268
Xbit__11__prll_regstr_ D_in[11] clk_cts_1 reset D_out[11] VSS VDD_1V8 dff_async_rst_269
Xbit__10__prll_regstr_ D_in[10] clk_cts_1 reset D_out[10] VSS VDD_1V8 dff_async_rst_270
Xbit__9__prll_regstr_ D_in[9] clk_cts_1 IN4 D_out[9] VSS VDD_1V8 dff_async_rst_271
Xbit__8__prll_regstr_ D_in[8] clk_cts_1 IN20 D_out[8] VSS VDD_1V8 dff_async_rst_272
Xbit__7__prll_regstr_ D_in[7] clk IN21 D_out[7] VSS VDD_1V8 dff_async_rst_273
Xbit__6__prll_regstr_ D_in[6] clk IN11 D_out[6] VSS VDD_1V8 dff_async_rst_274
Xbit__5__prll_regstr_ D_in[5] clk IN14 D_out[5] VSS VDD_1V8 dff_async_rst_275
Xbit__4__prll_regstr_ D_in[4] clk IN16 D_out[4] VSS VDD_1V8 dff_async_rst_276
Xbit__3__prll_regstr_ D_in[3] clk IN10 D_out[3] VSS VDD_1V8 dff_async_rst_277
Xbit__2__prll_regstr_ D_in[2] clk IN12 D_out[2] VSS VDD_1V8 dff_async_rst_278
Xbit__1__prll_regstr_ D_in[1] clk IN13 D_out[1] VSS VDD_1V8 dff_async_rst_279
Xbit__0__prll_regstr_ D_in[0] clk IN8 D_out[0] VSS VDD_1V8 dff_async_rst_280
.ENDS

.SUBCKT prll_d_reg_bits65_2 clk reset D_in[64] D_in[63] D_in[62] D_in[61] D_in[60]
+ D_in[59] D_in[58] D_in[57] D_in[56] D_in[55] D_in[54] D_in[53] D_in[52] D_in[51]
+ D_in[50] D_in[49] D_in[48] D_in[47] D_in[46] D_in[45] D_in[44] D_in[43] D_in[42]
+ D_in[41] D_in[40] D_in[39] D_in[38] D_in[37] D_in[36] D_in[35] D_in[34] D_in[33]
+ D_in[32] D_in[31] D_in[30] D_in[29] D_in[28] D_in[27] D_in[26] D_in[25] D_in[24]
+ D_in[23] D_in[22] D_in[21] D_in[20] D_in[19] D_in[18] D_in[17] D_in[16] D_in[15]
+ D_in[14] D_in[13] D_in[12] D_in[11] D_in[10] D_in[9] D_in[8] D_in[7] D_in[6] D_in[5]
+ D_in[4] D_in[3] D_in[2] D_in[1] D_in[0] D_out[64] D_out[63] D_out[62] D_out[61]
+ D_out[60] D_out[59] D_out[58] D_out[57] D_out[56] D_out[55] D_out[54] D_out[53]
+ D_out[52] D_out[51] D_out[50] D_out[49] D_out[48] D_out[47] D_out[46] D_out[45]
+ D_out[44] D_out[43] D_out[42] D_out[41] D_out[40] D_out[39] D_out[38] D_out[37]
+ D_out[36] D_out[35] D_out[34] D_out[33] D_out[32] D_out[31] D_out[30] D_out[29]
+ D_out[28] D_out[27] D_out[26] D_out[25] D_out[24] D_out[23] D_out[22] D_out[21]
+ D_out[20] D_out[19] D_out[18] D_out[17] D_out[16] D_out[15] D_out[14] D_out[13]
+ D_out[12] D_out[11] D_out[10] D_out[9] D_out[8] D_out[7] D_out[6] D_out[5] D_out[4]
+ D_out[3] D_out[2] D_out[1] D_out[0] VSS VDD_1V8 IN0 IN1 IN2 IN3 IN4 IN5 IN6 IN7
+ IN8 IN9 IN10 IN11 IN12 IN13 IN14 IN15 IN16 IN17 IN18 IN19 IN20 IN21 IN22 IN23
+ IN24 IN25 IN26 IN27 IN28 IN29 IN30 IN31 IN32 IN33 IN34 IN35 IN36 IN37 IN38 IN39
+ IN40 IN41 IN42 IN43 clk_cts_1
Xbit__63__prll_regstr_ D_in[63] clk IN11 D_out[63] VSS VDD_1V8 dff_async_rst_152
Xbit__62__prll_regstr_ D_in[62] clk reset D_out[62] VSS VDD_1V8 dff_async_rst_153
Xbit__61__prll_regstr_ D_in[61] clk reset D_out[61] VSS VDD_1V8 dff_async_rst_154
Xbit__60__prll_regstr_ D_in[60] clk IN8 D_out[60] VSS VDD_1V8 dff_async_rst_155
Xbit__59__prll_regstr_ D_in[59] clk IN17 D_out[59] VSS VDD_1V8 dff_async_rst_156
Xbit__58__prll_regstr_ D_in[58] clk IN12 D_out[58] VSS VDD_1V8 dff_async_rst_157
Xbit__57__prll_regstr_ D_in[57] clk IN4 D_out[57] VSS VDD_1V8 dff_async_rst_158
Xbit__56__prll_regstr_ D_in[56] clk IN5 D_out[56] VSS VDD_1V8 dff_async_rst_159
Xbit__55__prll_regstr_ D_in[55] clk IN22 D_out[55] VSS VDD_1V8 dff_async_rst_160
Xbit__54__prll_regstr_ D_in[54] clk IN14 D_out[54] VSS VDD_1V8 dff_async_rst_161
Xbit__53__prll_regstr_ D_in[53] clk IN21 D_out[53] VSS VDD_1V8 dff_async_rst_162
Xbit__52__prll_regstr_ D_in[52] clk IN19 D_out[52] VSS VDD_1V8 dff_async_rst_163
Xbit__51__prll_regstr_ D_in[51] clk IN0 D_out[51] VSS VDD_1V8 dff_async_rst_164
Xbit__50__prll_regstr_ D_in[50] clk IN23 D_out[50] VSS VDD_1V8 dff_async_rst_165
Xbit__49__prll_regstr_ D_in[49] clk IN24 D_out[49] VSS VDD_1V8 dff_async_rst_166
Xbit__48__prll_regstr_ D_in[48] clk IN7 D_out[48] VSS VDD_1V8 dff_async_rst_167
Xbit__47__prll_regstr_ D_in[47] clk IN3 D_out[47] VSS VDD_1V8 dff_async_rst_168
Xbit__46__prll_regstr_ D_in[46] clk IN27 D_out[46] VSS VDD_1V8 dff_async_rst_169
Xbit__45__prll_regstr_ D_in[45] clk IN1 D_out[45] VSS VDD_1V8 dff_async_rst_170
Xbit__44__prll_regstr_ D_in[44] clk IN9 D_out[44] VSS VDD_1V8 dff_async_rst_171
Xbit__43__prll_regstr_ D_in[43] clk IN26 D_out[43] VSS VDD_1V8 dff_async_rst_172
Xbit__42__prll_regstr_ D_in[42] clk IN28 D_out[42] VSS VDD_1V8 dff_async_rst_173
Xbit__41__prll_regstr_ D_in[41] clk IN20 D_out[41] VSS VDD_1V8 dff_async_rst_174
Xbit__40__prll_regstr_ D_in[40] clk IN25 D_out[40] VSS VDD_1V8 dff_async_rst_175
Xbit__39__prll_regstr_ D_in[39] clk IN18 D_out[39] VSS VDD_1V8 dff_async_rst_176
Xbit__38__prll_regstr_ D_in[38] clk IN15 D_out[38] VSS VDD_1V8 dff_async_rst_177
Xbit__37__prll_regstr_ D_in[37] clk IN13 D_out[37] VSS VDD_1V8 dff_async_rst_178
Xbit__36__prll_regstr_ D_in[36] clk IN16 D_out[36] VSS VDD_1V8 dff_async_rst_179
Xbit__35__prll_regstr_ D_in[35] clk IN2 D_out[35] VSS VDD_1V8 dff_async_rst_180
Xbit__34__prll_regstr_ D_in[34] clk IN6 D_out[34] VSS VDD_1V8 dff_async_rst_181
Xbit__33__prll_regstr_ D_in[33] clk IN10 D_out[33] VSS VDD_1V8 dff_async_rst_182
Xbit__32__prll_regstr_ D_in[32] clk reset D_out[32] VSS VDD_1V8 dff_async_rst_183
Xbit__31__prll_regstr_ D_in[31] clk_cts_1 reset D_out[31] VSS VDD_1V8 dff_async_rst_184
Xbit__30__prll_regstr_ D_in[30] clk_cts_1 IN29 D_out[30] VSS VDD_1V8 dff_async_rst_185
Xbit__29__prll_regstr_ D_in[29] clk_cts_1 IN30 D_out[29] VSS VDD_1V8 dff_async_rst_186
Xbit__28__prll_regstr_ D_in[28] clk_cts_1 IN43 D_out[28] VSS VDD_1V8 dff_async_rst_187
Xbit__27__prll_regstr_ D_in[27] clk_cts_1 IN35 D_out[27] VSS VDD_1V8 dff_async_rst_188
Xbit__26__prll_regstr_ D_in[26] clk_cts_1 reset D_out[26] VSS VDD_1V8 dff_async_rst_189
Xbit__25__prll_regstr_ D_in[25] clk_cts_1 reset D_out[25] VSS VDD_1V8 dff_async_rst_190
Xbit__24__prll_regstr_ D_in[24] clk_cts_1 IN31 D_out[24] VSS VDD_1V8 dff_async_rst_191
Xbit__23__prll_regstr_ D_in[23] clk reset D_out[23] VSS VDD_1V8 dff_async_rst_192
Xbit__22__prll_regstr_ D_in[22] clk_cts_1 IN37 D_out[22] VSS VDD_1V8 dff_async_rst_193
Xbit__21__prll_regstr_ D_in[21] clk_cts_1 IN41 D_out[21] VSS VDD_1V8 dff_async_rst_194
Xbit__20__prll_regstr_ D_in[20] clk_cts_1 reset D_out[20] VSS VDD_1V8 dff_async_rst_195
Xbit__19__prll_regstr_ D_in[19] clk_cts_1 IN32 D_out[19] VSS VDD_1V8 dff_async_rst_196
Xbit__18__prll_regstr_ D_in[18] clk_cts_1 IN40 D_out[18] VSS VDD_1V8 dff_async_rst_197
Xbit__17__prll_regstr_ D_in[17] clk_cts_1 reset D_out[17] VSS VDD_1V8 dff_async_rst_198
Xbit__16__prll_regstr_ D_in[16] clk reset D_out[16] VSS VDD_1V8 dff_async_rst_199
Xbit__15__prll_regstr_ D_in[15] clk_cts_1 IN36 D_out[15] VSS VDD_1V8 dff_async_rst_200
Xbit__14__prll_regstr_ D_in[14] clk_cts_1 IN34 D_out[14] VSS VDD_1V8 dff_async_rst_201
Xbit__13__prll_regstr_ D_in[13] clk_cts_1 IN33 D_out[13] VSS VDD_1V8 dff_async_rst_202
Xbit__12__prll_regstr_ D_in[12] clk_cts_1 IN39 D_out[12] VSS VDD_1V8 dff_async_rst_203
Xbit__11__prll_regstr_ D_in[11] clk_cts_1 IN42 D_out[11] VSS VDD_1V8 dff_async_rst_204
Xbit__10__prll_regstr_ D_in[10] clk_cts_1 IN38 D_out[10] VSS VDD_1V8 dff_async_rst_205
Xbit__9__prll_regstr_ D_in[9] clk_cts_1 reset D_out[9] VSS VDD_1V8 dff_async_rst_206
Xbit__8__prll_regstr_ D_in[8] clk reset D_out[8] VSS VDD_1V8 dff_async_rst_207
Xbit__7__prll_regstr_ D_in[7] clk reset D_out[7] VSS VDD_1V8 dff_async_rst_208
Xbit__6__prll_regstr_ D_in[6] clk reset D_out[6] VSS VDD_1V8 dff_async_rst_209
Xbit__5__prll_regstr_ D_in[5] clk reset D_out[5] VSS VDD_1V8 dff_async_rst_210
Xbit__4__prll_regstr_ D_in[4] clk reset D_out[4] VSS VDD_1V8 dff_async_rst_211
Xbit__3__prll_regstr_ D_in[3] clk reset D_out[3] VSS VDD_1V8 dff_async_rst_212
Xbit__2__prll_regstr_ D_in[2] clk reset D_out[2] VSS VDD_1V8 dff_async_rst_213
Xbit__1__prll_regstr_ D_in[1] clk reset D_out[1] VSS VDD_1V8 dff_async_rst_214
Xbit__0__prll_regstr_ D_in[0] clk reset D_out[0] VSS VDD_1V8 dff_async_rst_215
.ENDS

.SUBCKT prll_d_reg_bits65_1 clk reset D_in[64] D_in[63] D_in[62] D_in[61] D_in[60]
+ D_in[59] D_in[58] D_in[57] D_in[56] D_in[55] D_in[54] D_in[53] D_in[52] D_in[51]
+ D_in[50] D_in[49] D_in[48] D_in[47] D_in[46] D_in[45] D_in[44] D_in[43] D_in[42]
+ D_in[41] D_in[40] D_in[39] D_in[38] D_in[37] D_in[36] D_in[35] D_in[34] D_in[33]
+ D_in[32] D_in[31] D_in[30] D_in[29] D_in[28] D_in[27] D_in[26] D_in[25] D_in[24]
+ D_in[23] D_in[22] D_in[21] D_in[20] D_in[19] D_in[18] D_in[17] D_in[16] D_in[15]
+ D_in[14] D_in[13] D_in[12] D_in[11] D_in[10] D_in[9] D_in[8] D_in[7] D_in[6] D_in[5]
+ D_in[4] D_in[3] D_in[2] D_in[1] D_in[0] D_out[64] D_out[63] D_out[62] D_out[61]
+ D_out[60] D_out[59] D_out[58] D_out[57] D_out[56] D_out[55] D_out[54] D_out[53]
+ D_out[52] D_out[51] D_out[50] D_out[49] D_out[48] D_out[47] D_out[46] D_out[45]
+ D_out[44] D_out[43] D_out[42] D_out[41] D_out[40] D_out[39] D_out[38] D_out[37]
+ D_out[36] D_out[35] D_out[34] D_out[33] D_out[32] D_out[31] D_out[30] D_out[29]
+ D_out[28] D_out[27] D_out[26] D_out[25] D_out[24] D_out[23] D_out[22] D_out[21]
+ D_out[20] D_out[19] D_out[18] D_out[17] D_out[16] D_out[15] D_out[14] D_out[13]
+ D_out[12] D_out[11] D_out[10] D_out[9] D_out[8] D_out[7] D_out[6] D_out[5] D_out[4]
+ D_out[3] D_out[2] D_out[1] D_out[0] VSS VDD_1V8 IN0 IN1 IN2 IN3 IN4 IN5 IN6 IN7
+ IN8 IN9 IN10 IN11 IN12 IN13 IN14 IN15 IN16 IN17 IN18 IN19 IN20 IN21 IN22 IN23
+ IN24 IN25 IN26 IN27 IN28 IN29 IN30 IN31 IN32 IN33 IN34 IN35 IN36 IN37 IN38 IN39
+ IN40 IN41 IN42 clk_cts_1
Xbit__63__prll_regstr_ D_in[63] clk reset D_out[63] VSS VDD_1V8 dff_async_rst_87
Xbit__62__prll_regstr_ D_in[62] clk reset D_out[62] VSS VDD_1V8 dff_async_rst_88
Xbit__61__prll_regstr_ D_in[61] clk reset D_out[61] VSS VDD_1V8 dff_async_rst_89
Xbit__60__prll_regstr_ D_in[60] clk reset D_out[60] VSS VDD_1V8 dff_async_rst_90
Xbit__59__prll_regstr_ D_in[59] clk IN28 D_out[59] VSS VDD_1V8 dff_async_rst_91
Xbit__58__prll_regstr_ D_in[58] clk IN27 D_out[58] VSS VDD_1V8 dff_async_rst_92
Xbit__57__prll_regstr_ D_in[57] clk IN20 D_out[57] VSS VDD_1V8 dff_async_rst_93
Xbit__56__prll_regstr_ D_in[56] clk IN21 D_out[56] VSS VDD_1V8 dff_async_rst_94
Xbit__55__prll_regstr_ D_in[55] clk IN22 D_out[55] VSS VDD_1V8 dff_async_rst_95
Xbit__54__prll_regstr_ D_in[54] clk IN25 D_out[54] VSS VDD_1V8 dff_async_rst_96
Xbit__53__prll_regstr_ D_in[53] clk IN31 D_out[53] VSS VDD_1V8 dff_async_rst_97
Xbit__52__prll_regstr_ D_in[52] clk reset D_out[52] VSS VDD_1V8 dff_async_rst_98
Xbit__51__prll_regstr_ D_in[51] clk IN23 D_out[51] VSS VDD_1V8 dff_async_rst_99
Xbit__50__prll_regstr_ D_in[50] clk IN30 D_out[50] VSS VDD_1V8 dff_async_rst_100
Xbit__49__prll_regstr_ D_in[49] clk IN18 D_out[49] VSS VDD_1V8 dff_async_rst_101
Xbit__48__prll_regstr_ D_in[48] clk IN19 D_out[48] VSS VDD_1V8 dff_async_rst_102
Xbit__47__prll_regstr_ D_in[47] clk IN40 D_out[47] VSS VDD_1V8 dff_async_rst_103
Xbit__46__prll_regstr_ D_in[46] clk IN38 D_out[46] VSS VDD_1V8 dff_async_rst_104
Xbit__45__prll_regstr_ D_in[45] clk IN35 D_out[45] VSS VDD_1V8 dff_async_rst_105
Xbit__44__prll_regstr_ D_in[44] clk IN39 D_out[44] VSS VDD_1V8 dff_async_rst_106
Xbit__43__prll_regstr_ D_in[43] clk IN29 D_out[43] VSS VDD_1V8 dff_async_rst_107
Xbit__42__prll_regstr_ D_in[42] clk IN36 D_out[42] VSS VDD_1V8 dff_async_rst_108
Xbit__41__prll_regstr_ D_in[41] clk IN24 D_out[41] VSS VDD_1V8 dff_async_rst_109
Xbit__40__prll_regstr_ D_in[40] clk IN42 D_out[40] VSS VDD_1V8 dff_async_rst_110
Xbit__39__prll_regstr_ D_in[39] clk IN32 D_out[39] VSS VDD_1V8 dff_async_rst_111
Xbit__38__prll_regstr_ D_in[38] clk IN37 D_out[38] VSS VDD_1V8 dff_async_rst_112
Xbit__37__prll_regstr_ D_in[37] clk IN33 D_out[37] VSS VDD_1V8 dff_async_rst_113
Xbit__36__prll_regstr_ D_in[36] clk IN26 D_out[36] VSS VDD_1V8 dff_async_rst_114
Xbit__35__prll_regstr_ D_in[35] clk IN34 D_out[35] VSS VDD_1V8 dff_async_rst_115
Xbit__34__prll_regstr_ D_in[34] clk IN41 D_out[34] VSS VDD_1V8 dff_async_rst_116
Xbit__33__prll_regstr_ D_in[33] clk reset D_out[33] VSS VDD_1V8 dff_async_rst_117
Xbit__32__prll_regstr_ D_in[32] clk reset D_out[32] VSS VDD_1V8 dff_async_rst_118
Xbit__31__prll_regstr_ D_in[31] clk_cts_1 reset D_out[31] VSS VDD_1V8 dff_async_rst_119
Xbit__30__prll_regstr_ D_in[30] clk reset D_out[30] VSS VDD_1V8 dff_async_rst_120
Xbit__29__prll_regstr_ D_in[29] clk reset D_out[29] VSS VDD_1V8 dff_async_rst_121
Xbit__28__prll_regstr_ D_in[28] clk_cts_1 reset D_out[28] VSS VDD_1V8 dff_async_rst_122
Xbit__27__prll_regstr_ D_in[27] clk_cts_1 reset D_out[27] VSS VDD_1V8 dff_async_rst_123
Xbit__26__prll_regstr_ D_in[26] clk reset D_out[26] VSS VDD_1V8 dff_async_rst_124
Xbit__25__prll_regstr_ D_in[25] clk reset D_out[25] VSS VDD_1V8 dff_async_rst_125
Xbit__24__prll_regstr_ D_in[24] clk reset D_out[24] VSS VDD_1V8 dff_async_rst_126
Xbit__23__prll_regstr_ D_in[23] clk_cts_1 IN16 D_out[23] VSS VDD_1V8 dff_async_rst_127
Xbit__22__prll_regstr_ D_in[22] clk_cts_1 IN15 D_out[22] VSS VDD_1V8 dff_async_rst_128
Xbit__21__prll_regstr_ D_in[21] clk_cts_1 IN14 D_out[21] VSS VDD_1V8 dff_async_rst_129
Xbit__20__prll_regstr_ D_in[20] clk_cts_1 IN2 D_out[20] VSS VDD_1V8 dff_async_rst_130
Xbit__19__prll_regstr_ D_in[19] clk_cts_1 IN9 D_out[19] VSS VDD_1V8 dff_async_rst_131
Xbit__18__prll_regstr_ D_in[18] clk_cts_1 reset D_out[18] VSS VDD_1V8 dff_async_rst_132
Xbit__17__prll_regstr_ D_in[17] clk_cts_1 IN8 D_out[17] VSS VDD_1V8 dff_async_rst_133
Xbit__16__prll_regstr_ D_in[16] clk_cts_1 IN5 D_out[16] VSS VDD_1V8 dff_async_rst_134
Xbit__15__prll_regstr_ D_in[15] clk_cts_1 IN3 D_out[15] VSS VDD_1V8 dff_async_rst_135
Xbit__14__prll_regstr_ D_in[14] clk_cts_1 IN1 D_out[14] VSS VDD_1V8 dff_async_rst_136
Xbit__13__prll_regstr_ D_in[13] clk_cts_1 IN4 D_out[13] VSS VDD_1V8 dff_async_rst_137
Xbit__12__prll_regstr_ D_in[12] clk_cts_1 IN12 D_out[12] VSS VDD_1V8 dff_async_rst_138
Xbit__11__prll_regstr_ D_in[11] clk_cts_1 IN13 D_out[11] VSS VDD_1V8 dff_async_rst_139
Xbit__10__prll_regstr_ D_in[10] clk_cts_1 reset D_out[10] VSS VDD_1V8 dff_async_rst_140
Xbit__9__prll_regstr_ D_in[9] clk_cts_1 IN10 D_out[9] VSS VDD_1V8 dff_async_rst_141
Xbit__8__prll_regstr_ D_in[8] clk_cts_1 IN6 D_out[8] VSS VDD_1V8 dff_async_rst_142
Xbit__7__prll_regstr_ D_in[7] clk_cts_1 reset D_out[7] VSS VDD_1V8 dff_async_rst_143
Xbit__6__prll_regstr_ D_in[6] clk_cts_1 IN0 D_out[6] VSS VDD_1V8 dff_async_rst_144
Xbit__5__prll_regstr_ D_in[5] clk_cts_1 IN7 D_out[5] VSS VDD_1V8 dff_async_rst_145
Xbit__4__prll_regstr_ D_in[4] clk_cts_1 IN17 D_out[4] VSS VDD_1V8 dff_async_rst_146
Xbit__3__prll_regstr_ D_in[3] clk_cts_1 reset D_out[3] VSS VDD_1V8 dff_async_rst_147
Xbit__2__prll_regstr_ D_in[2] clk_cts_1 reset D_out[2] VSS VDD_1V8 dff_async_rst_148
Xbit__1__prll_regstr_ D_in[1] clk_cts_1 IN11 D_out[1] VSS VDD_1V8 dff_async_rst_149
Xbit__0__prll_regstr_ D_in[0] clk_cts_1 reset D_out[0] VSS VDD_1V8 dff_async_rst_150
.ENDS

.SUBCKT prll_d_reg_bits65_0 clk reset D_in[64] D_in[63] D_in[62] D_in[61] D_in[60]
+ D_in[59] D_in[58] D_in[57] D_in[56] D_in[55] D_in[54] D_in[53] D_in[52] D_in[51]
+ D_in[50] D_in[49] D_in[48] D_in[47] D_in[46] D_in[45] D_in[44] D_in[43] D_in[42]
+ D_in[41] D_in[40] D_in[39] D_in[38] D_in[37] D_in[36] D_in[35] D_in[34] D_in[33]
+ D_in[32] D_in[31] D_in[30] D_in[29] D_in[28] D_in[27] D_in[26] D_in[25] D_in[24]
+ D_in[23] D_in[22] D_in[21] D_in[20] D_in[19] D_in[18] D_in[17] D_in[16] D_in[15]
+ D_in[14] D_in[13] D_in[12] D_in[11] D_in[10] D_in[9] D_in[8] D_in[7] D_in[6] D_in[5]
+ D_in[4] D_in[3] D_in[2] D_in[1] D_in[0] D_out[64] D_out[63] D_out[62] D_out[61]
+ D_out[60] D_out[59] D_out[58] D_out[57] D_out[56] D_out[55] D_out[54] D_out[53]
+ D_out[52] D_out[51] D_out[50] D_out[49] D_out[48] D_out[47] D_out[46] D_out[45]
+ D_out[44] D_out[43] D_out[42] D_out[41] D_out[40] D_out[39] D_out[38] D_out[37]
+ D_out[36] D_out[35] D_out[34] D_out[33] D_out[32] D_out[31] D_out[30] D_out[29]
+ D_out[28] D_out[27] D_out[26] D_out[25] D_out[24] D_out[23] D_out[22] D_out[21]
+ D_out[20] D_out[19] D_out[18] D_out[17] D_out[16] D_out[15] D_out[14] D_out[13]
+ D_out[12] D_out[11] D_out[10] D_out[9] D_out[8] D_out[7] D_out[6] D_out[5] D_out[4]
+ D_out[3] D_out[2] D_out[1] D_out[0] VSS VDD_1V8 IN0 IN1 IN2 IN3 IN4 IN5 IN6 IN7
+ IN8 IN9 IN10 IN11 IN12 IN13 IN14 IN15 IN16 IN17 IN18 IN19 IN20 IN21 IN22 IN23
+ IN24 IN25 IN26 IN27 IN28 IN29 IN30 IN31 IN32 IN33 IN34 IN35 IN36 IN37 IN38 IN39
+ IN40 IN41 IN42 IN43 clk_cts_1
Xbit__63__prll_regstr_ D_in[63] clk reset D_out[63] VSS VDD_1V8 dff_async_rst_22
Xbit__62__prll_regstr_ D_in[62] clk reset D_out[62] VSS VDD_1V8 dff_async_rst_23
Xbit__61__prll_regstr_ D_in[61] clk reset D_out[61] VSS VDD_1V8 dff_async_rst_24
Xbit__60__prll_regstr_ D_in[60] clk reset D_out[60] VSS VDD_1V8 dff_async_rst_25
Xbit__59__prll_regstr_ D_in[59] clk IN33 D_out[59] VSS VDD_1V8 dff_async_rst_26
Xbit__58__prll_regstr_ D_in[58] clk IN39 D_out[58] VSS VDD_1V8 dff_async_rst_27
Xbit__57__prll_regstr_ D_in[57] clk IN35 D_out[57] VSS VDD_1V8 dff_async_rst_28
Xbit__56__prll_regstr_ D_in[56] clk IN23 D_out[56] VSS VDD_1V8 dff_async_rst_29
Xbit__55__prll_regstr_ D_in[55] clk IN26 D_out[55] VSS VDD_1V8 dff_async_rst_30
Xbit__54__prll_regstr_ D_in[54] clk IN27 D_out[54] VSS VDD_1V8 dff_async_rst_31
Xbit__53__prll_regstr_ D_in[53] clk IN30 D_out[53] VSS VDD_1V8 dff_async_rst_32
Xbit__52__prll_regstr_ D_in[52] clk reset D_out[52] VSS VDD_1V8 dff_async_rst_33
Xbit__51__prll_regstr_ D_in[51] clk IN31 D_out[51] VSS VDD_1V8 dff_async_rst_34
Xbit__50__prll_regstr_ D_in[50] clk IN41 D_out[50] VSS VDD_1V8 dff_async_rst_35
Xbit__49__prll_regstr_ D_in[49] clk IN37 D_out[49] VSS VDD_1V8 dff_async_rst_36
Xbit__48__prll_regstr_ D_in[48] clk IN24 D_out[48] VSS VDD_1V8 dff_async_rst_37
Xbit__47__prll_regstr_ D_in[47] clk IN32 D_out[47] VSS VDD_1V8 dff_async_rst_38
Xbit__46__prll_regstr_ D_in[46] clk IN40 D_out[46] VSS VDD_1V8 dff_async_rst_39
Xbit__45__prll_regstr_ D_in[45] clk IN36 D_out[45] VSS VDD_1V8 dff_async_rst_40
Xbit__44__prll_regstr_ D_in[44] clk IN28 D_out[44] VSS VDD_1V8 dff_async_rst_41
Xbit__43__prll_regstr_ D_in[43] clk IN21 D_out[43] VSS VDD_1V8 dff_async_rst_42
Xbit__42__prll_regstr_ D_in[42] clk IN22 D_out[42] VSS VDD_1V8 dff_async_rst_43
Xbit__41__prll_regstr_ D_in[41] clk IN19 D_out[41] VSS VDD_1V8 dff_async_rst_44
Xbit__40__prll_regstr_ D_in[40] clk IN18 D_out[40] VSS VDD_1V8 dff_async_rst_45
Xbit__39__prll_regstr_ D_in[39] clk IN38 D_out[39] VSS VDD_1V8 dff_async_rst_46
Xbit__38__prll_regstr_ D_in[38] clk IN42 D_out[38] VSS VDD_1V8 dff_async_rst_47
Xbit__37__prll_regstr_ D_in[37] clk IN20 D_out[37] VSS VDD_1V8 dff_async_rst_48
Xbit__36__prll_regstr_ D_in[36] clk IN25 D_out[36] VSS VDD_1V8 dff_async_rst_49
Xbit__35__prll_regstr_ D_in[35] clk IN29 D_out[35] VSS VDD_1V8 dff_async_rst_50
Xbit__34__prll_regstr_ D_in[34] clk IN34 D_out[34] VSS VDD_1V8 dff_async_rst_51
Xbit__33__prll_regstr_ D_in[33] clk reset D_out[33] VSS VDD_1V8 dff_async_rst_52
Xbit__32__prll_regstr_ D_in[32] clk IN43 D_out[32] VSS VDD_1V8 dff_async_rst_53
Xbit__31__prll_regstr_ D_in[31] clk_cts_1 reset D_out[31] VSS VDD_1V8 dff_async_rst_54
Xbit__30__prll_regstr_ D_in[30] clk_cts_1 reset D_out[30] VSS VDD_1V8 dff_async_rst_55
Xbit__29__prll_regstr_ D_in[29] clk_cts_1 reset D_out[29] VSS VDD_1V8 dff_async_rst_56
Xbit__28__prll_regstr_ D_in[28] clk_cts_1 reset D_out[28] VSS VDD_1V8 dff_async_rst_57
Xbit__27__prll_regstr_ D_in[27] clk_cts_1 reset D_out[27] VSS VDD_1V8 dff_async_rst_58
Xbit__26__prll_regstr_ D_in[26] clk reset D_out[26] VSS VDD_1V8 dff_async_rst_59
Xbit__25__prll_regstr_ D_in[25] clk_cts_1 reset D_out[25] VSS VDD_1V8 dff_async_rst_60
Xbit__24__prll_regstr_ D_in[24] clk reset D_out[24] VSS VDD_1V8 dff_async_rst_61
Xbit__23__prll_regstr_ D_in[23] clk_cts_1 IN9 D_out[23] VSS VDD_1V8 dff_async_rst_62
Xbit__22__prll_regstr_ D_in[22] clk_cts_1 IN17 D_out[22] VSS VDD_1V8 dff_async_rst_63
Xbit__21__prll_regstr_ D_in[21] clk_cts_1 IN16 D_out[21] VSS VDD_1V8 dff_async_rst_64
Xbit__20__prll_regstr_ D_in[20] clk_cts_1 IN2 D_out[20] VSS VDD_1V8 dff_async_rst_65
Xbit__19__prll_regstr_ D_in[19] clk_cts_1 IN10 D_out[19] VSS VDD_1V8 dff_async_rst_66
Xbit__18__prll_regstr_ D_in[18] clk_cts_1 reset D_out[18] VSS VDD_1V8 dff_async_rst_67
Xbit__17__prll_regstr_ D_in[17] clk_cts_1 IN12 D_out[17] VSS VDD_1V8 dff_async_rst_68
Xbit__16__prll_regstr_ D_in[16] clk_cts_1 IN6 D_out[16] VSS VDD_1V8 dff_async_rst_69
Xbit__15__prll_regstr_ D_in[15] clk_cts_1 IN11 D_out[15] VSS VDD_1V8 dff_async_rst_70
Xbit__14__prll_regstr_ D_in[14] clk_cts_1 IN4 D_out[14] VSS VDD_1V8 dff_async_rst_71
Xbit__13__prll_regstr_ D_in[13] clk_cts_1 IN8 D_out[13] VSS VDD_1V8 dff_async_rst_72
Xbit__12__prll_regstr_ D_in[12] clk_cts_1 IN14 D_out[12] VSS VDD_1V8 dff_async_rst_73
Xbit__11__prll_regstr_ D_in[11] clk_cts_1 IN13 D_out[11] VSS VDD_1V8 dff_async_rst_74
Xbit__10__prll_regstr_ D_in[10] clk_cts_1 IN0 D_out[10] VSS VDD_1V8 dff_async_rst_75
Xbit__9__prll_regstr_ D_in[9] clk_cts_1 IN15 D_out[9] VSS VDD_1V8 dff_async_rst_76
Xbit__8__prll_regstr_ D_in[8] clk_cts_1 IN3 D_out[8] VSS VDD_1V8 dff_async_rst_77
Xbit__7__prll_regstr_ D_in[7] clk_cts_1 reset D_out[7] VSS VDD_1V8 dff_async_rst_78
Xbit__6__prll_regstr_ D_in[6] clk_cts_1 IN7 D_out[6] VSS VDD_1V8 dff_async_rst_79
Xbit__5__prll_regstr_ D_in[5] clk_cts_1 IN1 D_out[5] VSS VDD_1V8 dff_async_rst_80
Xbit__4__prll_regstr_ D_in[4] clk_cts_1 reset D_out[4] VSS VDD_1V8 dff_async_rst_81
Xbit__3__prll_regstr_ D_in[3] clk_cts_1 reset D_out[3] VSS VDD_1V8 dff_async_rst_82
Xbit__2__prll_regstr_ D_in[2] clk_cts_1 reset D_out[2] VSS VDD_1V8 dff_async_rst_83
Xbit__1__prll_regstr_ D_in[1] clk_cts_1 IN5 D_out[1] VSS VDD_1V8 dff_async_rst_84
Xbit__0__prll_regstr_ D_in[0] clk_cts_1 reset D_out[0] VSS VDD_1V8 dff_async_rst_85
.ENDS

.SUBCKT csr_file_width32_number_reg12 Din[31] Din[30] Din[29] Din[28] Din[27] Din[26]
+ Din[25] Din[24] Din[23] Din[22] Din[21] Din[20] Din[19] Din[18] Din[17] Din[16]
+ Din[15] Din[14] Din[13] Din[12] Din[11] Din[10] Din[9] Din[8] Din[7] Din[6] Din[5]
+ Din[4] Din[3] Din[2] Din[1] Din[0] Dout1[31] Dout1[30] Dout1[29] Dout1[28] Dout1[27]
+ Dout1[26] Dout1[25] Dout1[24] Dout1[23] Dout1[22] Dout1[21] Dout1[20] Dout1[19]
+ Dout1[18] Dout1[17] Dout1[16] Dout1[15] Dout1[14] Dout1[13] Dout1[12] Dout1[11]
+ Dout1[10] Dout1[9] Dout1[8] Dout1[7] Dout1[6] Dout1[5] Dout1[4] Dout1[3] Dout1[2]
+ Dout1[1] Dout1[0] addres1[3] addres1[2] addres1[1] addres1[0] Write_en clk rst
+ mip_IO mip_time mie_IO mie_time comparation[31] comparation[30] comparation[29]
+ comparation[28] comparation[27] comparation[26] comparation[25] comparation[24]
+ comparation[23] comparation[22] comparation[21] comparation[20] comparation[19]
+ comparation[18] comparation[17] comparation[16] comparation[15] comparation[14]
+ comparation[13] comparation[12] comparation[11] comparation[10] comparation[9]
+ comparation[8] comparation[7] comparation[6] comparation[5] comparation[4] comparation[3]
+ comparation[2] comparation[1] comparation[0] timer[31] timer[30] timer[29] timer[28]
+ timer[27] timer[26] timer[25] timer[24] timer[23] timer[22] timer[21] timer[20]
+ timer[19] timer[18] timer[17] timer[16] timer[15] timer[14] timer[13] timer[12]
+ timer[11] timer[10] timer[9] timer[8] timer[7] timer[6] timer[5] timer[4] timer[3]
+ timer[2] timer[1] timer[0] full_range_level_shifter[7] full_range_level_shifter[6]
+ full_range_level_shifter[5] full_range_level_shifter[4] full_range_level_shifter[3]
+ full_range_level_shifter[2] full_range_level_shifter[1] full_range_level_shifter[0]
+ IS_Val[31] IS_Val[30] IS_Val[29] IS_Val[28] IS_Val[27] IS_Val[26] IS_Val[25] IS_Val[24]
+ IS_Val[23] IS_Val[22] IS_Val[21] IS_Val[20] IS_Val[19] IS_Val[18] IS_Val[17] IS_Val[16]
+ IS_Val[15] IS_Val[14] IS_Val[13] IS_Val[12] IS_Val[11] IS_Val[10] IS_Val[9] IS_Val[8]
+ IS_Val[7] IS_Val[6] IS_Val[5] IS_Val[4] IS_Val[3] IS_Val[2] IS_Val[1] IS_Val[0]
+ IS_Config[31] IS_Config[30] IS_Config[29] IS_Config[28] IS_Config[27] IS_Config[26]
+ IS_Config[25] IS_Config[24] IS_Config[23] IS_Config[22] IS_Config[21] IS_Config[20]
+ IS_Config[19] IS_Config[18] IS_Config[17] IS_Config[16] IS_Config[15] IS_Config[14]
+ IS_Config[13] IS_Config[12] IS_Config[11] IS_Config[10] IS_Config[9] IS_Config[8]
+ IS_Config[7] IS_Config[6] IS_Config[5] IS_Config[4] IS_Config[3] IS_Config[2]
+ IS_Config[1] IS_Config[0] IS_Trigger[3] IS_Trigger[2] IS_Trigger[1] IS_Trigger[0]
+ Mie_analogic mip_analogic Reg_GPIO_en[7] Reg_GPIO_en[6] Reg_GPIO_en[5] Reg_GPIO_en[4]
+ Reg_GPIO_en[3] Reg_GPIO_en[2] Reg_GPIO_en[1] Reg_GPIO_en[0] Reg_GPIO_int[7] Reg_GPIO_int[6]
+ Reg_GPIO_int[5] Reg_GPIO_int[4] Reg_GPIO_int[3] Reg_GPIO_int[2] Reg_GPIO_int[1]
+ Reg_GPIO_int[0] Reg_GPIO_out[7] Reg_GPIO_out[6] Reg_GPIO_out[5] Reg_GPIO_out[4]
+ Reg_GPIO_out[3] Reg_GPIO_out[2] Reg_GPIO_out[1] Reg_GPIO_out[0] VSS VDD_1V8 IN0
XIS_Trigge_31__rf19_Zero_tristate_IS_Trigger VSS conect_deco_latch1[11] Dout1[31]
+ VSS VDD_1V8 tristategate_251
XIS_Trigge_30__rf19_Zero_tristate_IS_Trigger VSS conect_deco_latch1[11] Dout1[30]
+ VSS VDD_1V8 tristategate_252
XIS_Trigge_29__rf19_Zero_tristate_IS_Trigger VSS conect_deco_latch1[11] Dout1[29]
+ VSS VDD_1V8 tristategate_253
XIS_Trigge_28__rf19_Zero_tristate_IS_Trigger VSS conect_deco_latch1[11] Dout1[28]
+ VSS VDD_1V8 tristategate_254
XIS_Trigge_27__rf19_Zero_tristate_IS_Trigger VSS conect_deco_latch1[11] Dout1[27]
+ VSS VDD_1V8 tristategate_255
XIS_Trigge_26__rf19_Zero_tristate_IS_Trigger VSS conect_deco_latch1[11] Dout1[26]
+ VSS VDD_1V8 tristategate_256
XIS_Trigge_25__rf19_Zero_tristate_IS_Trigger VSS conect_deco_latch1[11] Dout1[25]
+ VSS VDD_1V8 tristategate_257
XIS_Trigge_24__rf19_Zero_tristate_IS_Trigger VSS conect_deco_latch1[11] Dout1[24]
+ VSS VDD_1V8 tristategate_258
XIS_Trigge_23__rf19_Zero_tristate_IS_Trigger VSS conect_deco_latch1[11] Dout1[23]
+ VSS VDD_1V8 tristategate_259
XIS_Trigge_22__rf19_Zero_tristate_IS_Trigger VSS conect_deco_latch1[11] Dout1[22]
+ VSS VDD_1V8 tristategate_260
XIS_Trigge_21__rf19_Zero_tristate_IS_Trigger VSS conect_deco_latch1[11] Dout1[21]
+ VSS VDD_1V8 tristategate_261
XIS_Trigge_20__rf19_Zero_tristate_IS_Trigger VSS conect_deco_latch1[11] Dout1[20]
+ VSS VDD_1V8 tristategate_262
XIS_Trigge_19__rf19_Zero_tristate_IS_Trigger VSS conect_deco_latch1[11] Dout1[19]
+ VSS VDD_1V8 tristategate_263
XIS_Trigge_18__rf19_Zero_tristate_IS_Trigger VSS conect_deco_latch1[11] Dout1[18]
+ VSS VDD_1V8 tristategate_264
XIS_Trigge_17__rf19_Zero_tristate_IS_Trigger VSS conect_deco_latch1[11] Dout1[17]
+ VSS VDD_1V8 tristategate_265
XIS_Trigge_16__rf19_Zero_tristate_IS_Trigger VSS conect_deco_latch1[11] Dout1[16]
+ VSS VDD_1V8 tristategate_266
XIS_Trigge_15__rf19_Zero_tristate_IS_Trigger VSS conect_deco_latch1[11] Dout1[15]
+ VSS VDD_1V8 tristategate_267
XIS_Trigge_14__rf19_Zero_tristate_IS_Trigger VSS conect_deco_latch1[11] Dout1[14]
+ VSS VDD_1V8 tristategate_268
XIS_Trigge_13__rf19_Zero_tristate_IS_Trigger VSS conect_deco_latch1[11] Dout1[13]
+ VSS VDD_1V8 tristategate_269
XIS_Trigge_12__rf19_Zero_tristate_IS_Trigger VSS conect_deco_latch1[11] Dout1[12]
+ VSS VDD_1V8 tristategate_270
XIS_Trigge_11__rf19_Zero_tristate_IS_Trigger VSS conect_deco_latch1[11] Dout1[11]
+ VSS VDD_1V8 tristategate_271
XIS_Trigge_10__rf19_Zero_tristate_IS_Trigger VSS conect_deco_latch1[11] Dout1[10]
+ VSS VDD_1V8 tristategate_272
XIS_Trigge_9__rf19_Zero_tristate_IS_Trigger VSS conect_deco_latch1[11] Dout1[9]
+ VSS VDD_1V8 tristategate_273
XIS_Trigge_8__rf19_Zero_tristate_IS_Trigger VSS conect_deco_latch1[11] Dout1[8]
+ VSS VDD_1V8 tristategate_274
XIS_Trigge_7__rf19_Zero_tristate_IS_Trigger VSS conect_deco_latch1[11] Dout1[7]
+ VSS VDD_1V8 tristategate_275
XIS_Trigge_6__rf19_Zero_tristate_IS_Trigger VSS conect_deco_latch1[11] Dout1[6]
+ VSS VDD_1V8 tristategate_276
XIS_Trigge_5__rf19_Zero_tristate_IS_Trigger VSS conect_deco_latch1[11] Dout1[5]
+ VSS VDD_1V8 tristategate_277
XIS_Trigge_4__rf19_Zero_tristate_IS_Trigger VSS conect_deco_latch1[11] Dout1[4]
+ VSS VDD_1V8 tristategate_278
XIS_Trigge_3__rf18_latch_IS_Trigger Din[3] Dout1[3] conect_deco_latch1[11] CTS_CLK_CTO_delay61
+ n8 IS_Trigger[3] VSS VDD_1V8 latch_tri_rst0_Hard_0
XIS_Trigge_2__rf18_latch_IS_Trigger Din[2] Dout1[2] conect_deco_latch1[11] CTS_CLK_CTO_delay61
+ n8 IS_Trigger[2] VSS VDD_1V8 latch_tri_rst0_Hard_1
XIS_Trigge_1__rf18_latch_IS_Trigger Din[1] Dout1[1] conect_deco_latch1[11] CTS_CLK_CTO_delay61
+ n8 IS_Trigger[1] VSS VDD_1V8 latch_tri_rst0_Hard_2
XIS_Trigge_0__rf18_latch_IS_Trigger Din[0] Dout1[0] conect_deco_latch1[11] CTS_CLK_CTO_delay61
+ n8 IS_Trigger[0] VSS VDD_1V8 latch_tri_rst0_Hard_3
XIS_Confi_31__latch_IS_Config Din[31] Dout1[31] n98 Sal_and_write_10_G5B2I1 n5 n85
+ VSS VDD_1V8 latch_tri_rst0_Hard_4
XIS_Confi_30__latch_IS_Config Din[30] Dout1[30] n98 Sal_and_write_10_G5B2I1 n5 n83
+ VSS VDD_1V8 latch_tri_rst0_Hard_5
XIS_Confi_29__latch_IS_Config Din[29] Dout1[29] n98 Sal_and_write_10_G5B2I1 n5 n81
+ VSS VDD_1V8 latch_tri_rst0_Hard_6
XIS_Confi_28__latch_IS_Config Din[28] Dout1[28] n98 Sal_and_write_10_G5B2I1 n5 n79
+ VSS VDD_1V8 latch_tri_rst0_Hard_7
XIS_Confi_27__latch_IS_Config Din[27] Dout1[27] n98 Sal_and_write_10_G5B2I1 n5 n77
+ VSS VDD_1V8 latch_tri_rst0_Hard_8
XIS_Confi_26__latch_IS_Config Din[26] Dout1[26] n98 Sal_and_write_10_G5B2I1 n5 n75
+ VSS VDD_1V8 latch_tri_rst0_Hard_9
XIS_Confi_25__latch_IS_Config Din[25] Dout1[25] n98 Sal_and_write_10_G5B2I1 n5 n73
+ VSS VDD_1V8 latch_tri_rst0_Hard_10
XIS_Confi_24__latch_IS_Config Din[24] Dout1[24] n98 Sal_and_write_10_G5B2I1 n5 n71
+ VSS VDD_1V8 latch_tri_rst0_Hard_11
XIS_Confi_23__latch_IS_Config Din[23] Dout1[23] n98 Sal_and_write_10_G5B2I1 n5 n69
+ VSS VDD_1V8 latch_tri_rst0_Hard_12
XIS_Confi_22__latch_IS_Config Din[22] Dout1[22] n98 Sal_and_write_10_G5B2I1 n5 n67
+ VSS VDD_1V8 latch_tri_rst0_Hard_13
XIS_Confi_21__latch_IS_Config Din[21] Dout1[21] n98 Sal_and_write_10_G5B2I1 n5 n65
+ VSS VDD_1V8 latch_tri_rst0_Hard_14
XIS_Confi_20__latch_IS_Config Din[20] Dout1[20] n98 Sal_and_write_10_G5B2I1 n5 n63
+ VSS VDD_1V8 latch_tri_rst0_Hard_15
XIS_Confi_19__latch_IS_Config Din[19] Dout1[19] n98 Sal_and_write_10_G5B2I1 n8 n61
+ VSS VDD_1V8 latch_tri_rst0_Hard_16
XIS_Confi_18__latch_IS_Config Din[18] Dout1[18] n98 Sal_and_write_10_G5B2I1 n5 n59
+ VSS VDD_1V8 latch_tri_rst0_Hard_17
XIS_Confi_17__latch_IS_Config Din[17] Dout1[17] n98 Sal_and_write_10_G5B2I1 n8 n57
+ VSS VDD_1V8 latch_tri_rst0_Hard_18
XIS_Confi_16__latch_IS_Config Din[16] Dout1[16] n98 Sal_and_write_10_G5B2I1 n8 n55
+ VSS VDD_1V8 latch_tri_rst0_Hard_19
XIS_Confi_15__latch_IS_Config Din[15] Dout1[15] n98 Sal_and_write_10_G5B2I1 n8 n53
+ VSS VDD_1V8 latch_tri_rst0_Hard_20
XIS_Confi_14__latch_IS_Config Din[14] Dout1[14] n98 Sal_and_write_10_G5B2I1 n5 n51
+ VSS VDD_1V8 latch_tri_rst0_Hard_21
XIS_Confi_13__latch_IS_Config Din[13] Dout1[13] n98 Sal_and_write_10_G5B2I1 n4 n49
+ VSS VDD_1V8 latch_tri_rst0_Hard_22
XIS_Confi_12__latch_IS_Config Din[12] Dout1[12] n98 Sal_and_write_10_G5B2I1 n4 n47
+ VSS VDD_1V8 latch_tri_rst0_Hard_23
XIS_Confi_11__latch_IS_Config Din[11] Dout1[11] n98 Sal_and_write_10_G5B2I1 n5 n45
+ VSS VDD_1V8 latch_tri_rst0_Hard_24
XIS_Confi_10__latch_IS_Config Din[10] Dout1[10] n98 Sal_and_write_10_G5B2I1 n8 n43
+ VSS VDD_1V8 latch_tri_rst0_Hard_25
XIS_Confi_9__latch_IS_Config Din[9] Dout1[9] n98 Sal_and_write_10_G5B2I1 n4 n41
+ VSS VDD_1V8 latch_tri_rst0_Hard_26
XIS_Confi_8__latch_IS_Config Din[8] Dout1[8] n98 Sal_and_write_10_G5B2I1 n4 n39
+ VSS VDD_1V8 latch_tri_rst0_Hard_27
XIS_Confi_7__latch_IS_Config Din[7] Dout1[7] n98 Sal_and_write_10_G5B2I1 n8 n37
+ VSS VDD_1V8 latch_tri_rst0_Hard_28
XIS_Confi_6__latch_IS_Config Din[6] Dout1[6] n98 Sal_and_write_10_G5B2I1 n8 n35
+ VSS VDD_1V8 latch_tri_rst0_Hard_29
XIS_Confi_5__latch_IS_Config Din[5] Dout1[5] n98 Sal_and_write_10_G5B2I1 n8 n33
+ VSS VDD_1V8 latch_tri_rst0_Hard_30
XIS_Confi_4__latch_IS_Config Din[4] Dout1[4] n98 Sal_and_write_10_G5B2I1 n8 n31
+ VSS VDD_1V8 latch_tri_rst0_Hard_31
XIS_Confi_3__latch_IS_Config Din[3] Dout1[3] n98 Sal_and_write_10_G5B2I1 n8 n29
+ VSS VDD_1V8 latch_tri_rst0_Hard_32
XIS_Confi_2__latch_IS_Config Din[2] Dout1[2] n98 Sal_and_write_10_G5B2I1 n8 n27
+ VSS VDD_1V8 latch_tri_rst0_Hard_33
XIS_Confi_1__latch_IS_Config Din[1] Dout1[1] n98 Sal_and_write_10_G5B2I1 n8 n25
+ VSS VDD_1V8 latch_tri_rst0_Hard_34
XIS_Confi_0__latch_IS_Config Din[0] Dout1[0] n98 Sal_and_write_10_G5B2I1 n8 n23
+ VSS VDD_1V8 latch_tri_rst0_Hard_35
XIS_Va_31__latch_IS_Val Din[31] Dout1[31] conect_deco_latch1[9] Sal_and_write_9_G5B2I1
+ n5 n86 VSS VDD_1V8 latch_tri_rst0_Hard_36
XIS_Va_30__latch_IS_Val Din[30] Dout1[30] conect_deco_latch1[9] Sal_and_write_9_G5B2I1
+ n5 n84 VSS VDD_1V8 latch_tri_rst0_Hard_37
XIS_Va_29__latch_IS_Val Din[29] Dout1[29] conect_deco_latch1[9] Sal_and_write_9_G5B2I1
+ n5 n82 VSS VDD_1V8 latch_tri_rst0_Hard_38
XIS_Va_28__latch_IS_Val Din[28] Dout1[28] conect_deco_latch1[9] Sal_and_write_9_G5B2I1
+ n5 n80 VSS VDD_1V8 latch_tri_rst0_Hard_39
XIS_Va_27__latch_IS_Val Din[27] Dout1[27] conect_deco_latch1[9] Sal_and_write_9_G5B2I1
+ n5 n78 VSS VDD_1V8 latch_tri_rst0_Hard_40
XIS_Va_26__latch_IS_Val Din[26] Dout1[26] conect_deco_latch1[9] Sal_and_write_9_G5B2I1
+ n5 n76 VSS VDD_1V8 latch_tri_rst0_Hard_41
XIS_Va_25__latch_IS_Val Din[25] Dout1[25] conect_deco_latch1[9] Sal_and_write_9_G5B2I1
+ n5 n74 VSS VDD_1V8 latch_tri_rst0_Hard_42
XIS_Va_24__latch_IS_Val Din[24] Dout1[24] conect_deco_latch1[9] Sal_and_write_9_G5B2I1
+ n5 n72 VSS VDD_1V8 latch_tri_rst0_Hard_43
XIS_Va_23__latch_IS_Val Din[23] Dout1[23] conect_deco_latch1[9] Sal_and_write_9_G5B2I1
+ n5 n70 VSS VDD_1V8 latch_tri_rst0_Hard_44
XIS_Va_22__latch_IS_Val Din[22] Dout1[22] conect_deco_latch1[9] Sal_and_write_9_G5B2I1
+ n5 n68 VSS VDD_1V8 latch_tri_rst0_Hard_45
XIS_Va_21__latch_IS_Val Din[21] Dout1[21] conect_deco_latch1[9] Sal_and_write_9_G5B2I1
+ n5 n66 VSS VDD_1V8 latch_tri_rst0_Hard_46
XIS_Va_20__latch_IS_Val Din[20] Dout1[20] conect_deco_latch1[9] Sal_and_write_9_G5B2I1
+ n5 n64 VSS VDD_1V8 latch_tri_rst0_Hard_47
XIS_Va_19__latch_IS_Val Din[19] Dout1[19] conect_deco_latch1[9] Sal_and_write_9_G5B2I1
+ n8 n62 VSS VDD_1V8 latch_tri_rst0_Hard_48
XIS_Va_18__latch_IS_Val Din[18] Dout1[18] conect_deco_latch1[9] Sal_and_write_9_G5B2I1
+ n5 n60 VSS VDD_1V8 latch_tri_rst0_Hard_49
XIS_Va_17__latch_IS_Val Din[17] Dout1[17] conect_deco_latch1[9] Sal_and_write_9_G5B2I1
+ n8 n58 VSS VDD_1V8 latch_tri_rst0_Hard_50
XIS_Va_16__latch_IS_Val Din[16] Dout1[16] conect_deco_latch1[9] Sal_and_write_9_G5B2I1
+ n8 n56 VSS VDD_1V8 latch_tri_rst0_Hard_51
XIS_Va_15__latch_IS_Val Din[15] Dout1[15] conect_deco_latch1[9] Sal_and_write_9_G5B2I1
+ n8 n54 VSS VDD_1V8 latch_tri_rst0_Hard_52
XIS_Va_14__latch_IS_Val Din[14] Dout1[14] conect_deco_latch1[9] Sal_and_write_9_G5B2I1
+ n5 n52 VSS VDD_1V8 latch_tri_rst0_Hard_53
XIS_Va_13__latch_IS_Val Din[13] Dout1[13] conect_deco_latch1[9] Sal_and_write_9_G5B2I1
+ n4 n50 VSS VDD_1V8 latch_tri_rst0_Hard_54
XIS_Va_12__latch_IS_Val Din[12] Dout1[12] conect_deco_latch1[9] Sal_and_write_9_G5B2I1
+ n4 n48 VSS VDD_1V8 latch_tri_rst0_Hard_55
XIS_Va_11__latch_IS_Val Din[11] Dout1[11] conect_deco_latch1[9] Sal_and_write_9_G5B2I1
+ n5 n46 VSS VDD_1V8 latch_tri_rst0_Hard_56
XIS_Va_10__latch_IS_Val Din[10] Dout1[10] conect_deco_latch1[9] Sal_and_write_9_G5B2I1
+ n8 n44 VSS VDD_1V8 latch_tri_rst0_Hard_57
XIS_Va_9__latch_IS_Val Din[9] Dout1[9] conect_deco_latch1[9] Sal_and_write_9_G5B2I1
+ n4 n42 VSS VDD_1V8 latch_tri_rst0_Hard_58
XIS_Va_8__latch_IS_Val Din[8] Dout1[8] conect_deco_latch1[9] Sal_and_write_9_G5B2I1
+ n4 n40 VSS VDD_1V8 latch_tri_rst0_Hard_59
XIS_Va_7__latch_IS_Val Din[7] Dout1[7] conect_deco_latch1[9] Sal_and_write_9_G5B2I1
+ n8 n38 VSS VDD_1V8 latch_tri_rst0_Hard_60
XIS_Va_6__latch_IS_Val Din[6] Dout1[6] conect_deco_latch1[9] Sal_and_write_9_G5B2I1
+ n8 n36 VSS VDD_1V8 latch_tri_rst0_Hard_61
XIS_Va_5__latch_IS_Val Din[5] Dout1[5] conect_deco_latch1[9] Sal_and_write_9_G5B2I1
+ n8 n34 VSS VDD_1V8 latch_tri_rst0_Hard_62
XIS_Va_4__latch_IS_Val Din[4] Dout1[4] conect_deco_latch1[9] Sal_and_write_9_G5B2I1
+ n8 n32 VSS VDD_1V8 latch_tri_rst0_Hard_63
XIS_Va_3__latch_IS_Val Din[3] Dout1[3] conect_deco_latch1[9] Sal_and_write_9_G5B2I1
+ n8 n30 VSS VDD_1V8 latch_tri_rst0_Hard_64
XIS_Va_2__latch_IS_Val Din[2] Dout1[2] conect_deco_latch1[9] Sal_and_write_9_G5B2I1
+ n8 n28 VSS VDD_1V8 latch_tri_rst0_Hard_65
XIS_Va_1__latch_IS_Val Din[1] Dout1[1] conect_deco_latch1[9] Sal_and_write_9_G5B2I1
+ n8 n26 VSS VDD_1V8 latch_tri_rst0_Hard_66
XIS_Va_0__latch_IS_Val Din[0] Dout1[0] conect_deco_latch1[9] Sal_and_write_9_G5B2I1
+ n8 n24 VSS VDD_1V8 latch_tri_rst0_Hard_67
Xfull_range_level_shift_31__rf17_Zero_tristate_full_range VSS n96 Dout1[31] VSS
+ VDD_1V8 tristategate_279
Xfull_range_level_shift_30__rf17_Zero_tristate_full_range VSS n96 Dout1[30] VSS
+ VDD_1V8 tristategate_280
Xfull_range_level_shift_29__rf17_Zero_tristate_full_range VSS n96 Dout1[29] VSS
+ VDD_1V8 tristategate_281
Xfull_range_level_shift_28__rf17_Zero_tristate_full_range VSS n96 Dout1[28] VSS
+ VDD_1V8 tristategate_282
Xfull_range_level_shift_27__rf17_Zero_tristate_full_range VSS n96 Dout1[27] VSS
+ VDD_1V8 tristategate_283
Xfull_range_level_shift_26__rf17_Zero_tristate_full_range VSS n96 Dout1[26] VSS
+ VDD_1V8 tristategate_284
Xfull_range_level_shift_25__rf17_Zero_tristate_full_range VSS n96 Dout1[25] VSS
+ VDD_1V8 tristategate_285
Xfull_range_level_shift_24__rf17_Zero_tristate_full_range VSS n96 Dout1[24] VSS
+ VDD_1V8 tristategate_286
Xfull_range_level_shift_23__rf17_Zero_tristate_full_range VSS n96 Dout1[23] VSS
+ VDD_1V8 tristategate_287
Xfull_range_level_shift_22__rf17_Zero_tristate_full_range VSS n96 Dout1[22] VSS
+ VDD_1V8 tristategate_288
Xfull_range_level_shift_21__rf17_Zero_tristate_full_range VSS n96 Dout1[21] VSS
+ VDD_1V8 tristategate_289
Xfull_range_level_shift_20__rf17_Zero_tristate_full_range VSS n96 Dout1[20] VSS
+ VDD_1V8 tristategate_290
Xfull_range_level_shift_19__rf17_Zero_tristate_full_range VSS n96 Dout1[19] VSS
+ VDD_1V8 tristategate_291
Xfull_range_level_shift_18__rf17_Zero_tristate_full_range VSS n96 Dout1[18] VSS
+ VDD_1V8 tristategate_292
Xfull_range_level_shift_17__rf17_Zero_tristate_full_range VSS n96 Dout1[17] VSS
+ VDD_1V8 tristategate_293
Xfull_range_level_shift_16__rf17_Zero_tristate_full_range VSS n96 Dout1[16] VSS
+ VDD_1V8 tristategate_294
Xfull_range_level_shift_15__rf17_Zero_tristate_full_range VSS n96 Dout1[15] VSS
+ VDD_1V8 tristategate_295
Xfull_range_level_shift_14__rf17_Zero_tristate_full_range VSS n96 Dout1[14] VSS
+ VDD_1V8 tristategate_296
Xfull_range_level_shift_13__rf17_Zero_tristate_full_range VSS n96 Dout1[13] VSS
+ VDD_1V8 tristategate_297
Xfull_range_level_shift_12__rf17_Zero_tristate_full_range VSS n96 Dout1[12] VSS
+ VDD_1V8 tristategate_298
Xfull_range_level_shift_11__rf17_Zero_tristate_full_range VSS n96 Dout1[11] VSS
+ VDD_1V8 tristategate_299
Xfull_range_level_shift_10__rf17_Zero_tristate_full_range VSS n96 Dout1[10] VSS
+ VDD_1V8 tristategate_300
Xfull_range_level_shift_9__rf17_Zero_tristate_full_range VSS n96 Dout1[9] VSS VDD_1V8 tristategate_301
Xfull_range_level_shift_8__rf17_Zero_tristate_full_range VSS n96 Dout1[8] VSS VDD_1V8 tristategate_302
Xfull_range_level_shift_7__rf16_latch_full_range Din[7] Dout1[7] n96 CTS_CLK_CTO_delay81
+ n8 full_range_level_shifter[7] VSS VDD_1V8 latch_tri_rst0_Hard_68
Xfull_range_level_shift_6__rf16_latch_full_range Din[6] Dout1[6] n96 CTS_CLK_CTO_delay81
+ n8 full_range_level_shifter[6] VSS VDD_1V8 latch_tri_rst0_Hard_69
Xfull_range_level_shift_5__rf16_latch_full_range Din[5] Dout1[5] n96 CTS_CLK_CTO_delay81
+ n8 full_range_level_shifter[5] VSS VDD_1V8 latch_tri_rst0_Hard_70
Xfull_range_level_shift_4__rf16_latch_full_range Din[4] Dout1[4] n96 CTS_CLK_CTO_delay81
+ n8 full_range_level_shifter[4] VSS VDD_1V8 latch_tri_rst0_Hard_71
Xfull_range_level_shift_3__rf16_latch_full_range Din[3] Dout1[3] n96 CTS_CLK_CTO_delay81
+ n8 full_range_level_shifter[3] VSS VDD_1V8 latch_tri_rst0_Hard_72
Xfull_range_level_shift_2__rf16_latch_full_range Din[2] Dout1[2] n96 CTS_CLK_CTO_delay81
+ n8 full_range_level_shifter[2] VSS VDD_1V8 latch_tri_rst0_Hard_73
Xfull_range_level_shift_1__rf16_latch_full_range Din[1] Dout1[1] n96 CTS_CLK_CTO_delay81
+ n8 full_range_level_shifter[1] VSS VDD_1V8 latch_tri_rst0_Hard_74
Xfull_range_level_shift_0__rf16_latch_full_range Din[0] Dout1[0] n96 CTS_CLK_CTO_delay81
+ n8 full_range_level_shifter[0] VSS VDD_1V8 latch_tri_rst0_Hard_75
XValor_timer_31__tristate_timer timer[31] conect_deco_latch1[7] Dout1[31] VSS VDD_1V8 tristategate_303
XValor_timer_30__tristate_timer timer[30] conect_deco_latch1[7] Dout1[30] VSS VDD_1V8 tristategate_304
XValor_timer_29__tristate_timer timer[29] conect_deco_latch1[7] Dout1[29] VSS VDD_1V8 tristategate_305
XValor_timer_28__tristate_timer timer[28] conect_deco_latch1[7] Dout1[28] VSS VDD_1V8 tristategate_306
XValor_timer_27__tristate_timer timer[27] conect_deco_latch1[7] Dout1[27] VSS VDD_1V8 tristategate_307
XValor_timer_26__tristate_timer timer[26] conect_deco_latch1[7] Dout1[26] VSS VDD_1V8 tristategate_308
XValor_timer_25__tristate_timer timer[25] conect_deco_latch1[7] Dout1[25] VSS VDD_1V8 tristategate_309
XValor_timer_24__tristate_timer timer[24] conect_deco_latch1[7] Dout1[24] VSS VDD_1V8 tristategate_310
XValor_timer_23__tristate_timer timer[23] conect_deco_latch1[7] Dout1[23] VSS VDD_1V8 tristategate_311
XValor_timer_22__tristate_timer timer[22] conect_deco_latch1[7] Dout1[22] VSS VDD_1V8 tristategate_312
XValor_timer_21__tristate_timer timer[21] conect_deco_latch1[7] Dout1[21] VSS VDD_1V8 tristategate_313
XValor_timer_20__tristate_timer timer[20] conect_deco_latch1[7] Dout1[20] VSS VDD_1V8 tristategate_314
XValor_timer_19__tristate_timer timer[19] conect_deco_latch1[7] Dout1[19] VSS VDD_1V8 tristategate_315
XValor_timer_18__tristate_timer timer[18] conect_deco_latch1[7] Dout1[18] VSS VDD_1V8 tristategate_316
XValor_timer_17__tristate_timer timer[17] conect_deco_latch1[7] Dout1[17] VSS VDD_1V8 tristategate_317
XValor_timer_16__tristate_timer timer[16] conect_deco_latch1[7] Dout1[16] VSS VDD_1V8 tristategate_318
XValor_timer_15__tristate_timer timer[15] conect_deco_latch1[7] Dout1[15] VSS VDD_1V8 tristategate_319
XValor_timer_14__tristate_timer timer[14] conect_deco_latch1[7] Dout1[14] VSS VDD_1V8 tristategate_320
XValor_timer_13__tristate_timer timer[13] conect_deco_latch1[7] Dout1[13] VSS VDD_1V8 tristategate_321
XValor_timer_12__tristate_timer timer[12] conect_deco_latch1[7] Dout1[12] VSS VDD_1V8 tristategate_322
XValor_timer_11__tristate_timer timer[11] conect_deco_latch1[7] Dout1[11] VSS VDD_1V8 tristategate_323
XValor_timer_10__tristate_timer timer[10] conect_deco_latch1[7] Dout1[10] VSS VDD_1V8 tristategate_324
XValor_timer_9__tristate_timer timer[9] conect_deco_latch1[7] Dout1[9] VSS VDD_1V8 tristategate_325
XValor_timer_8__tristate_timer timer[8] conect_deco_latch1[7] Dout1[8] VSS VDD_1V8 tristategate_326
XValor_timer_7__tristate_timer timer[7] conect_deco_latch1[7] Dout1[7] VSS VDD_1V8 tristategate_327
XValor_timer_6__tristate_timer timer[6] conect_deco_latch1[7] Dout1[6] VSS VDD_1V8 tristategate_328
XValor_timer_5__tristate_timer timer[5] conect_deco_latch1[7] Dout1[5] VSS VDD_1V8 tristategate_329
XValor_timer_4__tristate_timer timer[4] conect_deco_latch1[7] Dout1[4] VSS VDD_1V8 tristategate_330
XValor_timer_3__tristate_timer timer[3] conect_deco_latch1[7] Dout1[3] VSS VDD_1V8 tristategate_331
XValor_timer_2__tristate_timer timer[2] conect_deco_latch1[7] Dout1[2] VSS VDD_1V8 tristategate_332
XValor_timer_1__tristate_timer timer[1] conect_deco_latch1[7] Dout1[1] VSS VDD_1V8 tristategate_333
XValor_timer_0__tristate_timer timer[0] conect_deco_latch1[7] Dout1[0] VSS VDD_1V8 tristategate_334
XRegistro_Comparacion_31__latch_Comparacion Din[31] Dout1[31] n101 Sal_and_write_G5B2I1_6_
+ rst comparation[31] VSS VDD_1V8 latch_tri_rst0_Hard_76
XRegistro_Comparacion_30__latch_Comparacion Din[30] Dout1[30] n101 Sal_and_write_G5B2I1_6_
+ rst comparation[30] VSS VDD_1V8 latch_tri_rst0_Hard_77
XRegistro_Comparacion_29__latch_Comparacion Din[29] Dout1[29] n101 Sal_and_write_G5B2I1_6_
+ rst comparation[29] VSS VDD_1V8 latch_tri_rst0_Hard_78
XRegistro_Comparacion_28__latch_Comparacion Din[28] Dout1[28] n101 Sal_and_write_G5B2I1_6_
+ n7 comparation[28] VSS VDD_1V8 latch_tri_rst0_Hard_79
XRegistro_Comparacion_27__latch_Comparacion Din[27] Dout1[27] n101 Sal_and_write_G5B2I1_6_
+ rst comparation[27] VSS VDD_1V8 latch_tri_rst0_Hard_80
XRegistro_Comparacion_26__latch_Comparacion Din[26] Dout1[26] n101 Sal_and_write_G5B2I1_6_
+ rst comparation[26] VSS VDD_1V8 latch_tri_rst0_Hard_81
XRegistro_Comparacion_25__latch_Comparacion Din[25] Dout1[25] n101 Sal_and_write_G5B2I1_6_
+ n7 comparation[25] VSS VDD_1V8 latch_tri_rst0_Hard_82
XRegistro_Comparacion_24__latch_Comparacion Din[24] Dout1[24] n101 Sal_and_write_G5B2I1_6_
+ n7 comparation[24] VSS VDD_1V8 latch_tri_rst0_Hard_83
XRegistro_Comparacion_23__latch_Comparacion Din[23] Dout1[23] n101 Sal_and_write_G5B2I1_6_
+ n7 comparation[23] VSS VDD_1V8 latch_tri_rst0_Hard_84
XRegistro_Comparacion_22__latch_Comparacion Din[22] Dout1[22] n101 Sal_and_write_G5B2I1_6_
+ n22 comparation[22] VSS VDD_1V8 latch_tri_rst0_Hard_85
XRegistro_Comparacion_21__latch_Comparacion Din[21] Dout1[21] n101 Sal_and_write_G5B2I1_6_
+ n22 comparation[21] VSS VDD_1V8 latch_tri_rst0_Hard_86
XRegistro_Comparacion_20__latch_Comparacion Din[20] Dout1[20] n101 Sal_and_write_G5B2I1_6_
+ n4 comparation[20] VSS VDD_1V8 latch_tri_rst0_Hard_87
XRegistro_Comparacion_19__latch_Comparacion Din[19] Dout1[19] n101 Sal_and_write_G5B2I1_6_
+ n4 comparation[19] VSS VDD_1V8 latch_tri_rst0_Hard_88
XRegistro_Comparacion_18__latch_Comparacion Din[18] Dout1[18] n101 Sal_and_write_G5B2I1_6_
+ n4 comparation[18] VSS VDD_1V8 latch_tri_rst0_Hard_89
XRegistro_Comparacion_17__latch_Comparacion Din[17] Dout1[17] n101 Sal_and_write_G5B2I1_6_
+ n4 comparation[17] VSS VDD_1V8 latch_tri_rst0_Hard_90
XRegistro_Comparacion_16__latch_Comparacion Din[16] Dout1[16] n101 Sal_and_write_G5B2I1_6_
+ n4 comparation[16] VSS VDD_1V8 latch_tri_rst0_Hard_91
XRegistro_Comparacion_15__latch_Comparacion Din[15] Dout1[15] n101 Sal_and_write_G5B2I1_6_
+ n4 comparation[15] VSS VDD_1V8 latch_tri_rst0_Hard_92
XRegistro_Comparacion_14__latch_Comparacion Din[14] Dout1[14] n101 Sal_and_write_G5B2I1_6_
+ n4 comparation[14] VSS VDD_1V8 latch_tri_rst0_Hard_93
XRegistro_Comparacion_13__latch_Comparacion Din[13] Dout1[13] n101 Sal_and_write_G5B2I1_6_
+ n22 comparation[13] VSS VDD_1V8 latch_tri_rst0_Hard_94
XRegistro_Comparacion_12__latch_Comparacion Din[12] Dout1[12] n101 Sal_and_write_G5B2I1_6_
+ n22 comparation[12] VSS VDD_1V8 latch_tri_rst0_Hard_95
XRegistro_Comparacion_11__latch_Comparacion Din[11] Dout1[11] n101 Sal_and_write_G5B2I1_6_
+ n22 comparation[11] VSS VDD_1V8 latch_tri_rst0_Hard_96
XRegistro_Comparacion_10__latch_Comparacion Din[10] Dout1[10] n101 Sal_and_write_G5B2I1_6_
+ n22 comparation[10] VSS VDD_1V8 latch_tri_rst0_Hard_97
XRegistro_Comparacion_9__latch_Comparacion Din[9] Dout1[9] n101 Sal_and_write_G5B2I1_6_
+ n22 comparation[9] VSS VDD_1V8 latch_tri_rst0_Hard_98
XRegistro_Comparacion_8__latch_Comparacion Din[8] Dout1[8] n101 Sal_and_write_G5B2I1_6_
+ n22 comparation[8] VSS VDD_1V8 latch_tri_rst0_Hard_99
XRegistro_Comparacion_7__latch_Comparacion Din[7] Dout1[7] n101 Sal_and_write_G5B2I1_6_
+ n22 comparation[7] VSS VDD_1V8 latch_tri_rst0_Hard_100
XRegistro_Comparacion_6__latch_Comparacion Din[6] Dout1[6] n101 Sal_and_write_G5B2I1_6_
+ n22 comparation[6] VSS VDD_1V8 latch_tri_rst0_Hard_101
XRegistro_Comparacion_5__latch_Comparacion Din[5] Dout1[5] n101 Sal_and_write_G5B2I1_6_
+ n9 comparation[5] VSS VDD_1V8 latch_tri_rst0_Hard_102
XRegistro_Comparacion_4__latch_Comparacion Din[4] Dout1[4] n101 Sal_and_write_G5B2I1_6_
+ n9 comparation[4] VSS VDD_1V8 latch_tri_rst0_Hard_103
XRegistro_Comparacion_3__latch_Comparacion Din[3] Dout1[3] n101 Sal_and_write_G5B2I1_6_
+ n22 comparation[3] VSS VDD_1V8 latch_tri_rst0_Hard_104
XRegistro_Comparacion_2__latch_Comparacion Din[2] Dout1[2] n101 Sal_and_write_G5B2I1_6_
+ n9 comparation[2] VSS VDD_1V8 latch_tri_rst0_Hard_105
XRegistro_Comparacion_1__latch_Comparacion Din[1] Dout1[1] n101 Sal_and_write_G5B2I1_6_
+ n9 comparation[1] VSS VDD_1V8 latch_tri_rst0_Hard_106
XRegistro_Comparacion_0__latch_Comparacion Din[0] Dout1[0] n101 Sal_and_write_G5B2I1_6_
+ n9 comparation[0] VSS VDD_1V8 latch_tri_rst0_Hard_107
XRegsitrio_mvtec_31__rf14_latches_mvtec Din[31] Dout1[31] conect_deco_latch1[5]
+ Sal_and_write_G5B2I1_5_ rst VSS VDD_1V8 latch_tri_estado_0
XRegsitrio_mvtec_30__rf14_latches_mvtec Din[30] Dout1[30] conect_deco_latch1[5]
+ Sal_and_write_G5B2I1_5_ n7 VSS VDD_1V8 latch_tri_estado_1
XRegsitrio_mvtec_29__rf14_latches_mvtec Din[29] Dout1[29] conect_deco_latch1[5]
+ Sal_and_write_G5B2I1_5_ rst VSS VDD_1V8 latch_tri_estado_2
XRegsitrio_mvtec_28__rf14_latches_mvtec Din[28] Dout1[28] conect_deco_latch1[5]
+ Sal_and_write_G5B2I1_5_ n7 VSS VDD_1V8 latch_tri_estado_3
XRegsitrio_mvtec_27__rf14_latches_mvtec Din[27] Dout1[27] conect_deco_latch1[5]
+ Sal_and_write_G5B2I1_5_ n7 VSS VDD_1V8 latch_tri_estado_4
XRegsitrio_mvtec_26__rf14_latches_mvtec Din[26] Dout1[26] conect_deco_latch1[5]
+ Sal_and_write_G5B2I1_5_ n7 VSS VDD_1V8 latch_tri_estado_5
XRegsitrio_mvtec_25__rf14_latches_mvtec Din[25] Dout1[25] conect_deco_latch1[5]
+ Sal_and_write_G5B2I1_5_ n7 VSS VDD_1V8 latch_tri_estado_6
XRegsitrio_mvtec_24__rf14_latches_mvtec Din[24] Dout1[24] conect_deco_latch1[5]
+ Sal_and_write_G5B2I1_5_ n7 VSS VDD_1V8 latch_tri_estado_7
XRegsitrio_mvtec_23__rf14_latches_mvtec Din[23] Dout1[23] conect_deco_latch1[5]
+ Sal_and_write_G5B2I1_5_ n7 VSS VDD_1V8 latch_tri_estado_8
XRegsitrio_mvtec_22__rf14_latches_mvtec Din[22] Dout1[22] conect_deco_latch1[5]
+ Sal_and_write_G5B2I1_5_ n22 VSS VDD_1V8 latch_tri_estado_9
XRegsitrio_mvtec_21__rf14_latches_mvtec Din[21] Dout1[21] conect_deco_latch1[5]
+ Sal_and_write_G5B2I1_5_ n22 VSS VDD_1V8 latch_tri_estado_10
XRegsitrio_mvtec_20__rf14_latches_mvtec Din[20] Dout1[20] conect_deco_latch1[5]
+ Sal_and_write_G5B2I1_5_ n7 VSS VDD_1V8 latch_tri_estado_11
XRegsitrio_mvtec_19__rf14_latches_mvtec Din[19] Dout1[19] conect_deco_latch1[5]
+ Sal_and_write_G5B2I1_5_ n7 VSS VDD_1V8 latch_tri_estado_12
XRegsitrio_mvtec_18__rf14_latches_mvtec Din[18] Dout1[18] conect_deco_latch1[5]
+ Sal_and_write_G5B2I1_5_ n7 VSS VDD_1V8 latch_tri_estado_13
XRegsitrio_mvtec_17__rf14_latches_mvtec Din[17] Dout1[17] conect_deco_latch1[5]
+ Sal_and_write_G5B2I1_5_ n22 VSS VDD_1V8 latch_tri_estado_14
XRegsitrio_mvtec_16__rf14_latches_mvtec Din[16] Dout1[16] conect_deco_latch1[5]
+ Sal_and_write_G5B2I1_5_ n4 VSS VDD_1V8 latch_tri_estado_15
XRegsitrio_mvtec_15__rf14_latches_mvtec Din[15] Dout1[15] conect_deco_latch1[5]
+ Sal_and_write_G5B2I1_5_ n4 VSS VDD_1V8 latch_tri_estado_16
XRegsitrio_mvtec_14__rf14_latches_mvtec Din[14] Dout1[14] conect_deco_latch1[5]
+ Sal_and_write_G5B2I1_5_ n22 VSS VDD_1V8 latch_tri_estado_17
XRegsitrio_mvtec_13__rf14_latches_mvtec Din[13] Dout1[13] conect_deco_latch1[5]
+ Sal_and_write_G5B2I1_5_ n22 VSS VDD_1V8 latch_tri_estado_18
XRegsitrio_mvtec_12__rf14_latches_mvtec Din[12] Dout1[12] conect_deco_latch1[5]
+ Sal_and_write_G5B2I1_5_ rst VSS VDD_1V8 latch_tri_estado_19
XRegsitrio_mvtec_11__rf14_latches_mvtec Din[11] Dout1[11] conect_deco_latch1[5]
+ Sal_and_write_G5B2I1_5_ rst VSS VDD_1V8 latch_tri_estado_20
XRegsitrio_mvtec_10__rf14_latches_mvtec Din[10] Dout1[10] conect_deco_latch1[5]
+ Sal_and_write_G5B2I1_5_ n4 VSS VDD_1V8 latch_tri_estado_21
XRegsitrio_mvtec_9__rf14_latches_mvtec Din[9] Dout1[9] conect_deco_latch1[5] Sal_and_write_G5B2I1_5_
+ n22 VSS VDD_1V8 latch_tri_estado_22
XRegsitrio_mvtec_8__rf14_latches_mvtec Din[8] Dout1[8] conect_deco_latch1[5] Sal_and_write_G5B2I1_5_
+ rst VSS VDD_1V8 latch_tri_estado_23
XRegsitrio_mvtec_7__rf14_latches_mvtec Din[7] Dout1[7] conect_deco_latch1[5] Sal_and_write_G5B2I1_5_
+ n9 VSS VDD_1V8 latch_tri_estado_24
XRegsitrio_mvtec_6__rf14_latches_mvtec Din[6] Dout1[6] conect_deco_latch1[5] Sal_and_write_G5B2I1_5_
+ n22 VSS VDD_1V8 latch_tri_estado_25
XRegsitrio_mvtec_5__rf14_latches_mvtec Din[5] Dout1[5] conect_deco_latch1[5] Sal_and_write_G5B2I1_5_
+ n4 VSS VDD_1V8 latch_tri_estado_26
XRegsitrio_mvtec_4__rf14_latches_mvtec Din[4] Dout1[4] conect_deco_latch1[5] Sal_and_write_G5B2I1_5_
+ n9 VSS VDD_1V8 latch_tri_estado_27
XRegsitrio_mvtec_3__rf14_latches_mvtec Din[3] Dout1[3] conect_deco_latch1[5] Sal_and_write_G5B2I1_5_
+ n22 VSS VDD_1V8 latch_tri_estado_28
XRegsitrio_mvtec_2__rf14_latches_mvtec Din[2] Dout1[2] conect_deco_latch1[5] Sal_and_write_G5B2I1_5_
+ rst VSS VDD_1V8 latch_tri_estado_29
XRegsitrio_mvtec_1__rf15_tristategate_mvtec VSS conect_deco_latch1[5] Dout1[1] VSS
+ VDD_1V8 tristategate_335
XRegsitrio_mvtec_0__rf15_tristategate_mvtec VSS conect_deco_latch1[5] Dout1[0] VSS
+ VDD_1V8 tristategate_336
XRegsitrio_GPIO_31__rf13_tristategate_zeroo VSS n97 Dout1[31] VSS VDD_1V8 tristategate_337
XRegsitrio_GPIO_30__rf13_tristategate_zeroo VSS n97 Dout1[30] VSS VDD_1V8 tristategate_338
XRegsitrio_GPIO_29__rf13_tristategate_zeroo VSS n97 Dout1[29] VSS VDD_1V8 tristategate_339
XRegsitrio_GPIO_28__rf13_tristategate_zeroo VSS n97 Dout1[28] VSS VDD_1V8 tristategate_340
XRegsitrio_GPIO_27__rf13_tristategate_zeroo VSS n97 Dout1[27] VSS VDD_1V8 tristategate_341
XRegsitrio_GPIO_26__rf13_tristategate_zeroo VSS n97 Dout1[26] VSS VDD_1V8 tristategate_342
XRegsitrio_GPIO_25__rf13_tristategate_zeroo VSS n97 Dout1[25] VSS VDD_1V8 tristategate_343
XRegsitrio_GPIO_24__rf13_tristategate_zeroo VSS n97 Dout1[24] VSS VDD_1V8 tristategate_344
XRegsitrio_GPIO_23__rf13_tristategate_zeroo VSS n97 Dout1[23] VSS VDD_1V8 tristategate_345
XRegsitrio_GPIO_22__rf13_tristategate_zeroo VSS n97 Dout1[22] VSS VDD_1V8 tristategate_346
XRegsitrio_GPIO_21__rf13_tristategate_zeroo VSS n97 Dout1[21] VSS VDD_1V8 tristategate_347
XRegsitrio_GPIO_20__rf13_tristategate_zeroo VSS n97 Dout1[20] VSS VDD_1V8 tristategate_348
XRegsitrio_GPIO_19__rf13_tristategate_zeroo VSS n97 Dout1[19] VSS VDD_1V8 tristategate_349
XRegsitrio_GPIO_18__rf13_tristategate_zeroo VSS n97 Dout1[18] VSS VDD_1V8 tristategate_350
XRegsitrio_GPIO_17__rf13_tristategate_zeroo VSS n97 Dout1[17] VSS VDD_1V8 tristategate_351
XRegsitrio_GPIO_16__rf13_tristategate_zeroo VSS n97 Dout1[16] VSS VDD_1V8 tristategate_352
XRegsitrio_GPIO_15__rf13_tristategate_zeroo VSS n97 Dout1[15] VSS VDD_1V8 tristategate_353
XRegsitrio_GPIO_14__rf13_tristategate_zeroo VSS n97 Dout1[14] VSS VDD_1V8 tristategate_354
XRegsitrio_GPIO_13__rf13_tristategate_zeroo VSS n97 Dout1[13] VSS VDD_1V8 tristategate_355
XRegsitrio_GPIO_12__rf13_tristategate_zeroo VSS n97 Dout1[12] VSS VDD_1V8 tristategate_356
XRegsitrio_GPIO_11__rf13_tristategate_zeroo VSS n97 Dout1[11] VSS VDD_1V8 tristategate_357
XRegsitrio_GPIO_10__rf13_tristategate_zeroo VSS n97 Dout1[10] VSS VDD_1V8 tristategate_358
XRegsitrio_GPIO_9__rf13_tristategate_zeroo VSS n97 Dout1[9] VSS VDD_1V8 tristategate_359
XRegsitrio_GPIO_8__rf13_tristategate_zeroo VSS n97 Dout1[8] VSS VDD_1V8 tristategate_360
XRegsitrio_GPIO_7__rf11_latch_Mie_IO wire_GPIO_latch_in[7] Dout1[7] n97 CTS_CLK_CTO_delay101
+ n9 Reg_GPIO_out[7] VSS VDD_1V8 latch_tri_rst0_Hard_108
XRegsitrio_GPIO_6__rf11_latch_Mie_IO wire_GPIO_latch_in[6] Dout1[6] n97 CTS_CLK_CTO_delay101
+ n9 Reg_GPIO_out[6] VSS VDD_1V8 latch_tri_rst0_Hard_109
XRegsitrio_GPIO_5__rf11_latch_Mie_IO wire_GPIO_latch_in[5] Dout1[5] n97 CTS_CLK_CTO_delay101
+ n9 Reg_GPIO_out[5] VSS VDD_1V8 latch_tri_rst0_Hard_110
XRegsitrio_GPIO_4__rf11_latch_Mie_IO wire_GPIO_latch_in[4] Dout1[4] n97 CTS_CLK_CTO_delay101
+ n9 Reg_GPIO_out[4] VSS VDD_1V8 latch_tri_rst0_Hard_111
XRegsitrio_GPIO_3__rf11_latch_Mie_IO wire_GPIO_latch_in[3] Dout1[3] n97 CTS_CLK_CTO_delay101
+ n9 Reg_GPIO_out[3] VSS VDD_1V8 latch_tri_rst0_Hard_112
XRegsitrio_GPIO_2__rf11_latch_Mie_IO wire_GPIO_latch_in[2] Dout1[2] n97 CTS_CLK_CTO_delay101
+ n9 Reg_GPIO_out[2] VSS VDD_1V8 latch_tri_rst0_Hard_113
XRegsitrio_GPIO_1__rf11_latch_Mie_IO wire_GPIO_latch_in[1] Dout1[1] n97 CTS_CLK_CTO_delay101
+ n9 Reg_GPIO_out[1] VSS VDD_1V8 latch_tri_rst0_Hard_114
XRegsitrio_GPIO_0__rf11_latch_Mie_IO wire_GPIO_latch_in[0] Dout1[0] n97 CTS_CLK_CTO_delay101
+ n9 Reg_GPIO_out[0] VSS VDD_1V8 latch_tri_rst0_Hard_115
XRegsitrio_interrup2_31__latches_mcause Din[31] Dout1[31] n99 Sal_and_write_G5B2I1_3_
+ n5 VSS VDD_1V8 latch_tri_estado_30
XRegsitrio_interrup2_30__latches_mcause Din[30] Dout1[30] n99 Sal_and_write_G5B2I1_3_
+ n5 VSS VDD_1V8 latch_tri_estado_31
XRegsitrio_interrup2_29__latches_mcause Din[29] Dout1[29] n99 Sal_and_write_G5B2I1_3_
+ n5 VSS VDD_1V8 latch_tri_estado_32
XRegsitrio_interrup2_28__latches_mcause Din[28] Dout1[28] n99 Sal_and_write_G5B2I1_3_
+ n7 VSS VDD_1V8 latch_tri_estado_33
XRegsitrio_interrup2_27__latches_mcause Din[27] Dout1[27] n99 Sal_and_write_G5B2I1_3_
+ n5 VSS VDD_1V8 latch_tri_estado_34
XRegsitrio_interrup2_26__latches_mcause Din[26] Dout1[26] n99 Sal_and_write_G5B2I1_3_
+ n5 VSS VDD_1V8 latch_tri_estado_35
XRegsitrio_interrup2_25__latches_mcause Din[25] Dout1[25] n99 Sal_and_write_G5B2I1_3_
+ n5 VSS VDD_1V8 latch_tri_estado_36
XRegsitrio_interrup2_24__latches_mcause Din[24] Dout1[24] n99 Sal_and_write_G5B2I1_3_
+ n5 VSS VDD_1V8 latch_tri_estado_37
XRegsitrio_interrup2_23__latches_mcause Din[23] Dout1[23] n99 Sal_and_write_G5B2I1_3_
+ n5 VSS VDD_1V8 latch_tri_estado_38
XRegsitrio_interrup2_22__latches_mcause Din[22] Dout1[22] n99 Sal_and_write_G5B2I1_3_
+ n4 VSS VDD_1V8 latch_tri_estado_39
XRegsitrio_interrup2_21__latches_mcause Din[21] Dout1[21] n99 Sal_and_write_G5B2I1_3_
+ n4 VSS VDD_1V8 latch_tri_estado_40
XRegsitrio_interrup2_20__latches_mcause Din[20] Dout1[20] n99 Sal_and_write_G5B2I1_3_
+ n4 VSS VDD_1V8 latch_tri_estado_41
XRegsitrio_interrup2_19__latches_mcause Din[19] Dout1[19] n99 Sal_and_write_G5B2I1_3_
+ n4 VSS VDD_1V8 latch_tri_estado_42
XRegsitrio_interrup2_18__latches_mcause Din[18] Dout1[18] n99 Sal_and_write_G5B2I1_3_
+ n4 VSS VDD_1V8 latch_tri_estado_43
XRegsitrio_interrup2_17__latches_mcause Din[17] Dout1[17] n99 Sal_and_write_G5B2I1_3_
+ n4 VSS VDD_1V8 latch_tri_estado_44
XRegsitrio_interrup2_16__latches_mcause Din[16] Dout1[16] n99 Sal_and_write_G5B2I1_3_
+ n4 VSS VDD_1V8 latch_tri_estado_45
XRegsitrio_interrup2_15__latches_mcause Din[15] Dout1[15] n99 Sal_and_write_G5B2I1_3_
+ n4 VSS VDD_1V8 latch_tri_estado_46
XRegsitrio_interrup2_14__latches_mcause Din[14] Dout1[14] n99 Sal_and_write_G5B2I1_3_
+ n22 VSS VDD_1V8 latch_tri_estado_47
XRegsitrio_interrup2_13__latches_mcause Din[13] Dout1[13] n99 Sal_and_write_G5B2I1_3_
+ n22 VSS VDD_1V8 latch_tri_estado_48
XRegsitrio_interrup2_12__latches_mcause Din[12] Dout1[12] n99 Sal_and_write_G5B2I1_3_
+ n22 VSS VDD_1V8 latch_tri_estado_49
XRegsitrio_interrup2_11__latches_mcause Din[11] Dout1[11] n99 Sal_and_write_G5B2I1_3_
+ n22 VSS VDD_1V8 latch_tri_estado_50
XRegsitrio_interrup2_10__latches_mcause Din[10] Dout1[10] n99 Sal_and_write_G5B2I1_3_
+ n4 VSS VDD_1V8 latch_tri_estado_51
XRegsitrio_interrup2_9__latches_mcause Din[9] Dout1[9] n99 Sal_and_write_G5B2I1_3_
+ n22 VSS VDD_1V8 latch_tri_estado_52
XRegsitrio_interrup2_8__latches_mcause Din[8] Dout1[8] n99 Sal_and_write_G5B2I1_3_
+ n22 VSS VDD_1V8 latch_tri_estado_53
XRegsitrio_interrup2_7__latches_mcause Din[7] Dout1[7] n99 Sal_and_write_G5B2I1_3_
+ n22 VSS VDD_1V8 latch_tri_estado_54
XRegsitrio_interrup2_6__latches_mcause Din[6] Dout1[6] n99 Sal_and_write_G5B2I1_3_
+ n22 VSS VDD_1V8 latch_tri_estado_55
XRegsitrio_interrup2_5__latches_mcause Din[5] Dout1[5] n99 Sal_and_write_G5B2I1_3_
+ n4 VSS VDD_1V8 latch_tri_estado_56
XRegsitrio_interrup2_4__latches_mcause Din[4] Dout1[4] n99 Sal_and_write_G5B2I1_3_
+ n8 VSS VDD_1V8 latch_tri_estado_57
XRegsitrio_interrup2_3__latches_mcause Din[3] Dout1[3] n99 Sal_and_write_G5B2I1_3_
+ n4 VSS VDD_1V8 latch_tri_estado_58
XRegsitrio_interrup2_2__latches_mcause Din[2] Dout1[2] n99 Sal_and_write_G5B2I1_3_
+ n4 VSS VDD_1V8 latch_tri_estado_59
XRegsitrio_interrup2_1__latches_mcause Din[1] Dout1[1] n99 Sal_and_write_G5B2I1_3_
+ n22 VSS VDD_1V8 latch_tri_estado_60
XRegsitrio_interrup2_0__latches_mcause Din[0] Dout1[0] n99 Sal_and_write_G5B2I1_3_
+ n4 VSS VDD_1V8 latch_tri_estado_61
XRegsitrio_interruption1_31__latches_interruption1 Din[31] Dout1[31] n95 Sal_and_write_G5B2I1_2_
+ n7 VSS VDD_1V8 latch_tri_estado_62
XRegsitrio_interruption1_30__latches_interruption1 Din[30] Dout1[30] n95 Sal_and_write_G5B2I1_2_
+ n7 VSS VDD_1V8 latch_tri_estado_63
XRegsitrio_interruption1_29__latches_interruption1 Din[29] Dout1[29] n95 Sal_and_write_G5B2I1_2_
+ n7 VSS VDD_1V8 latch_tri_estado_64
XRegsitrio_interruption1_28__latches_interruption1 Din[28] Dout1[28] n95 Sal_and_write_G5B2I1_2_
+ n7 VSS VDD_1V8 latch_tri_estado_65
XRegsitrio_interruption1_27__latches_interruption1 Din[27] Dout1[27] n95 Sal_and_write_G5B2I1_2_
+ n7 VSS VDD_1V8 latch_tri_estado_66
XRegsitrio_interruption1_26__latches_interruption1 Din[26] Dout1[26] n95 Sal_and_write_G5B2I1_2_
+ n7 VSS VDD_1V8 latch_tri_estado_67
XRegsitrio_interruption1_25__latches_interruption1 Din[25] Dout1[25] n95 Sal_and_write_G5B2I1_2_
+ n7 VSS VDD_1V8 latch_tri_estado_68
XRegsitrio_interruption1_24__latches_interruption1 Din[24] Dout1[24] n95 Sal_and_write_G5B2I1_2_
+ n5 VSS VDD_1V8 latch_tri_estado_69
XRegsitrio_interruption1_23__latches_interruption1 Din[23] Dout1[23] n95 Sal_and_write_G5B2I1_2_
+ n5 VSS VDD_1V8 latch_tri_estado_70
XRegsitrio_interruption1_22__latches_interruption1 Din[22] Dout1[22] n95 Sal_and_write_G5B2I1_2_
+ n5 VSS VDD_1V8 latch_tri_estado_71
XRegsitrio_interruption1_21__latches_interruption1 Din[21] Dout1[21] n95 Sal_and_write_G5B2I1_2_
+ n4 VSS VDD_1V8 latch_tri_estado_72
XRegsitrio_interruption1_20__latches_interruption1 Din[20] Dout1[20] n95 Sal_and_write_G5B2I1_2_
+ n4 VSS VDD_1V8 latch_tri_estado_73
XRegsitrio_interruption1_19__latches_interruption1 Din[19] Dout1[19] n95 Sal_and_write_G5B2I1_2_
+ n4 VSS VDD_1V8 latch_tri_estado_74
XRegsitrio_interruption1_18__latches_interruption1 Din[18] Dout1[18] n95 Sal_and_write_G5B2I1_2_
+ n4 VSS VDD_1V8 latch_tri_estado_75
XRegsitrio_interruption1_17__latches_interruption1 Din[17] Dout1[17] n95 Sal_and_write_G5B2I1_2_
+ n4 VSS VDD_1V8 latch_tri_estado_76
XRegsitrio_interruption1_16__latches_interruption1 Din[16] Dout1[16] n95 Sal_and_write_G5B2I1_2_
+ n4 VSS VDD_1V8 latch_tri_estado_77
XRegsitrio_interruption1_15__latches_interruption1 Din[15] Dout1[15] n95 Sal_and_write_G5B2I1_2_
+ n4 VSS VDD_1V8 latch_tri_estado_78
XRegsitrio_interruption1_14__latches_interruption1 Din[14] Dout1[14] n95 Sal_and_write_G5B2I1_2_
+ n22 VSS VDD_1V8 latch_tri_estado_79
XRegsitrio_interruption1_13__latches_interruption1 Din[13] Dout1[13] n95 Sal_and_write_G5B2I1_2_
+ n22 VSS VDD_1V8 latch_tri_estado_80
XRegsitrio_interruption1_12__latches_interruption1 Din[12] Dout1[12] n95 Sal_and_write_G5B2I1_2_
+ n22 VSS VDD_1V8 latch_tri_estado_81
XRegsitrio_interruption1_11__latches_interruption1 Din[11] Dout1[11] n95 Sal_and_write_G5B2I1_2_
+ n22 VSS VDD_1V8 latch_tri_estado_82
XRegsitrio_interruption1_10__latches_interruption1 Din[10] Dout1[10] n95 Sal_and_write_G5B2I1_2_
+ n4 VSS VDD_1V8 latch_tri_estado_83
XRegsitrio_interruption1_9__latches_interruption1 Din[9] Dout1[9] n95 Sal_and_write_G5B2I1_2_
+ n22 VSS VDD_1V8 latch_tri_estado_84
XRegsitrio_interruption1_8__latches_interruption1 Din[8] Dout1[8] n95 Sal_and_write_G5B2I1_2_
+ n22 VSS VDD_1V8 latch_tri_estado_85
XRegsitrio_interruption1_7__latches_interruption1 Din[7] Dout1[7] n95 Sal_and_write_G5B2I1_2_
+ n3 VSS VDD_1V8 latch_tri_estado_86
XRegsitrio_interruption1_6__latches_interruption1 Din[6] Dout1[6] n95 Sal_and_write_G5B2I1_2_
+ n22 VSS VDD_1V8 latch_tri_estado_87
XRegsitrio_interruption1_5__latches_interruption1 Din[5] Dout1[5] n95 Sal_and_write_G5B2I1_2_
+ n9 VSS VDD_1V8 latch_tri_estado_88
XRegsitrio_interruption1_4__latches_interruption1 Din[4] Dout1[4] n95 Sal_and_write_G5B2I1_2_
+ n9 VSS VDD_1V8 latch_tri_estado_89
XRegsitrio_interruption1_3__latches_interruption1 Din[3] Dout1[3] n95 Sal_and_write_G5B2I1_2_
+ n22 VSS VDD_1V8 latch_tri_estado_90
XRegsitrio_interruption1_2__latches_interruption1 Din[2] Dout1[2] n95 Sal_and_write_G5B2I1_2_
+ n9 VSS VDD_1V8 latch_tri_estado_91
XRegsitrio_interruption1_1__latches_interruption1 Din[1] Dout1[1] n95 Sal_and_write_G5B2I1_2_
+ n22 VSS VDD_1V8 latch_tri_estado_92
XRegsitrio_interruption1_0__latches_interruption1 Din[0] Dout1[0] n95 Sal_and_write_G5B2I1_2_
+ n9 VSS VDD_1V8 latch_tri_estado_93
XRegsitrio_mepc_31__rf8_latches_mepc Din[31] Dout1[31] conect_deco_latch1[1] Sal_and_write_G5B2I1_1_
+ rst VSS VDD_1V8 latch_tri_estado_94
XRegsitrio_mepc_30__rf8_latches_mepc Din[30] Dout1[30] conect_deco_latch1[1] Sal_and_write_G5B2I1_1_
+ rst VSS VDD_1V8 latch_tri_estado_95
XRegsitrio_mepc_29__rf8_latches_mepc Din[29] Dout1[29] conect_deco_latch1[1] Sal_and_write_G5B2I1_1_
+ n7 VSS VDD_1V8 latch_tri_estado_96
XRegsitrio_mepc_28__rf8_latches_mepc Din[28] Dout1[28] conect_deco_latch1[1] Sal_and_write_G5B2I1_1_
+ n7 VSS VDD_1V8 latch_tri_estado_97
XRegsitrio_mepc_27__rf8_latches_mepc Din[27] Dout1[27] conect_deco_latch1[1] Sal_and_write_G5B2I1_1_
+ n7 VSS VDD_1V8 latch_tri_estado_98
XRegsitrio_mepc_26__rf8_latches_mepc Din[26] Dout1[26] conect_deco_latch1[1] Sal_and_write_G5B2I1_1_
+ n7 VSS VDD_1V8 latch_tri_estado_99
XRegsitrio_mepc_25__rf8_latches_mepc Din[25] Dout1[25] conect_deco_latch1[1] Sal_and_write_G5B2I1_1_
+ n7 VSS VDD_1V8 latch_tri_estado_100
XRegsitrio_mepc_24__rf8_latches_mepc Din[24] Dout1[24] conect_deco_latch1[1] Sal_and_write_G5B2I1_1_
+ n7 VSS VDD_1V8 latch_tri_estado_101
XRegsitrio_mepc_23__rf8_latches_mepc Din[23] Dout1[23] conect_deco_latch1[1] Sal_and_write_G5B2I1_1_
+ n7 VSS VDD_1V8 latch_tri_estado_102
XRegsitrio_mepc_22__rf8_latches_mepc Din[22] Dout1[22] conect_deco_latch1[1] Sal_and_write_G5B2I1_1_
+ n7 VSS VDD_1V8 latch_tri_estado_103
XRegsitrio_mepc_21__rf8_latches_mepc Din[21] Dout1[21] conect_deco_latch1[1] Sal_and_write_G5B2I1_1_
+ n22 VSS VDD_1V8 latch_tri_estado_104
XRegsitrio_mepc_20__rf8_latches_mepc Din[20] Dout1[20] conect_deco_latch1[1] Sal_and_write_G5B2I1_1_
+ n7 VSS VDD_1V8 latch_tri_estado_105
XRegsitrio_mepc_19__rf8_latches_mepc Din[19] Dout1[19] conect_deco_latch1[1] Sal_and_write_G5B2I1_1_
+ n7 VSS VDD_1V8 latch_tri_estado_106
XRegsitrio_mepc_18__rf8_latches_mepc Din[18] Dout1[18] conect_deco_latch1[1] Sal_and_write_G5B2I1_1_
+ n7 VSS VDD_1V8 latch_tri_estado_107
XRegsitrio_mepc_17__rf8_latches_mepc Din[17] Dout1[17] conect_deco_latch1[1] Sal_and_write_G5B2I1_1_
+ n4 VSS VDD_1V8 latch_tri_estado_108
XRegsitrio_mepc_16__rf8_latches_mepc Din[16] Dout1[16] conect_deco_latch1[1] Sal_and_write_G5B2I1_1_
+ n4 VSS VDD_1V8 latch_tri_estado_109
XRegsitrio_mepc_15__rf8_latches_mepc Din[15] Dout1[15] conect_deco_latch1[1] Sal_and_write_G5B2I1_1_
+ n4 VSS VDD_1V8 latch_tri_estado_110
XRegsitrio_mepc_14__rf8_latches_mepc Din[14] Dout1[14] conect_deco_latch1[1] Sal_and_write_G5B2I1_1_
+ n22 VSS VDD_1V8 latch_tri_estado_111
XRegsitrio_mepc_13__rf8_latches_mepc Din[13] Dout1[13] conect_deco_latch1[1] Sal_and_write_G5B2I1_1_
+ n3 VSS VDD_1V8 latch_tri_estado_112
XRegsitrio_mepc_12__rf8_latches_mepc Din[12] Dout1[12] conect_deco_latch1[1] Sal_and_write_G5B2I1_1_
+ n22 VSS VDD_1V8 latch_tri_estado_113
XRegsitrio_mepc_11__rf8_latches_mepc Din[11] Dout1[11] conect_deco_latch1[1] Sal_and_write_G5B2I1_1_
+ n22 VSS VDD_1V8 latch_tri_estado_114
XRegsitrio_mepc_10__rf8_latches_mepc Din[10] Dout1[10] conect_deco_latch1[1] Sal_and_write_G5B2I1_1_
+ n4 VSS VDD_1V8 latch_tri_estado_115
XRegsitrio_mepc_9__rf8_latches_mepc Din[9] Dout1[9] conect_deco_latch1[1] Sal_and_write_G5B2I1_1_
+ n22 VSS VDD_1V8 latch_tri_estado_116
XRegsitrio_mepc_8__rf8_latches_mepc Din[8] Dout1[8] conect_deco_latch1[1] Sal_and_write_G5B2I1_1_
+ n9 VSS VDD_1V8 latch_tri_estado_117
XRegsitrio_mepc_7__rf8_latches_mepc Din[7] Dout1[7] conect_deco_latch1[1] Sal_and_write_G5B2I1_1_
+ n9 VSS VDD_1V8 latch_tri_estado_118
XRegsitrio_mepc_6__rf8_latches_mepc Din[6] Dout1[6] conect_deco_latch1[1] Sal_and_write_G5B2I1_1_
+ n22 VSS VDD_1V8 latch_tri_estado_119
XRegsitrio_mepc_5__rf8_latches_mepc Din[5] Dout1[5] conect_deco_latch1[1] Sal_and_write_G5B2I1_1_
+ n9 VSS VDD_1V8 latch_tri_estado_120
XRegsitrio_mepc_4__rf8_latches_mepc Din[4] Dout1[4] conect_deco_latch1[1] Sal_and_write_G5B2I1_1_
+ n9 VSS VDD_1V8 latch_tri_estado_121
XRegsitrio_mepc_3__rf8_latches_mepc Din[3] Dout1[3] conect_deco_latch1[1] Sal_and_write_G5B2I1_1_
+ n22 VSS VDD_1V8 latch_tri_estado_122
XRegsitrio_mepc_2__rf8_latches_mepc Din[2] Dout1[2] conect_deco_latch1[1] Sal_and_write_G5B2I1_1_
+ n9 VSS VDD_1V8 latch_tri_estado_123
XRegsitrio_mepc_1__rf7_tristategate_mepc VSS conect_deco_latch1[1] Dout1[1] VSS
+ VDD_1V8 tristategate_361
XRegsitrio_mepc_0__rf7_tristategate_mepc VSS conect_deco_latch1[1] Dout1[0] VSS
+ VDD_1V8 tristategate_362
XRegistro_Mie_31__rf6_tristategate_Registro_0 VSS n100 Dout1[31] VSS VDD_1V8 tristategate_363
XRegistro_Mie_30__rf6_tristategate_Registro_0 VSS n100 Dout1[30] VSS VDD_1V8 tristategate_364
XRegistro_Mie_29__rf6_tristategate_Registro_0 VSS n100 Dout1[29] VSS VDD_1V8 tristategate_365
XRegistro_Mie_28__rf6_tristategate_Registro_0 VSS n100 Dout1[28] VSS VDD_1V8 tristategate_366
XRegistro_Mie_27__rf6_tristategate_Registro_0 VSS n100 Dout1[27] VSS VDD_1V8 tristategate_367
XRegistro_Mie_26__rf6_tristategate_Registro_0 VSS n100 Dout1[26] VSS VDD_1V8 tristategate_368
XRegistro_Mie_25__rf6_tristategate_Registro_0 VSS n100 Dout1[25] VSS VDD_1V8 tristategate_369
XRegistro_Mie_24__rf6_tristategate_Registro_0 VSS n100 Dout1[24] VSS VDD_1V8 tristategate_370
XRegistro_Mie_23__rf6_tristategate_Registro_0 VSS n100 Dout1[23] VSS VDD_1V8 tristategate_371
XRegistro_Mie_22__rf6_tristategate_Registro_0 VSS n100 Dout1[22] VSS VDD_1V8 tristategate_372
XRegistro_Mie_21__rf6_tristategate_Registro_0 VSS n100 Dout1[21] VSS VDD_1V8 tristategate_373
XRegistro_Mie_20__rf6_tristategate_Registro_0 VSS n100 Dout1[20] VSS VDD_1V8 tristategate_374
XRegistro_Mie_19__rf6_tristategate_Registro_0 VSS n100 Dout1[19] VSS VDD_1V8 tristategate_375
XRegistro_Mie_18__rf6_tristategate_Registro_0 VSS n100 Dout1[18] VSS VDD_1V8 tristategate_376
XRegistro_Mie_17__rf6_tristategate_Registro_0 VSS n100 Dout1[17] VSS VDD_1V8 tristategate_377
XRegistro_Mie_16__rf6_tristategate_Registro_0 VSS n100 Dout1[16] VSS VDD_1V8 tristategate_378
XRegistro_Mie_15__rf12_latch_Mie_IO Din[15] Dout1[15] n100 Sal_and_write_G5B2I1_0_
+ n9 Reg_GPIO_en[7] VSS VDD_1V8 latch_tri_rst0_Hard_116
XRegistro_Mie_14__rf12_latch_Mie_IO Din[14] Dout1[14] n100 Sal_and_write_G5B2I1_0_
+ n9 Reg_GPIO_en[6] VSS VDD_1V8 latch_tri_rst0_Hard_117
XRegistro_Mie_13__rf12_latch_Mie_IO Din[13] Dout1[13] n100 Sal_and_write_G5B2I1_0_
+ n9 Reg_GPIO_en[5] VSS VDD_1V8 latch_tri_rst0_Hard_118
XRegistro_Mie_12__rf12_latch_Mie_IO Din[12] Dout1[12] n100 Sal_and_write_G5B2I1_0_
+ n9 Reg_GPIO_en[4] VSS VDD_1V8 latch_tri_rst0_Hard_119
XRegistro_Mie_11__rf12_latch_Mie_IO Din[11] Dout1[11] n100 Sal_and_write_G5B2I1_0_
+ n9 Reg_GPIO_en[3] VSS VDD_1V8 latch_tri_rst0_Hard_120
XRegistro_Mie_10__rf12_latch_Mie_IO Din[10] Dout1[10] n100 Sal_and_write_G5B2I1_0_
+ n9 Reg_GPIO_en[2] VSS VDD_1V8 latch_tri_rst0_Hard_121
XRegistro_Mie_9__rf12_latch_Mie_IO Din[9] Dout1[9] n100 Sal_and_write_G5B2I1_0_
+ n9 Reg_GPIO_en[1] VSS VDD_1V8 latch_tri_rst0_Hard_122
XRegistro_Mie_8__rf12_latch_Mie_IO Din[8] Dout1[8] n100 Sal_and_write_G5B2I1_0_
+ n9 Reg_GPIO_en[0] VSS VDD_1V8 latch_tri_rst0_Hard_123
XRegistro_Mie_7__rf6_tristategate_Registro_0 VSS n100 Dout1[7] VSS VDD_1V8 tristategate_379
XRegistro_Mie_6__rf6_tristategate_Registro_0 VSS n100 Dout1[6] VSS VDD_1V8 tristategate_380
XRegistro_Mie_5__rf5_tristategate_mip_analogic mip_analogic n100 Dout1[5] VSS VDD_1V8 tristategate_381
XRegistro_Mie_4__rf4_latch_Mie_analogic Din[4] Dout1[4] n100 Sal_and_write_G5B2I1_0_
+ n9 Mie_analogic VSS VDD_1V8 latch_tri_rst0_Hard_124
XRegistro_Mie_3__rf3_tristategate_mip_IO mip_IO n100 Dout1[3] VSS VDD_1V8 tristategate_382
XRegistro_Mie_2__rf2_tristategate_mip_IO mip_time n100 Dout1[2] VSS VDD_1V8 tristategate_383
XRegistro_Mie_1__rf1_latch_Mie_IO Din[1] Dout1[1] n100 Sal_and_write_G5B2I1_0_ n9
+ mie_IO VSS VDD_1V8 latch_tri_rst0_Hard_125
XRegistro_Mie_0__rf0_latch_Mie_Time Din[0] Dout1[0] n100 Sal_and_write_G5B2I1_0_
+ n9 mie_time VSS VDD_1V8 latch_tri_rst0_Hard_126
XDeco_csr addres1[3] addres1[2] addres1[1] addres1[0] conect_deco_latch1[11] n98
+ conect_deco_latch1[9] n96 conect_deco_latch1[7] n101 conect_deco_latch1[5] n97
+ n99 n95 conect_deco_latch1[1] n100 VSS VDD_1V8 Decodificador_width12
Xplace8 VSS VDD_1V8 n22 n3 BUHDLLX0
XINHDLLX2_G4B2I1 VSS VDD_1V8 n1 n1_G4B1I1 INHDLLX6
XU17 VSS VDD_1V8 Sal_and_write[4] n97 n1_G4B2I1 NO2I1HDLLX2
XU11 VSS VDD_1V8 Sal_and_write_11 conect_deco_latch1[11] n1_G4B2I1 NO2I1HDLLX0
XU14 VSS VDD_1V8 Sal_and_write_8 n96 n1_G4B2I1 NO2I1HDLLX1
XINHDLLX3_G5B1I11 VSS VDD_1V8 Sal_and_write_9_G5B1I1 Sal_and_write_9_G5B2I1 INHDLLX6
XINHDLLX2_G5B2I1 Sal_and_write_10_G5B1I1 VSS VDD_1V8 Sal_and_write_10 INHDLLX2
XINHDLLX2_G5B2I14 Sal_and_write_G5B1I1_3_ VSS VDD_1V8 Sal_and_write[3] INHDLLX2
XINHDLLX2_G5B2I12 Sal_and_write_G5B1I1_6_ VSS VDD_1V8 Sal_and_write[6] INHDLLX2
XINHDLLX2_G5B2I15 Sal_and_write_G5B1I1_2_ VSS Sal_and_write[2] VDD_1V8 INHDLLX3
XINHDLLX4_G5B1I13 VSS VDD_1V8 Sal_and_write_G5B1I1_2_ Sal_and_write_G5B2I1_2_ INHDLLX6
XINHDLLX2_G5B2I16 Sal_and_write_G5B1I1_1_ VSS Sal_and_write[1] VDD_1V8 INHDLLX3
XINHDLLX4_G5B1I14 VSS VDD_1V8 Sal_and_write_G5B1I1_1_ Sal_and_write_G5B2I1_1_ INHDLLX6
XINHDLLX2_G5B2I13 Sal_and_write_G5B1I1_5_ VSS Sal_and_write[5] VDD_1V8 INHDLLX3
XINHDLLX4_G5B1I11 VSS VDD_1V8 Sal_and_write_G5B1I1_5_ Sal_and_write_G5B2I1_5_ INHDLLX6
XCTS_CLK_CTO_delay10 CTS_CLK_CTO_delay101 VSS VDD_1V8 Sal_and_write[4] BUHDLLX2
XCTS_CLK_CTO_delay8 CTS_CLK_CTO_delay81 VSS VDD_1V8 Sal_and_write_8 BUHDLLX2
XCTS_CLK_CTO_delay6 CTS_CLK_CTO_delay61 VSS VDD_1V8 Sal_and_write_11 BUHDLLX2
XINHDLLX3_G5B1I1 VSS VDD_1V8 Sal_and_write_10_G5B1I1 Sal_and_write_10_G5B2I1 INHDLLX6
XINHDLLX4_G5B1I12 VSS VDD_1V8 Sal_and_write_G5B1I1_3_ Sal_and_write_G5B2I1_3_ INHDLLX6
XINHDLLX4_G5B1I1 VSS VDD_1V8 Sal_and_write_G5B1I1_6_ Sal_and_write_G5B2I1_6_ INHDLLX6
XU21 VSS VDD_1V8 Sal_and_write[0] n100 n1_G4B2I1 NO2I1HDLLX2
XINHDLLX8_G4B1I1 VDD_1V8 VSS n1_G4B2I1 n1_G4B1I1 INHDLLX12
XINHDLLX2_G5B2I17 Sal_and_write_G5B1I1_0_ VSS VDD_1V8 Sal_and_write[0] INHDLLX2
XINHDLLX2_G5B1I1 Sal_and_write_G5B2I1_0_ VSS VDD_1V8 Sal_and_write_G5B1I1_0_ INHDLLX2
XINHDLLX2_G5B2I11 Sal_and_write_9_G5B1I1 VSS VDD_1V8 Sal_and_write_9 INHDLLX2
XU10 n1 VSS clk VDD_1V8 Write_en NA2I1HDLLX4
XU12 VSS VDD_1V8 Sal_and_write_10 n98 n1_G4B2I1 NO2I1HDLLX4
XU13 VSS VDD_1V8 Sal_and_write_9 conect_deco_latch1[9] n1_G4B2I1 NO2I1HDLLX4
XU15 VSS VDD_1V8 Sal_and_write[6] n101 n1_G4B2I1 NO2I1HDLLX4
XU16 VSS VDD_1V8 Sal_and_write[5] conect_deco_latch1[5] n1_G4B2I1 NO2I1HDLLX4
XU18 VSS VDD_1V8 Sal_and_write[3] n99 n1_G4B2I1 NO2I1HDLLX4
XU19 VSS VDD_1V8 Sal_and_write[2] n95 n1_G4B2I1 NO2I1HDLLX4
XU20 VSS VDD_1V8 Sal_and_write[1] conect_deco_latch1[1] n1_G4B2I1 NO2I1HDLLX4
XU46 VSS n43 n44 VDD_1V8 IS_Val[10] AND2HDLLX0
XU45 VSS n41 n42 VDD_1V8 IS_Val[9] AND2HDLLX0
XU44 VSS n39 n40 VDD_1V8 IS_Val[8] AND2HDLLX0
XU43 VSS n37 n38 VDD_1V8 IS_Val[7] AND2HDLLX0
XU42 VSS n35 n36 VDD_1V8 IS_Val[6] AND2HDLLX0
XU41 VSS n33 n34 VDD_1V8 IS_Val[5] AND2HDLLX0
XU40 VSS n31 n32 VDD_1V8 IS_Val[4] AND2HDLLX0
XU39 VSS n29 n30 VDD_1V8 IS_Val[3] AND2HDLLX0
XU38 VSS n27 n28 VDD_1V8 IS_Val[2] AND2HDLLX0
XU37 VSS n25 n26 VDD_1V8 IS_Val[1] AND2HDLLX0
XU36 VSS n23 n24 VDD_1V8 IS_Val[0] AND2HDLLX0
XU75 VSS wire_GPIO_latch_in[0] VDD_1V8 Reg_GPIO_en[0] Din[0] Reg_GPIO_int[0] MU2HDLLX0
XU74 VSS wire_GPIO_latch_in[1] VDD_1V8 Reg_GPIO_en[1] Din[1] Reg_GPIO_int[1] MU2HDLLX0
XU73 VSS wire_GPIO_latch_in[2] VDD_1V8 Reg_GPIO_en[2] Din[2] Reg_GPIO_int[2] MU2HDLLX0
XU72 VSS wire_GPIO_latch_in[3] VDD_1V8 Reg_GPIO_en[3] Din[3] Reg_GPIO_int[3] MU2HDLLX0
XU71 VSS wire_GPIO_latch_in[4] VDD_1V8 Reg_GPIO_en[4] Din[4] Reg_GPIO_int[4] MU2HDLLX0
XU70 VSS wire_GPIO_latch_in[5] VDD_1V8 Reg_GPIO_en[5] Din[5] Reg_GPIO_int[5] MU2HDLLX0
XU69 VSS wire_GPIO_latch_in[6] VDD_1V8 Reg_GPIO_en[6] Din[6] Reg_GPIO_int[6] MU2HDLLX0
XU68 VSS wire_GPIO_latch_in[7] VDD_1V8 Reg_GPIO_en[7] Din[7] Reg_GPIO_int[7] MU2HDLLX0
XU67 VSS n85 n86 VDD_1V8 IS_Val[31] AND2HDLLX0
XU66 VSS n83 n84 VDD_1V8 IS_Val[30] AND2HDLLX0
XU65 VSS n81 n82 VDD_1V8 IS_Val[29] AND2HDLLX0
XU64 VSS n79 n80 VDD_1V8 IS_Val[28] AND2HDLLX0
XU63 VSS n77 n78 VDD_1V8 IS_Val[27] AND2HDLLX0
XU62 VSS n75 n76 VDD_1V8 IS_Val[26] AND2HDLLX0
XU61 VSS n73 n74 VDD_1V8 IS_Val[25] AND2HDLLX0
XU60 VSS n71 n72 VDD_1V8 IS_Val[24] AND2HDLLX0
XU59 VSS n69 n70 VDD_1V8 IS_Val[23] AND2HDLLX0
XU58 VSS n67 n68 VDD_1V8 IS_Val[22] AND2HDLLX0
XU57 VSS n65 n66 VDD_1V8 IS_Val[21] AND2HDLLX0
XU56 VSS n63 n64 VDD_1V8 IS_Val[20] AND2HDLLX0
XU55 VSS n61 n62 VDD_1V8 IS_Val[19] AND2HDLLX0
XU54 VSS n59 n60 VDD_1V8 IS_Val[18] AND2HDLLX0
XU53 VSS n57 n58 VDD_1V8 IS_Val[17] AND2HDLLX0
XU52 VSS n55 n56 VDD_1V8 IS_Val[16] AND2HDLLX0
XU51 VSS n53 n54 VDD_1V8 IS_Val[15] AND2HDLLX0
XU50 VSS n51 n52 VDD_1V8 IS_Val[14] AND2HDLLX0
XU49 VSS n49 n50 VDD_1V8 IS_Val[13] AND2HDLLX0
XU48 VSS n47 n48 VDD_1V8 IS_Val[12] AND2HDLLX0
XU47 VSS n45 n46 VDD_1V8 IS_Val[11] AND2HDLLX0
Xplace7 n9 VSS VDD_1V8 IN0 INHDLLX0
Xplace6 n8 VSS VDD_1V8 IN0 INHDLLX0
Xplace5 n7 VSS VDD_1V8 IN0 INHDLLX0
Xplace4 n5 VSS VDD_1V8 IN0 INHDLLX0
Xplace3 n4 VSS VDD_1V8 IN0 INHDLLX0
Xplace2 n3 VSS VDD_1V8 IN0 INHDLLX0
.ENDS

.SUBCKT prll_intrfs_cntrl_riscv_0_7_3 clk reset D_in[2] D_in[1] D_in[0] pndng ld_w
+ rst_w rst_r bs_grnt push pop trn_chng wrt IN0 VSS VDD_1V8 IN1 IN2 IN3
Xwrt_buf wrt_pre wrt n6 VSS VDD_1V8 tri_buf_4
Xtrn_chng_buf trn_chng_pre trn_chng n6 VSS VDD_1V8 tri_buf_5
Xrd_st_mchn c_r IN2 clk rst_r push rdi s_ds_r VSS VDD_1V8 prll_rd_st_mchn_2
Xwt_st_mchn c_w IN3 clk rst_w pop wrt_pre s_ds_w bs_rqst ld_w VSS VDD_1V8 prll_wt_st_mchn_2
Xarb_st_mchn clk reset c_a trn_chng_nthng_t_snd VSS VDD_1V8 Arbiter_st_Mchn_2
Xarb_cntr cnt_rbtr[1] cnt_rbtr[0] trn_chng reset VSS VDD_1V8 Counter_arb_mx_cnt3_2
Xbs_grnt_dly n6 clk reset bs_grnt VSS VDD_1V8 dff_async_rst_1193
XU2 VSS n6 cnt_rbtr[0] cnt_rbtr[1] VDD_1V8 NO2HDLLX0
XU10 n2 VSS VDD_1V8 D_in[2] D_in[0] D_in[1] NO3HDLLX0
XU11 n3 D_in[0] D_in[1] VSS VDD_1V8 D_in[2] n2 AN31HDLLX0
XU5 VSS wrt n10 VDD_1V8 n4 NA2HDLLX0
XU12 VSS VDD_1V8 c_r n4 s_ds_r n3 MU2IHDLLX0
XU6 n1 VSS VDD_1V8 s_ds_w INHDLLX0
XU8 VSS VDD_1V8 trn_chng_pre trn_chng_nthng_t_snd IN1 OR2HDLLX0
XU9 VSS c_a bs_rqst n10 VDD_1V8 NO2HDLLX0
Xplace1 n10 VSS VDD_1V8 IN0 INHDLLX0
XU7 VSS VDD_1V8 c_w n1 rdi s_ds_w IN0 pndng AO32HDLLX1
.ENDS

.SUBCKT prll_intrfs_cntrl_riscv_1_7_3 clk reset D_in[2] D_in[1] D_in[0] pndng ld_w
+ rst_w rst_r bs_grnt push pop trn_chng wrt IN0 VSS VDD_1V8 IN1 IN2 IN3 IN4 IN5
Xwrt_buf wrt_pre wrt n5 VSS VDD_1V8 tri_buf_2
Xtrn_chng_buf trn_chng_pre trn_chng n5 VSS VDD_1V8 tri_buf_3
Xrd_st_mchn c_r IN3 clk rst_r push rdi s_ds_r VSS VDD_1V8 prll_rd_st_mchn_1
Xwt_st_mchn c_w IN2 clk rst_w pop wrt_pre s_ds_w bs_rqst ld_w VSS VDD_1V8 prll_wt_st_mchn_1
Xarb_st_mchn clk reset c_a trn_chng_nthng_t_snd VSS VDD_1V8 Arbiter_st_Mchn_1
Xarb_cntr cnt_rbtr[1] cnt_rbtr[0] trn_chng IN4 VSS VDD_1V8 Counter_arb_mx_cnt3_1
Xbs_grnt_dly n5 clk IN5 bs_grnt VSS VDD_1V8 dff_async_rst_1062
XU10 VSS VDD_1V8 c_w n4 IN0 s_ds_w rdi pndng AO32HDLLX0
XU9 n4 VSS VDD_1V8 s_ds_w INHDLLX0
XU8 VSS c_r VDD_1V8 n2 n1 n3 ON21HDLLX0
XU7 VSS VDD_1V8 n1 D_in[2] D_in[1] EO2HDLLX0
XU5 VSS s_ds_r D_in[0] VDD_1V8 n3 NA2HDLLX0
XU4 VSS VDD_1V8 c_a IN0 bs_rqst NO2I1HDLLX0
XU3 VSS VDD_1V8 trn_chng_pre trn_chng_nthng_t_snd IN1 OR2HDLLX0
XU2 VSS VDD_1V8 n5 cnt_rbtr[0] cnt_rbtr[1] NO2I1HDLLX0
XU6 VSS IN0 s_ds_r VDD_1V8 n2 wrt NA3I2HDLLX0
.ENDS

.SUBCKT prll_intrfs_cntrl_riscv_2_7_3 clk reset D_in[2] D_in[1] D_in[0] pndng ld_w
+ rst_w rst_r bs_grnt push pop trn_chng wrt IN0 VSS VDD_1V8 IN1 IN2 IN3 IN4 clk_cts_4
Xwrt_buf wrt_pre wrt n5 VSS VDD_1V8 tri_buf_0
Xtrn_chng_buf trn_chng_pre trn_chng n5 VSS VDD_1V8 tri_buf_1
Xrd_st_mchn c_r IN3 clk_cts_4 rst_r push rdi s_ds_r VSS VDD_1V8 IN4 prll_rd_st_mchn_0
Xwt_st_mchn c_w reset clk rst_w pop wrt_pre s_ds_w bs_rqst ld_w VSS VDD_1V8 prll_wt_st_mchn_0
Xarb_st_mchn clk reset c_a trn_chng_nthng_t_snd VSS VDD_1V8 Arbiter_st_Mchn_0
Xarb_cntr cnt_rbtr[1] cnt_rbtr[0] trn_chng reset VSS VDD_1V8 Counter_arb_mx_cnt3_0
Xbs_grnt_dly n5 clk reset bs_grnt VSS VDD_1V8 dff_async_rst_931
XU10 VSS VDD_1V8 c_w n4 IN2 s_ds_w rdi pndng AO32HDLLX0
XU9 n4 VSS VDD_1V8 s_ds_w INHDLLX0
XU8 VSS c_r VDD_1V8 n2 n1 n3 ON21HDLLX0
XU7 VSS VDD_1V8 n1 D_in[2] D_in[0] EO2HDLLX0
XU5 VSS s_ds_r D_in[1] VDD_1V8 n3 NA2HDLLX0
XU4 VSS VDD_1V8 c_a IN2 bs_rqst NO2I1HDLLX1
XU3 VSS VDD_1V8 trn_chng_pre trn_chng_nthng_t_snd IN1 OR2HDLLX0
XU2 VSS VDD_1V8 n5 cnt_rbtr[1] cnt_rbtr[0] NO2I1HDLLX0
XU6 VSS IN0 s_ds_r VDD_1V8 n2 wrt NA3I2HDLLX0
.ENDS

.SUBCKT fifo_to_uart_reg_pos_array8_data_fifo64_byte_out8 sys_clk pop_T sys_rst_l
+ Din[63] Din[62] Din[61] Din[60] Din[59] Din[58] Din[57] Din[56] Din[55] Din[54]
+ Din[53] Din[52] Din[51] Din[50] Din[49] Din[48] Din[47] Din[46] Din[45] Din[44]
+ Din[43] Din[42] Din[41] Din[40] Din[39] Din[38] Din[37] Din[36] Din[35] Din[34]
+ Din[33] Din[32] Din[31] Din[30] Din[29] Din[28] Din[27] Din[26] Din[25] Din[24]
+ Din[23] Din[22] Din[21] Din[20] Din[19] Din[18] Din[17] Din[16] Din[15] Din[14]
+ Din[13] Din[12] Din[11] Din[10] Din[9] Din[8] Din[7] Din[6] Din[5] Din[4] Din[3]
+ Din[2] Din[1] Din[0] Dout[63] Dout[62] Dout[61] Dout[60] Dout[59] Dout[58] Dout[57]
+ Dout[56] Dout[55] Dout[54] Dout[53] Dout[52] Dout[51] Dout[50] Dout[49] Dout[48]
+ Dout[47] Dout[46] Dout[45] Dout[44] Dout[43] Dout[42] Dout[41] Dout[40] Dout[39]
+ Dout[38] Dout[37] Dout[36] Dout[35] Dout[34] Dout[33] Dout[32] Dout[31] Dout[30]
+ Dout[29] Dout[28] Dout[27] Dout[26] Dout[25] Dout[24] Dout[23] Dout[22] Dout[21]
+ Dout[20] Dout[19] Dout[18] Dout[17] Dout[16] Dout[15] Dout[14] Dout[13] Dout[12]
+ Dout[11] Dout[10] Dout[9] Dout[8] Dout[7] Dout[6] Dout[5] Dout[4] Dout[3] Dout[2]
+ Dout[1] Dout[0] VSS VDD_1V8 IN0 IN1 IN2 IN3 IN4 IN5 IN6 IN7 IN8 IN9 IN10 IN11
+ IN12
Xftu_reg_7__prll_d_reg pop_T sys_rst_l Din[63] Din[62] Din[61] Din[60] Din[59] Din[58]
+ Din[57] Din[56] Dout[63] Dout[62] Dout[61] Dout[60] Dout[59] Dout[58] Dout[57]
+ Dout[56] VSS VDD_1V8 n15 n15 n15 IN4 IN11 prll_d_rega_bits8_0
Xftu_reg_6__prll_d_reg pop_T sys_rst_l Din[55] Din[54] Din[53] Din[52] Din[51] Din[50]
+ Din[49] Din[48] Dout[55] Dout[54] Dout[53] Dout[52] Dout[51] Dout[50] Dout[49]
+ Dout[48] VSS VDD_1V8 prll_d_rega_bits8_1
Xftu_reg_5__prll_d_reg pop_T sys_rst_l Din[47] Din[46] Din[45] Din[44] Din[43] Din[42]
+ Din[41] Din[40] Dout[47] Dout[46] Dout[45] Dout[44] Dout[43] Dout[42] Dout[41]
+ Dout[40] VSS VDD_1V8 prll_d_rega_bits8_2
Xftu_reg_4__prll_d_reg pop_T sys_rst_l Din[39] Din[38] Din[37] Din[36] Din[35] Din[34]
+ Din[33] Din[32] Dout[39] Dout[38] Dout[37] Dout[36] Dout[35] Dout[34] Dout[33]
+ Dout[32] VSS VDD_1V8 n15 prll_d_rega_bits8_3
Xftu_reg_3__prll_d_reg n15 IN1 Din[31] Din[30] Din[29] Din[28] Din[27] Din[26] Din[25]
+ Din[24] Dout[31] Dout[30] Dout[29] Dout[28] Dout[27] Dout[26] Dout[25] Dout[24]
+ VSS VDD_1V8 prll_d_rega_bits8_4
Xftu_reg_2__prll_d_reg n15 IN3 Din[23] Din[22] Din[21] Din[20] Din[19] Din[18] Din[17]
+ Din[16] Dout[23] Dout[22] Dout[21] Dout[20] Dout[19] Dout[18] Dout[17] Dout[16]
+ VSS VDD_1V8 prll_d_rega_bits8_5
Xftu_reg_1__prll_d_reg n15 IN2 Din[15] Din[14] Din[13] Din[12] Din[11] Din[10] Din[9]
+ Din[8] Dout[15] Dout[14] Dout[13] Dout[12] Dout[11] Dout[10] Dout[9] Dout[8] VSS
+ VDD_1V8 prll_d_rega_bits8_6
Xftu_reg_0__prll_d_reg n15 sys_rst_l Din[7] Din[6] Din[5] Din[4] Din[3] Din[2] Din[1]
+ Din[0] Dout[7] Dout[6] Dout[5] Dout[4] Dout[3] Dout[2] Dout[1] Dout[0] VSS VDD_1V8
+ IN5 IN6 IN7 IN8 IN9 IN10 IN12 prll_d_rega_bits8_7
Xplace1 VSS VDD_1V8 n15 IN0 BUHDLLX0
.ENDS

.SUBCKT uart_to_fifo_reg_pos_array8_data_fifo64_byte_out8 enable[7] enable[6] enable[5]
+ enable[4] enable[3] enable[2] enable[1] enable[0] sys_rst_l sys_clk Din[7] Din[6]
+ Din[5] Din[4] Din[3] Din[2] Din[1] Din[0] Dout[63] Dout[62] Dout[61] Dout[60]
+ Dout[59] Dout[58] Dout[57] Dout[56] Dout[55] Dout[54] Dout[53] Dout[52] Dout[51]
+ Dout[50] Dout[49] Dout[48] Dout[47] Dout[46] Dout[45] Dout[44] Dout[43] Dout[42]
+ Dout[41] Dout[40] Dout[39] Dout[38] Dout[37] Dout[36] Dout[35] Dout[34] Dout[33]
+ Dout[32] Dout[31] Dout[30] Dout[29] Dout[28] Dout[27] Dout[26] Dout[25] Dout[24]
+ Dout[23] Dout[22] Dout[21] Dout[20] Dout[19] Dout[18] Dout[17] Dout[16] Dout[15]
+ Dout[14] Dout[13] Dout[12] Dout[11] Dout[10] Dout[9] Dout[8] Dout[7] Dout[6] Dout[5]
+ Dout[4] Dout[3] Dout[2] Dout[1] Dout[0] VSS VDD_1V8
Xutf_reg_7__prll_d_reg sys_clk n9 enable[7] Din[7] Din[6] Din[5] Din[4] Din[3] Din[2]
+ Din[1] Din[0] Dout[63] Dout[62] Dout[61] Dout[60] Dout[59] Dout[58] Dout[57] Dout[56]
+ VSS VDD_1V8 n8 n8 n8 n8 n8 n8 n8 prll_d_reg_ena_bits8_0
Xutf_reg_6__prll_d_reg sys_clk n8 enable[6] Din[7] Din[6] Din[5] Din[4] Din[3] Din[2]
+ Din[1] Din[0] Dout[55] Dout[54] Dout[53] Dout[52] Dout[51] Dout[50] Dout[49] Dout[48]
+ VSS VDD_1V8 prll_d_reg_ena_bits8_1
Xutf_reg_5__prll_d_reg sys_clk n8 enable[5] Din[7] Din[6] Din[5] Din[4] Din[3] Din[2]
+ Din[1] Din[0] Dout[47] Dout[46] Dout[45] Dout[44] Dout[43] Dout[42] Dout[41] Dout[40]
+ VSS VDD_1V8 prll_d_reg_ena_bits8_2
Xutf_reg_4__prll_d_reg sys_clk n8 enable[4] Din[7] Din[6] Din[5] Din[4] Din[3] Din[2]
+ Din[1] Din[0] Dout[39] Dout[38] Dout[37] Dout[36] Dout[35] Dout[34] Dout[33] Dout[32]
+ VSS VDD_1V8 prll_d_reg_ena_bits8_3
Xutf_reg_3__prll_d_reg sys_clk n9 enable[3] Din[7] Din[6] Din[5] Din[4] Din[3] Din[2]
+ Din[1] Din[0] Dout[31] Dout[30] Dout[29] Dout[28] Dout[27] Dout[26] Dout[25] Dout[24]
+ VSS VDD_1V8 prll_d_reg_ena_bits8_4
Xutf_reg_2__prll_d_reg sys_clk n9 enable[2] Din[7] Din[6] Din[5] Din[4] Din[3] Din[2]
+ Din[1] Din[0] Dout[23] Dout[22] Dout[21] Dout[20] Dout[19] Dout[18] Dout[17] Dout[16]
+ VSS VDD_1V8 prll_d_reg_ena_bits8_5
Xutf_reg_1__prll_d_reg sys_clk n9 enable[1] Din[7] Din[6] Din[5] Din[4] Din[3] Din[2]
+ Din[1] Din[0] Dout[15] Dout[14] Dout[13] Dout[12] Dout[11] Dout[10] Dout[9] Dout[8]
+ VSS VDD_1V8 prll_d_reg_ena_bits8_6
Xutf_reg_0__prll_d_reg sys_clk n9 enable[0] Din[7] Din[6] Din[5] Din[4] Din[3] Din[2]
+ Din[1] Din[0] Dout[7] Dout[6] Dout[5] Dout[4] Dout[3] Dout[2] Dout[1] Dout[0]
+ VSS VDD_1V8 prll_d_reg_ena_bits8_7
Xplace1 n8 VSS VDD_1V8 sys_rst_l INHDLLX0
Xplace2 n9 VSS VDD_1V8 sys_rst_l INHDLLX0
.ENDS

.SUBCKT ALU_2_bits_size32_cntrl_size4 A[31] A[30] A[29] A[28] A[27] A[26] A[25] A[24]
+ A[23] A[22] A[21] A[20] A[19] A[18] A[17] A[16] A[15] A[14] A[13] A[12] A[11]
+ A[10] A[9] A[8] A[7] A[6] A[5] A[4] A[3] A[2] A[1] A[0] B[31] B[30] B[29] B[28]
+ B[27] B[26] B[25] B[24] B[23] B[22] B[21] B[20] B[19] B[18] B[17] B[16] B[15]
+ B[14] B[13] B[12] B[11] B[10] B[9] B[8] B[7] B[6] B[5] B[4] B[3] B[2] B[1] B[0]
+ Alu_Cntrl[3] Alu_Cntrl[2] Alu_Cntrl[1] Alu_Cntrl[0] Cin Zero oVerflow Negative
+ Carry OUT[31] OUT[30] OUT[29] OUT[28] OUT[27] OUT[26] OUT[25] OUT[24] OUT[23]
+ OUT[22] OUT[21] OUT[20] OUT[19] OUT[18] OUT[17] OUT[16] OUT[15] OUT[14] OUT[13]
+ OUT[12] OUT[11] OUT[10] OUT[9] OUT[8] OUT[7] OUT[6] OUT[5] OUT[4] OUT[3] OUT[2]
+ OUT[1] OUT[0] VSS VDD_1V8
Xinst_BS A[31] A[30] A[29] A[28] A[27] A[26] A[25] A[24] A[23] A[22] A[21] A[20]
+ A[19] A[18] A[17] A[16] A[15] A[14] A[13] A[12] A[11] A[10] A[9] A[8] A[7] A[6]
+ A[5] A[4] A[3] A[2] A[1] A[0] VSS VSS VSS VSS VSS VSS VSS VSS VSS VSS VSS VSS
+ VSS VSS VSS VSS VSS VSS VSS VSS VSS VSS VSS VSS VSS VSS VSS n17 n18 n26 n19 B[0]
+ shift_cod[1] shift_cod[0] final_shift[31] final_shift[30] final_shift[29] final_shift[28]
+ final_shift[27] final_shift[26] final_shift[25] final_shift[24] final_shift[23]
+ final_shift[22] final_shift[21] final_shift[20] final_shift[19] final_shift[18]
+ final_shift[17] final_shift[16] final_shift[15] final_shift[14] final_shift[13]
+ final_shift[12] final_shift[11] final_shift[10] final_shift[9] final_shift[8]
+ final_shift[7] final_shift[6] final_shift[5] final_shift[4] final_shift[3] final_shift[2]
+ final_shift[1] final_shift[0] VSS VDD_1V8 B[2] B[1] B[3] B[4] Barrel_Shifter
Xinst_CSK A[31] A[30] A[29] A[28] A[27] A[26] A[25] A[24] A[23] A[22] A[21] A[20]
+ A[19] A[18] A[17] A[16] A[15] A[14] A[13] A[12] A[11] A[10] A[9] A[8] A[7] A[6]
+ A[5] A[4] A[3] A[2] A[1] A[0] complemento_a_2[31] complemento_a_2[30] complemento_a_2[29]
+ complemento_a_2[28] complemento_a_2[27] complemento_a_2[26] complemento_a_2[25]
+ complemento_a_2[24] complemento_a_2[23] complemento_a_2[22] complemento_a_2[21]
+ complemento_a_2[20] complemento_a_2[19] complemento_a_2[18] complemento_a_2[17]
+ complemento_a_2[16] complemento_a_2[15] complemento_a_2[14] complemento_a_2[13]
+ complemento_a_2[12] complemento_a_2[11] complemento_a_2[10] complemento_a_2[9]
+ complemento_a_2[8] complemento_a_2[7] complemento_a_2[6] complemento_a_2[5] complemento_a_2[4]
+ complemento_a_2[3] complemento_a_2[2] complemento_a_2[1] complemento_a_2[0] VSS
+ SYNOPSYS_UNCONNECTED_63 final_suma[31] final_suma[30] final_suma[29] final_suma[28]
+ final_suma[27] final_suma[26] final_suma[25] final_suma[24] final_suma[23] final_suma[22]
+ final_suma[21] final_suma[20] final_suma[19] final_suma[18] final_suma[17] final_suma[16]
+ final_suma[15] final_suma[14] final_suma[13] final_suma[12] final_suma[11] final_suma[10]
+ final_suma[9] final_suma[8] final_suma[7] final_suma[6] final_suma[5] final_suma[4]
+ final_suma[3] final_suma[2] final_suma[1] final_suma[0] VSS VDD_1V8 CSK_sin_mux
Xplace3 VSS VDD_1V8 n1 n246 BUHDLLX0
XU201 VSS VDD_1V8 n111 n109 n108 n107 n106 AN211HDLLX1
XU59 n301 VSS VDD_1V8 B[21] INHDLLX0
XU58 VSS n48 VDD_1V8 n71 n107 n35 ON21HDLLX0
XU57 VSS A[7] n390 VDD_1V8 n71 NA2HDLLX0
XU56 n390 VSS VDD_1V8 B[7] INHDLLX0
XU55 VSS n107 A[6] n398 VDD_1V8 NO2HDLLX0
XU54 VSS VDD_1V8 n35 n34 n33 n112 n32 AN211HDLLX0
XU53 n32 VSS VDD_1V8 n109 INHDLLX0
XU52 VSS n403 A[5] VDD_1V8 n109 NA2HDLLX0
XU51 VSS A[6] n398 VDD_1V8 n112 AND2HDLLX0
XU50 n398 VSS VDD_1V8 B[6] INHDLLX0
XU49 VSS n33 VDD_1V8 n105 n103 n31 ON21HDLLX0
XU48 VSS A[4] n17 VDD_1V8 n105 NA2HDLLX0
XU47 VSS n103 A[4] n17 VDD_1V8 NO2HDLLX0
XU45 VSS n31 VDD_1V8 n97 n30 n99 ON21HDLLX0
XU44 n97 VSS VDD_1V8 n80 INHDLLX0
XU43 VSS n80 n18 A[3] VDD_1V8 NO2HDLLX0
XU42 VSS n30 VDD_1V8 n100 n102 n29 ON21HDLLX0
XU41 VSS A[3] n18 VDD_1V8 n100 NA2HDLLX0
XU39 VSS n102 A[2] n26 VDD_1V8 NO2HDLLX0
XU37 VSS n95 n29 VDD_1V8 B[0] n94 n25 OA31HDLLX0
XU36 VSS n19 A[1] VDD_1V8 n95 NA2HDLLX0
XU35 VSS n94 n19 A[1] VDD_1V8 NO2HDLLX0
XU32 VSS n99 B[2] n24 VDD_1V8 NO2HDLLX0
XU30 n34 VSS VDD_1V8 n106 INHDLLX0
XU29 VSS n106 n403 A[5] VDD_1V8 NO2HDLLX0
XU28 n403 VSS VDD_1V8 B[5] INHDLLX0
XU27 VSS n291 A[23] VDD_1V8 n138 NA2HDLLX0
XU26 VSS n137 n291 A[23] VDD_1V8 NO2HDLLX0
XU25 n291 VSS VDD_1V8 B[23] INHDLLX0
XU24 VSS n296 A[22] VDD_1V8 n131 NA2HDLLX0
XU23 n296 VSS VDD_1V8 B[22] INHDLLX0
XU22 VSS n144 n286 A[24] VDD_1V8 NO2HDLLX0
XU21 n286 VSS VDD_1V8 B[24] INHDLLX0
XU20 n143 VSS VDD_1V8 n70 INHDLLX0
XU19 VSS n70 n281 A[25] VDD_1V8 NO2HDLLX0
XU18 n281 VSS VDD_1V8 B[25] INHDLLX0
XU17 VSS n61 n146 n152 VDD_1V8 NO2HDLLX0
XU16 VSS n152 A[27] n21 VDD_1V8 NO2HDLLX0
XU14 VSS n146 A[26] n276 VDD_1V8 NO2HDLLX0
XU13 n276 VSS VDD_1V8 B[26] INHDLLX0
XU12 VSS n161 A[30] n256 VDD_1V8 NO2HDLLX0
XU11 n256 VSS VDD_1V8 B[30] INHDLLX0
XU9 n81 Alu_Cntrl[2] VSS VDD_1V8 n429 n179 NO3I2HDLLX0
XU8 VSS n81 Alu_Cntrl[0] Alu_Cntrl[1] VDD_1V8 NO2HDLLX0
XU7 N545 VSS VDD_1V8 Alu_Cntrl[2] n179 n180 NO3HDLLX0
XU6 n179 VSS VDD_1V8 Alu_Cntrl[3] INHDLLX0
XU5 VSS n180 n249 n248 VDD_1V8 NO2HDLLX0
XU4 n248 VSS VDD_1V8 Alu_Cntrl[1] INHDLLX0
XU3 n249 VSS VDD_1V8 Alu_Cntrl[0] INHDLLX0
XU153 n178 VSS VDD_1V8 n166 n81 n81 n169 n86 AN32HDLLX0
XU152 n166 VSS VDD_1V8 n165 INHDLLX0
XU151 VSS n251 A[31] VDD_1V8 n165 NA2HDLLX0
XU150 n169 VSS VDD_1V8 n164 INHDLLX0
XU149 VSS n164 n251 A[31] VDD_1V8 NO2HDLLX0
XU148 n251 VSS VDD_1V8 B[31] INHDLLX0
XU147 VSS n86 VDD_1V8 n163 n69 n161 ON21HDLLX0
XU146 VSS A[30] n256 VDD_1V8 n163 NA2HDLLX0
XU145 n69 VSS VDD_1V8 n65 n67 n67 n66 n68 AN32HDLLX0
XU144 n65 VSS VDD_1V8 n150 n63 n63 n148 n64 AN32HDLLX0
XU143 VSS A[27] n21 VDD_1V8 n148 NA2HDLLX0
XU142 VSS VDD_1V8 n63 A[29] n266 A[28] n20 AN22HDLLX0
XU141 VSS VDD_1V8 n152 n146 n152 n149 n62 n64 OA32HDLLX0
XU140 VSS n276 A[26] VDD_1V8 n149 NA2HDLLX0
XU139 n70 VDD_1V8 n141 VSS n145 n62 OA21HDLLX0
XU138 VSS A[25] n281 VDD_1V8 n145 NA2HDLLX0
XU137 VSS A[24] n286 VDD_1V8 n141 NA2HDLLX0
XU136 n66 VSS VDD_1V8 n150 INHDLLX0
XU135 VSS n150 n266 A[28] VDD_1V8 NO2HDLLX0
XU134 n266 VSS VDD_1V8 B[28] INHDLLX0
XU133 n67 VSS VDD_1V8 n151 INHDLLX0
XU132 VSS n151 n20 A[29] VDD_1V8 NO2HDLLX0
XU130 n143 n60 n68 VSS VDD_1V8 n61 n144 NO4I2HDLLX0
XU128 VSS n59 n303 n57 VDD_1V8 n58 n56 AO31HDLLX0
XU127 VSS n56 VDD_1V8 n55 n296 A[22] ON21HDLLX0
XU126 n55 VSS VDD_1V8 n137 INHDLLX0
XU125 n54 VSS VDD_1V8 n305 n77 n57 AO21HDLLX0
XU124 VSS n309 A[20] VDD_1V8 n77 NA2HDLLX0
XU123 n53 VSS VDD_1V8 n310 n317 n54 AO21HDLLX0
XU122 VSS A[19] n315 VDD_1V8 n317 NA2HDLLX0
XU121 n53 VSS VDD_1V8 n324 n318 n318 n51 n52 AN32HDLLX0
XU120 n324 VSS VDD_1V8 n125 INHDLLX0
XU119 VSS n322 A[18] VDD_1V8 n125 NA2HDLLX0
XU118 VSS n51 VDD_1V8 n123 n50 n330 ON21HDLLX0
XU117 VSS A[17] n329 VDD_1V8 n123 NA2HDLLX0
XU116 VSS A[16] n13 VDD_1V8 n50 NA2HDLLX0
XU115 n318 VSS VDD_1V8 n49 INHDLLX0
XU114 n52 VSS VDD_1V8 n325 INHDLLX0
XU113 VSS A[21] n301 VDD_1V8 n303 NA2HDLLX0
XU112 n58 VSS VDD_1V8 n47 n73 n73 n85 n48 AN32HDLLX0
XU111 n121 VSS n341 n46 n45 VDD_1V8 n47 ON211HDLLX0
XU110 VSS A[15] n14 VDD_1V8 n121 NA2HDLLX0
XU109 n45 VSS VDD_1V8 n41 n43 n43 n42 n44 AN32HDLLX0
XU108 VSS n41 VDD_1V8 n92 n362 n355 ON21HDLLX0
XU107 VSS A[13] n352 VDD_1V8 n92 NA2HDLLX0
XU106 VSS A[12] n361 VDD_1V8 n362 NA2HDLLX0
XU105 n361 VSS VDD_1V8 B[12] INHDLLX0
XU104 VSS n355 A[13] n352 VDD_1V8 NO2HDLLX0
XU103 VSS n72 n373 VDD_1V8 n40 n366 n88 n42 n380 ON321HDLLX0
XU102 VSS A[11] n15 VDD_1V8 n88 NA2HDLLX0
XU101 VSS A[10] n371 VDD_1V8 n373 NA2HDLLX0
XU100 n40 VSS VDD_1V8 n39 INHDLLX0
XU99 VSS VDD_1V8 n72 A[9] n385 A[8] n16 AN22HDLLX0
XU98 n385 VSS VDD_1V8 B[8] INHDLLX0
XU97 n44 VSS VDD_1V8 n38 INHDLLX0
XU96 VSS A[14] n346 VDD_1V8 n46 NA2HDLLX0
XU95 n85 VSS VDD_1V8 n38 n37 n393 NO3HDLLX0
XU94 n37 VSS n43 n39 VDD_1V8 n87 NA3HDLLX0
XU93 VSS n39 n366 n375 VDD_1V8 NO2HDLLX0
XU92 VSS n375 A[10] n371 VDD_1V8 NO2HDLLX0
XU91 n371 VSS VDD_1V8 B[10] INHDLLX0
XU90 VSS n366 A[11] n15 VDD_1V8 NO2HDLLX0
XU88 VSS n43 n347 n341 VDD_1V8 NO2HDLLX0
XU87 VSS n341 A[15] n14 VDD_1V8 NO2HDLLX0
XU85 VSS n347 A[14] n346 VDD_1V8 NO2HDLLX0
XU84 n346 VSS VDD_1V8 B[14] INHDLLX0
XU83 n388 VSS n380 B[8] VDD_1V8 n87 AN21HDLLX0
XU82 VSS n380 A[9] n16 VDD_1V8 NO2HDLLX0
XU80 n388 VSS VDD_1V8 A[8] INHDLLX0
XU79 VSS n38 VDD_1V8 n364 n352 A[13] ON21HDLLX0
XU78 n364 VSS A[12] VDD_1V8 B[12] NA2I1HDLLX0
XU77 n352 VSS VDD_1V8 B[13] INHDLLX0
XU76 n393 VSS VDD_1V8 n110 INHDLLX0
XU75 VSS n396 B[7] VDD_1V8 n110 NA2HDLLX0
XU74 n396 VSS VDD_1V8 A[7] INHDLLX0
XU73 n36 n330 n73 VSS VDD_1V8 n127 n122 NO4I2HDLLX0
XU72 VSS n330 A[17] n329 VDD_1V8 NO2HDLLX0
XU71 n329 VSS VDD_1V8 B[17] INHDLLX0
XU70 VSS n122 n13 A[16] VDD_1V8 NO2HDLLX0
XU68 VSS n36 n49 n325 VDD_1V8 NO2HDLLX0
XU67 VSS n325 A[18] n322 VDD_1V8 NO2HDLLX0
XU66 n322 VSS VDD_1V8 B[18] INHDLLX0
XU65 VSS n49 A[19] n315 VDD_1V8 NO2HDLLX0
XU64 n315 VSS VDD_1V8 B[19] INHDLLX0
XU63 VSS n127 n305 n310 VDD_1V8 NO2HDLLX0
XU62 VSS n310 A[20] n309 VDD_1V8 NO2HDLLX0
XU61 n309 VSS VDD_1V8 B[20] INHDLLX0
XU60 VSS n305 A[21] n301 VDD_1V8 NO2HDLLX0
XU255 n192 VSS VDD_1V8 n238 B[7] B[7] n193 n6 AN32HDLLX0
XU254 VSS n193 B[6] n191 VDD_1V8 NO2HDLLX0
XU253 N519 VSS VDD_1V8 n12 n398 n190 n1 ON22HDLLX0
XU252 VSS VDD_1V8 n190 n398 n191 EO2HDLLX0
XU251 VSS n189 n403 VDD_1V8 n191 NA2HDLLX0
XU250 VSS N518 VDD_1V8 n1 n188 n189 B[5] ON31HDLLX0
XU249 n188 VSS VDD_1V8 n238 B[5] B[5] n189 n6 AN32HDLLX0
XU248 VSS n189 B[4] n187 VDD_1V8 NO2HDLLX0
XU247 N517 VSS VDD_1V8 n12 n17 n186 n1 ON22HDLLX0
XU246 VSS VDD_1V8 n186 n17 n187 EO2HDLLX0
XU245 VSS n185 n18 VDD_1V8 n187 NA2HDLLX0
XU244 VSS N516 VDD_1V8 n1 n184 n185 B[3] ON31HDLLX0
XU243 n184 VSS VDD_1V8 n238 B[3] B[3] n185 n6 AN32HDLLX0
XU242 n185 VSS VDD_1V8 B[1] B[0] B[2] NO3HDLLX0
XU241 N515 VSS VDD_1V8 n12 n26 n1 n183 ON22HDLLX0
XU239 VSS VDD_1V8 n183 B[2] n182 EO2HDLLX0
XU238 VSS n182 B[1] B[0] VDD_1V8 NO2HDLLX0
XU237 VSS N514 VDD_1V8 n1 n181 n22 B[1] ON31HDLLX0
XU236 n181 VSS VDD_1V8 n238 B[1] B[1] n22 n6 AN32HDLLX0
XU233 Alu_Cntrl[2] n179 VSS VDD_1V8 Alu_Cntrl[0] n246 Alu_Cntrl[1] NA4HDLLX0
XU230 VSS VDD_1V8 n177 n176 n175 Alu_Cntrl[2] n174 AN211HDLLX0
XU229 n170 VSS n173 n172 n171 VDD_1V8 n174 ON211HDLLX0
XU228 n170 VSS VDD_1V8 n166 n168 n168 n167 n169 AN32HDLLX0
XU227 VSS n168 Alu_Cntrl[1] n249 VDD_1V8 NO2HDLLX0
XU226 n171 VSS VDD_1V8 n164 n250 n250 n167 n165 AN32HDLLX0
XU225 n163 VSS VDD_1V8 n161 n162 n167 AO21HDLLX0
XU224 VSS VDD_1V8 n162 n159 n158 n159 n160 n157 AO32HDLLX0
XU223 n157 VSS VDD_1V8 n153 n155 n155 n154 n156 AN32HDLLX0
XU222 n153 VSS VDD_1V8 n158 INHDLLX0
XU221 n154 VSS VDD_1V8 n152 INHDLLX0
XU220 VSS n155 n151 n150 VDD_1V8 NO2HDLLX0
XU219 n156 VSS VDD_1V8 n146 n148 n148 n147 n149 AN32HDLLX0
XU218 VSS n144 n145 VDD_1V8 n143 n147 NA22HDLLX0
XU217 VSS A[28] n266 VDD_1V8 n158 NA2HDLLX0
XU216 VSS A[29] n20 VDD_1V8 n159 NA2HDLLX0
XU214 VSS VDD_1V8 n140 n139 n138 n137 n136 AN211HDLLX0
XU213 n136 VSS n134 VDD_1V8 n135 n133 n132 n134 AN221HDLLX0
XU212 VSS n138 n131 VDD_1V8 n132 NA2HDLLX0
XU211 n133 VSS VDD_1V8 n130 INHDLLX0
XU210 VSS n134 VDD_1V8 n303 n128 n129 ON21HDLLX0
XU209 n128 VSS VDD_1V8 n127 INHDLLX0
XU208 VSS VDD_1V8 n129 A[20] n318 n126 n309 AN22HDLLX0
XU207 n126 VSS VDD_1V8 n325 n317 n317 n124 n125 AN32HDLLX0
XU206 n123 VSS VDD_1V8 n330 n122 n124 AO21HDLLX0
XU205 VSS VDD_1V8 n135 n347 n121 n341 n120 AN211HDLLX0
XU204 VSS n120 VDD_1V8 n117 n118 n119 ON21HDLLX0
XU203 VSS VDD_1V8 n117 n114 n115 n116 n113 AN22HDLLX0
XU202 VSS n113 VDD_1V8 n110 n111 n112 ON21HDLLX0
XU200 n105 VSS VDD_1V8 n103 n104 n108 AO21HDLLX0
XU199 n102 VDD_1V8 n101 VSS n100 n104 OA21HDLLX0
XU198 VSS n101 VDD_1V8 n97 n98 n99 ON21HDLLX0
XU197 n98 n95 n25 VSS VDD_1V8 B[0] n94 AN31HDLLX0
XU196 VSS n115 VDD_1V8 n93 n364 n354 ON21HDLLX0
XU195 n93 VSS VDD_1V8 n355 INHDLLX0
XU194 n354 VSS VDD_1V8 n92 INHDLLX0
XU193 VSS VDD_1V8 n375 n89 n91 n366 n88 n90 n119 AN321HDLLX0
XU192 n89 VSS VDD_1V8 n87 INHDLLX0
XU191 VSS A[9] n16 VDD_1V8 n90 NA2HDLLX0
XU190 VSS VDD_1V8 n142 A[27] n276 A[26] n21 AN22HDLLX0
XU189 VSS n250 Alu_Cntrl[0] n248 VDD_1V8 NO2HDLLX0
XU188 n172 VSS VDD_1V8 n180 INHDLLX0
XU187 n86 VSS n164 n165 VDD_1V8 n173 AN21HDLLX0
XU185 n300 n295 VSS VDD_1V8 n422 n83 n427 NA4HDLLX0
XU184 n291 VSS n137 A[23] VDD_1V8 n295 AN21HDLLX0
XU183 n296 VSS n139 A[22] VDD_1V8 n300 AN21HDLLX0
XU182 VSS n139 A[22] n296 VDD_1V8 NO2HDLLX0
XU181 VSS VDD_1V8 n422 A[2] n24 B[2] n26 AN22HDLLX0
XU180 n19 VSS n94 A[1] VDD_1V8 n427 AN21HDLLX0
XU179 VSS n438 n84 n81 VDD_1V8 n412 n417 AND4HDLLX0
XU178 n18 VSS n80 A[3] VDD_1V8 n417 AN21HDLLX0
XU177 n17 VSS n103 A[4] VDD_1V8 n412 AN21HDLLX0
XU176 VSS VDD_1V8 n438 A[0] n25 B[0] n22 AN22HDLLX0
XU174 n13 VSS n79 A[16] VDD_1V8 n130 AN21HDLLX0
XU173 n123 n77 VSS VDD_1V8 n303 n79 n78 NA4HDLLX0
XU172 VSS VDD_1V8 n78 A[19] n322 A[18] n315 AN22HDLLX0
XU171 n176 VSS VDD_1V8 n75 n74 n76 NO3HDLLX0
XU170 n402 n260 VSS VDD_1V8 n114 n74 n73 NA4HDLLX0
XU169 n256 VSS n161 A[30] VDD_1V8 n260 AN21HDLLX0
XU168 n398 VSS n107 A[6] VDD_1V8 n402 AN21HDLLX0
XU166 n118 VSS n92 n362 VDD_1V8 n116 NA3HDLLX0
XU165 VSS VDD_1V8 n116 A[15] n346 A[14] n14 AN22HDLLX0
XU164 VSS VDD_1V8 n91 A[11] n371 A[10] n15 AN22HDLLX0
XU163 n290 n407 VSS VDD_1V8 n285 n75 n275 NA4HDLLX0
XU162 n403 VSS n106 A[5] VDD_1V8 n407 AN21HDLLX0
XU161 n286 VSS n144 A[24] VDD_1V8 n290 AN21HDLLX0
XU160 n281 VSS n70 A[25] VDD_1V8 n285 AN21HDLLX0
XU159 n21 VSS n152 A[27] VDD_1V8 n275 AN21HDLLX0
XU158 n255 n280 VSS VDD_1V8 n265 n76 n270 NA4HDLLX0
XU157 n276 VSS n146 A[26] VDD_1V8 n280 AN21HDLLX0
XU156 VSS n255 n164 n166 VDD_1V8 NO2HDLLX0
XU155 n20 VSS n151 A[29] VDD_1V8 n265 AN21HDLLX0
XU154 n266 VSS n150 A[28] VDD_1V8 n270 AN21HDLLX0
XU351 VSS n272 VDD_1V8 n430 n431 n21 ON21HDLLX0
XU350 VSS VDD_1V8 n274 final_shift[27] final_suma[27] n10 n428 AN22HDLLX0
XU349 n268 VSS n270 n437 n269 VDD_1V8 OUT[28] ON211HDLLX0
XU348 VSS VDD_1V8 n268 A[28] n4 B[28] n267 AN22HDLLX0
XU347 VSS n267 VDD_1V8 n430 n431 n266 ON21HDLLX0
XU346 VSS VDD_1V8 n269 final_shift[28] final_suma[28] n10 n428 AN22HDLLX0
XU345 n263 VSS n265 n437 n264 VDD_1V8 OUT[29] ON211HDLLX0
XU344 VSS VDD_1V8 n263 A[29] n4 B[29] n262 AN22HDLLX0
XU343 VSS n262 VDD_1V8 n430 n431 n20 ON21HDLLX0
XU342 VSS VDD_1V8 n264 final_shift[29] final_suma[29] n10 n428 AN22HDLLX0
XU341 n258 VSS n260 n437 n259 VDD_1V8 OUT[30] ON211HDLLX0
XU340 VSS VDD_1V8 n258 A[30] n2 B[30] n257 AN22HDLLX0
XU339 VSS n257 VDD_1V8 n430 n431 n256 ON21HDLLX0
XU338 VSS VDD_1V8 n259 final_shift[30] final_suma[30] n10 n428 AN22HDLLX0
XU337 n253 VSS n255 n437 n254 VDD_1V8 OUT[31] ON211HDLLX0
XU336 VSS VDD_1V8 n253 A[31] n2 B[31] n252 AN22HDLLX0
XU335 VSS n252 VDD_1V8 n430 n431 n251 ON21HDLLX0
XU332 n430 VSS Alu_Cntrl[1] Alu_Cntrl[3] VDD_1V8 Alu_Cntrl[0] NA3HDLLX0
XU331 VSS VDD_1V8 n254 final_shift[31] final_suma[31] n10 n428 AN22HDLLX0
XU329 n249 n248 VSS VDD_1V8 Alu_Cntrl[2] n437 Alu_Cntrl[3] NA4HDLLX0
XU328 N544 VSS VDD_1V8 n12 n251 n1 n247 ON22HDLLX0
XU327 VSS VDD_1V8 n247 B[31] n244 EO2HDLLX0
XU326 VSS n244 B[30] n243 VDD_1V8 NO2HDLLX0
XU325 N543 VSS VDD_1V8 n12 n256 n242 n1 ON22HDLLX0
XU324 VSS VDD_1V8 n242 n256 n243 EO2HDLLX0
XU323 VSS n241 n20 VDD_1V8 n243 NA2HDLLX0
XU322 VSS N542 VDD_1V8 n1 n240 n241 B[29] ON31HDLLX0
XU321 n240 VSS VDD_1V8 n238 B[29] B[29] n241 n6 AN32HDLLX0
XU320 VSS n241 B[28] n237 VDD_1V8 NO2HDLLX0
XU319 N541 VSS VDD_1V8 n12 n266 n236 n1 ON22HDLLX0
XU318 VSS VDD_1V8 n236 n266 n237 EO2HDLLX0
XU317 VSS n235 n21 VDD_1V8 n237 NA2HDLLX0
XU316 VSS N540 VDD_1V8 n1 n234 n235 B[27] ON31HDLLX0
XU315 n234 VSS VDD_1V8 n238 B[27] B[27] n235 n6 AN32HDLLX0
XU314 VSS n235 B[26] n233 VDD_1V8 NO2HDLLX0
XU313 N539 VSS VDD_1V8 n12 n276 n232 n1 ON22HDLLX0
XU312 VSS VDD_1V8 n232 n276 n233 EO2HDLLX0
XU311 VSS n231 n281 VDD_1V8 n233 NA2HDLLX0
XU310 VSS N538 VDD_1V8 n1 n230 n231 B[25] ON31HDLLX0
XU309 n230 VSS VDD_1V8 n238 B[25] B[25] n231 n6 AN32HDLLX0
XU308 VSS n231 B[24] n229 VDD_1V8 NO2HDLLX0
XU307 N537 VSS VDD_1V8 n12 n286 n228 n1 ON22HDLLX0
XU306 VSS VDD_1V8 n228 n286 n229 EO2HDLLX0
XU305 VSS n226 n291 VDD_1V8 n229 NA2HDLLX0
XU304 VSS N536 VDD_1V8 n1 n225 n226 B[23] ON31HDLLX0
XU303 n225 VSS VDD_1V8 n238 B[23] B[23] n226 n6 AN32HDLLX0
XU302 VSS n226 B[22] n223 VDD_1V8 NO2HDLLX0
XU301 N535 VSS VDD_1V8 n12 n296 n222 n1 ON22HDLLX0
XU300 VSS VDD_1V8 n222 n296 n223 EO2HDLLX0
XU299 VSS n221 n301 VDD_1V8 n223 NA2HDLLX0
XU298 VSS N534 VDD_1V8 n1 n220 n221 B[21] ON31HDLLX0
XU297 n220 VSS VDD_1V8 n238 B[21] B[21] n221 n6 AN32HDLLX0
XU296 VSS n221 B[20] n219 VDD_1V8 NO2HDLLX0
XU295 N533 VSS VDD_1V8 n12 n309 n218 n1 ON22HDLLX0
XU294 VSS VDD_1V8 n218 n309 n219 EO2HDLLX0
XU293 VSS n217 n315 VDD_1V8 n219 NA2HDLLX0
XU292 VSS N532 VDD_1V8 n1 n216 n217 B[19] ON31HDLLX0
XU291 n216 VSS VDD_1V8 n238 B[19] B[19] n217 n6 AN32HDLLX0
XU290 VSS n217 B[18] n215 VDD_1V8 NO2HDLLX0
XU289 N531 VSS VDD_1V8 n12 n322 n214 n1 ON22HDLLX0
XU288 VSS VDD_1V8 n214 n322 n215 EO2HDLLX0
XU287 VSS n213 n329 VDD_1V8 n215 NA2HDLLX0
XU286 VSS N530 VDD_1V8 n1 n212 n213 B[17] ON31HDLLX0
XU285 n212 VSS VDD_1V8 n238 B[17] B[17] n213 n6 AN32HDLLX0
XU284 VSS n213 B[16] n211 VDD_1V8 NO2HDLLX0
XU283 N529 VSS VDD_1V8 n12 n13 n210 n1 ON22HDLLX0
XU282 VSS VDD_1V8 n210 n13 n211 EO2HDLLX0
XU281 VSS n209 n14 VDD_1V8 n211 NA2HDLLX0
XU280 VSS N528 VDD_1V8 n1 n208 n209 B[15] ON31HDLLX0
XU279 n208 VSS VDD_1V8 n238 B[15] B[15] n209 n6 AN32HDLLX0
XU278 VSS n209 B[14] n207 VDD_1V8 NO2HDLLX0
XU277 N527 VSS VDD_1V8 n12 n346 n206 n1 ON22HDLLX0
XU276 VSS VDD_1V8 n206 n346 n207 EO2HDLLX0
XU275 VSS n205 n352 VDD_1V8 n207 NA2HDLLX0
XU274 VSS N526 VDD_1V8 n1 n204 n205 B[13] ON31HDLLX0
XU273 n204 VSS VDD_1V8 n238 B[13] B[13] n205 n6 AN32HDLLX0
XU272 VSS n205 B[12] n203 VDD_1V8 NO2HDLLX0
XU271 N525 VSS VDD_1V8 n12 n361 n202 n1 ON22HDLLX0
XU270 VSS VDD_1V8 n202 n361 n203 EO2HDLLX0
XU269 VSS n201 n15 VDD_1V8 n203 NA2HDLLX0
XU268 VSS N524 VDD_1V8 n1 n200 n201 B[11] ON31HDLLX0
XU267 n200 VSS VDD_1V8 n238 B[11] B[11] n201 n6 AN32HDLLX0
XU266 VSS n201 B[10] n199 VDD_1V8 NO2HDLLX0
XU265 N523 VSS VDD_1V8 n12 n371 n198 n1 ON22HDLLX0
XU264 VSS VDD_1V8 n198 n371 n199 EO2HDLLX0
XU263 VSS n197 n16 VDD_1V8 n199 NA2HDLLX0
XU262 VSS N522 VDD_1V8 n1 n196 n197 B[9] ON31HDLLX0
XU261 n196 VSS VDD_1V8 n238 B[9] B[9] n197 n6 AN32HDLLX0
XU260 VSS n197 B[8] n195 VDD_1V8 NO2HDLLX0
XU259 N521 VSS VDD_1V8 n12 n385 n194 n1 ON22HDLLX0
XU258 VSS VDD_1V8 n194 n385 n195 EO2HDLLX0
XU257 VSS n193 n390 VDD_1V8 n195 NA2HDLLX0
XU256 VSS N520 VDD_1V8 n1 n192 n193 B[7] ON31HDLLX0
XU446 n397 VSS B[7] VDD_1V8 n5 n7 n2 n390 AN221HDLLX0
XU445 n386 VSS n389 n388 n387 VDD_1V8 OUT[8] ON211HDLLX0
XU444 n386 VSS VDD_1V8 n2 B[8] B[8] n388 n7 AN32HDLLX0
XU443 VSS VDD_1V8 n387 final_shift[8] final_suma[8] n429 n428 AN22HDLLX0
XU442 n389 VSS B[8] VDD_1V8 n5 n7 n2 n385 AN221HDLLX0
XU441 n381 VSS n384 n383 n382 VDD_1V8 OUT[9] ON211HDLLX0
XU440 VSS VDD_1V8 n381 n380 n2 B[9] n7 AN22HDLLX0
XU439 VSS VDD_1V8 n382 final_shift[9] final_suma[9] n429 n428 AN22HDLLX0
XU438 n383 VSS VDD_1V8 A[9] INHDLLX0
XU437 n384 VSS B[9] VDD_1V8 n5 n7 n2 n16 AN221HDLLX0
XU436 OUT[10] VSS n377 n376 VDD_1V8 n378 NA3HDLLX0
XU435 VSS n376 VDD_1V8 n7 n374 n375 ON21HDLLX0
XU434 n374 VSS VDD_1V8 n373 INHDLLX0
XU433 VSS VDD_1V8 n377 A[10] n2 B[10] n372 AN22HDLLX0
XU432 VSS n372 VDD_1V8 n430 n431 n371 ON21HDLLX0
XU431 VSS VDD_1V8 n378 final_shift[10] final_suma[10] n10 n428 AN22HDLLX0
XU430 n367 VSS n370 n369 n368 VDD_1V8 OUT[11] ON211HDLLX0
XU429 VSS VDD_1V8 n367 n366 n2 B[11] n7 AN22HDLLX0
XU428 VSS VDD_1V8 n368 final_shift[11] final_suma[11] n10 n428 AN22HDLLX0
XU427 n369 VSS VDD_1V8 A[11] INHDLLX0
XU426 n370 VSS B[11] VDD_1V8 n5 n7 n2 n15 AN221HDLLX0
XU425 OUT[12] VSS VDD_1V8 n437 n363 n363 n362 n364 AN32HDLLX0
XU424 VSS n363 VDD_1V8 n360 n430 n361 n359 OA211HDLLX0
XU423 n359 VSS VDD_1V8 n2 A[12] A[12] n5 B[12] AN32HDLLX0
XU422 VSS VDD_1V8 n360 final_shift[12] final_suma[12] n429 n428 AN22HDLLX0
XU421 OUT[13] VSS n357 n356 VDD_1V8 n358 NA3HDLLX0
XU420 VSS n356 VDD_1V8 n7 n354 n355 ON21HDLLX0
XU419 VSS VDD_1V8 n357 A[13] n2 B[13] n353 AN22HDLLX0
XU418 VSS n353 VDD_1V8 n430 n431 n352 ON21HDLLX0
XU417 VSS VDD_1V8 n358 final_shift[13] final_suma[13] n429 n428 AN22HDLLX0
XU416 n348 VSS n351 n350 n349 VDD_1V8 OUT[14] ON211HDLLX0
XU415 VSS VDD_1V8 n348 n347 n2 B[14] n7 AN22HDLLX0
XU414 VSS VDD_1V8 n349 final_shift[14] final_suma[14] n429 n428 AN22HDLLX0
XU413 n350 VSS VDD_1V8 A[14] INHDLLX0
XU412 n351 VSS B[14] VDD_1V8 n5 n7 n2 n346 AN221HDLLX0
XU411 n342 VSS n345 n344 n343 VDD_1V8 OUT[15] ON211HDLLX0
XU410 VSS VDD_1V8 n342 n341 n2 B[15] n7 AN22HDLLX0
XU409 VSS VDD_1V8 n343 final_shift[15] final_suma[15] n429 n428 AN22HDLLX0
XU408 n344 VSS VDD_1V8 A[15] INHDLLX0
XU407 n345 VSS B[15] VDD_1V8 n5 n7 n2 n14 AN221HDLLX0
XU406 n336 VSS n339 n23 n337 VDD_1V8 OUT[16] ON211HDLLX0
XU405 n336 VSS VDD_1V8 n4 B[16] B[16] n23 n7 AN32HDLLX0
XU404 VSS VDD_1V8 n337 final_shift[16] final_suma[16] n429 n428 AN22HDLLX0
XU402 n339 VSS B[16] VDD_1V8 n5 n7 n4 n13 AN221HDLLX0
XU401 n331 VSS n334 n333 n332 VDD_1V8 OUT[17] ON211HDLLX0
XU400 VSS VDD_1V8 n331 n330 n4 B[17] n7 AN22HDLLX0
XU399 VSS VDD_1V8 n332 final_shift[17] final_suma[17] n429 n428 AN22HDLLX0
XU398 n333 VSS VDD_1V8 A[17] INHDLLX0
XU397 n334 VSS B[17] VDD_1V8 n5 n7 n4 n329 AN221HDLLX0
XU396 OUT[18] VSS n327 n326 VDD_1V8 n328 NA3HDLLX0
XU395 VSS n326 VDD_1V8 n7 n324 n325 ON21HDLLX0
XU394 VSS VDD_1V8 n327 A[18] n4 B[18] n323 AN22HDLLX0
XU393 VSS n323 VDD_1V8 n430 n431 n322 ON21HDLLX0
XU392 VSS VDD_1V8 n328 final_shift[18] final_suma[18] n10 n428 AN22HDLLX0
XU391 OUT[19] VSS n320 n319 VDD_1V8 n321 NA3HDLLX0
XU390 VSS n317 n318 VDD_1V8 n7 n319 NA22HDLLX0
XU389 VSS VDD_1V8 n320 A[19] n4 B[19] n316 AN22HDLLX0
XU388 VSS n316 VDD_1V8 n430 n431 n315 ON21HDLLX0
XU387 VSS VDD_1V8 n321 final_shift[19] final_suma[19] n10 n428 AN22HDLLX0
XU386 n311 VSS n314 n313 n312 VDD_1V8 OUT[20] ON211HDLLX0
XU385 VSS VDD_1V8 n311 n310 n4 B[20] n7 AN22HDLLX0
XU384 VSS VDD_1V8 n312 final_shift[20] final_suma[20] n10 n428 AN22HDLLX0
XU383 n313 VSS VDD_1V8 A[20] INHDLLX0
XU382 n314 VSS B[20] VDD_1V8 n5 n7 n4 n309 AN221HDLLX0
XU380 OUT[21] VSS n307 n306 VDD_1V8 n308 NA3HDLLX0
XU379 VSS n306 VDD_1V8 n7 n304 n305 ON21HDLLX0
XU377 n304 VSS VDD_1V8 n303 INHDLLX0
XU376 VSS VDD_1V8 n307 A[21] n4 B[21] n302 AN22HDLLX0
XU375 VSS n302 VDD_1V8 n430 n431 n301 ON21HDLLX0
XU374 VSS VDD_1V8 n308 final_shift[21] final_suma[21] n10 n428 AN22HDLLX0
XU373 n298 VSS n300 n437 n299 VDD_1V8 OUT[22] ON211HDLLX0
XU372 VSS VDD_1V8 n298 A[22] n4 B[22] n297 AN22HDLLX0
XU371 VSS n297 VDD_1V8 n430 n431 n296 ON21HDLLX0
XU370 VSS VDD_1V8 n299 final_shift[22] final_suma[22] n10 n428 AN22HDLLX0
XU369 n293 VSS n295 n437 n294 VDD_1V8 OUT[23] ON211HDLLX0
XU368 VSS VDD_1V8 n293 A[23] n4 B[23] n292 AN22HDLLX0
XU367 VSS n292 VDD_1V8 n430 n431 n291 ON21HDLLX0
XU366 VSS VDD_1V8 n294 final_shift[23] final_suma[23] n10 n428 AN22HDLLX0
XU365 n288 VSS n290 n437 n289 VDD_1V8 OUT[24] ON211HDLLX0
XU364 VSS VDD_1V8 n288 A[24] n4 B[24] n287 AN22HDLLX0
XU363 VSS n287 VDD_1V8 n430 n431 n286 ON21HDLLX0
XU362 VSS VDD_1V8 n289 final_shift[24] final_suma[24] n10 n428 AN22HDLLX0
XU361 n283 VSS n285 n437 n284 VDD_1V8 OUT[25] ON211HDLLX0
XU360 VSS VDD_1V8 n283 A[25] n4 B[25] n282 AN22HDLLX0
XU359 VSS n282 VDD_1V8 n430 n431 n281 ON21HDLLX0
XU358 VSS VDD_1V8 n284 final_shift[25] final_suma[25] n10 n428 AN22HDLLX0
XU357 n278 VSS n280 n437 n279 VDD_1V8 OUT[26] ON211HDLLX0
XU356 VSS VDD_1V8 n278 A[26] n4 B[26] n277 AN22HDLLX0
XU355 VSS n277 VDD_1V8 n430 n431 n276 ON21HDLLX0
XU354 VSS VDD_1V8 n279 final_shift[26] final_suma[26] n10 n428 AN22HDLLX0
XU353 n273 VSS n275 n437 n274 VDD_1V8 OUT[27] ON211HDLLX0
XU352 VSS VDD_1V8 n273 A[27] n4 B[27] n272 AN22HDLLX0
XU231 VSS VDD_1V8 Zero Alu_Cntrl[2] n178 Alu_Cntrl[3] n177 AN211HDLLX1
XU186 n83 VSS n130 n84 VDD_1V8 n85 n175 NO4I3HDLLX0
XU215 n140 VSS n145 n141 VDD_1V8 n142 n160 NO4I3HDLLX0
XU129 VSS n60 VDD_1V8 n138 n131 n137 n59 OA211HDLLX0
XU167 n118 VSS n91 n71 VDD_1V8 n72 n114 NO4I3HDLLX0
XU330 n250 VSS VDD_1V8 N545 Alu_Cntrl[3] n428 AO21HDLLX0
Xshift_cod_reg_0_ shift_cod[0] VSS VDD_1V8 Alu_Cntrl[0] N545 DLHQHDLLX0
Xshift_cod_reg_1_ shift_cod[1] VSS VDD_1V8 Alu_Cntrl[1] N545 DLHQHDLLX0
Xcomplemento_a_2_reg_18_ complemento_a_2[18] VSS VDD_1V8 N531 n11 DLLQHDLLX0
Xcomplemento_a_2_reg_12_ complemento_a_2[12] VSS VDD_1V8 N525 n11 DLLQHDLLX0
Xcomplemento_a_2_reg_29_ complemento_a_2[29] VSS VDD_1V8 N542 n11 DLLQHDLLX0
Xcomplemento_a_2_reg_14_ complemento_a_2[14] VSS VDD_1V8 N527 n11 DLLQHDLLX0
Xcomplemento_a_2_reg_17_ complemento_a_2[17] VSS VDD_1V8 N530 n11 DLLQHDLLX0
Xcomplemento_a_2_reg_13_ complemento_a_2[13] VSS VDD_1V8 N526 n11 DLLQHDLLX0
Xcomplemento_a_2_reg_28_ complemento_a_2[28] VSS VDD_1V8 N541 n11 DLLQHDLLX0
Xcomplemento_a_2_reg_21_ complemento_a_2[21] VSS VDD_1V8 N534 n11 DLLQHDLLX0
Xcomplemento_a_2_reg_26_ complemento_a_2[26] VSS VDD_1V8 N539 n11 DLLQHDLLX0
Xcomplemento_a_2_reg_22_ complemento_a_2[22] VSS VDD_1V8 N535 n11 DLLQHDLLX0
Xcomplemento_a_2_reg_24_ complemento_a_2[24] VSS VDD_1V8 N537 n11 DLLQHDLLX0
Xcomplemento_a_2_reg_2_ complemento_a_2[2] VSS VDD_1V8 N515 n11 DLLQHDLLX0
Xcomplemento_a_2_reg_5_ complemento_a_2[5] VSS VDD_1V8 N518 n11 DLLQHDLLX0
Xcomplemento_a_2_reg_8_ complemento_a_2[8] VSS VDD_1V8 N521 n11 DLLQHDLLX0
Xcomplemento_a_2_reg_20_ complemento_a_2[20] VSS VDD_1V8 N533 n11 DLLQHDLLX0
Xcomplemento_a_2_reg_4_ complemento_a_2[4] VSS VDD_1V8 N517 n11 DLLQHDLLX0
Xcomplemento_a_2_reg_27_ complemento_a_2[27] VSS VDD_1V8 N540 n11 DLLQHDLLX0
Xcomplemento_a_2_reg_10_ complemento_a_2[10] VSS VDD_1V8 N523 n11 DLLQHDLLX0
Xcomplemento_a_2_reg_15_ complemento_a_2[15] VSS VDD_1V8 N528 n11 DLLQHDLLX0
Xcomplemento_a_2_reg_9_ complemento_a_2[9] VSS VDD_1V8 N522 n11 DLLQHDLLX0
Xcomplemento_a_2_reg_19_ complemento_a_2[19] VSS VDD_1V8 N532 n11 DLLQHDLLX0
Xcomplemento_a_2_reg_11_ complemento_a_2[11] VSS VDD_1V8 N524 n11 DLLQHDLLX0
Xcomplemento_a_2_reg_1_ complemento_a_2[1] VSS VDD_1V8 N514 n11 DLLQHDLLX0
Xcomplemento_a_2_reg_6_ complemento_a_2[6] VSS VDD_1V8 N519 n11 DLLQHDLLX0
Xcomplemento_a_2_reg_3_ complemento_a_2[3] VSS VDD_1V8 N516 n11 DLLQHDLLX0
Xcomplemento_a_2_reg_25_ complemento_a_2[25] VSS VDD_1V8 N538 n11 DLLQHDLLX0
Xcomplemento_a_2_reg_23_ complemento_a_2[23] VSS VDD_1V8 N536 n11 DLLQHDLLX0
Xcomplemento_a_2_reg_30_ complemento_a_2[30] VSS VDD_1V8 N543 n11 DLLQHDLLX0
Xcomplemento_a_2_reg_16_ complemento_a_2[16] VSS VDD_1V8 N529 n11 DLLQHDLLX0
Xcomplemento_a_2_reg_7_ complemento_a_2[7] VSS VDD_1V8 N520 n11 DLLQHDLLX0
Xcomplemento_a_2_reg_0_ complemento_a_2[0] VSS VDD_1V8 B[0] n11 DLLQHDLLX0
Xcomplemento_a_2_reg_31_ complemento_a_2[31] VSS VDD_1V8 N544 n11 DLLQHDLLX0
XU334 n431 VSS Alu_Cntrl[2] Alu_Cntrl[3] VDD_1V8 Alu_Cntrl[0] NA3HDLLX0
XU235 VSS n238 n11 n180 VDD_1V8 NO2HDLLX0
XU477 n435 VSS n438 n437 n436 VDD_1V8 OUT[0] ON211HDLLX0
XU476 VSS VDD_1V8 n435 A[0] n2 B[0] n433 AN22HDLLX0
XU475 VSS n433 VDD_1V8 n430 n431 n22 ON21HDLLX0
XU474 VSS VDD_1V8 n436 final_shift[0] final_suma[0] n429 n428 AN22HDLLX0
XU473 n425 VSS n427 n437 n426 VDD_1V8 OUT[1] ON211HDLLX0
XU472 VSS VDD_1V8 n425 A[1] n2 B[1] n424 AN22HDLLX0
XU471 VSS n424 VDD_1V8 n430 n431 n19 ON21HDLLX0
XU470 VSS VDD_1V8 n426 final_shift[1] final_suma[1] n429 n428 AN22HDLLX0
XU469 n420 VSS n422 n437 n421 VDD_1V8 OUT[2] ON211HDLLX0
XU468 VSS VDD_1V8 n420 A[2] n2 B[2] n419 AN22HDLLX0
XU467 VSS n419 VDD_1V8 n430 n431 n26 ON21HDLLX0
XU466 VSS VDD_1V8 n421 final_shift[2] final_suma[2] n429 n428 AN22HDLLX0
XU465 n415 VSS n417 n437 n416 VDD_1V8 OUT[3] ON211HDLLX0
XU464 VSS VDD_1V8 n415 A[3] n2 B[3] n414 AN22HDLLX0
XU463 VSS n414 VDD_1V8 n430 n431 n18 ON21HDLLX0
XU462 VSS VDD_1V8 n416 final_shift[3] final_suma[3] n10 n428 AN22HDLLX0
XU461 n410 VSS n412 n437 n411 VDD_1V8 OUT[4] ON211HDLLX0
XU460 VSS VDD_1V8 n410 A[4] n2 B[4] n409 AN22HDLLX0
XU459 VSS n409 VDD_1V8 n430 n431 n17 ON21HDLLX0
XU458 VSS VDD_1V8 n411 final_shift[4] final_suma[4] n429 n428 AN22HDLLX0
XU457 n405 VSS n407 n437 n406 VDD_1V8 OUT[5] ON211HDLLX0
XU456 VSS VDD_1V8 n405 A[5] n2 B[5] n404 AN22HDLLX0
XU455 VSS n404 VDD_1V8 n430 n431 n403 ON21HDLLX0
XU454 VSS VDD_1V8 n406 final_shift[5] final_suma[5] n429 n428 AN22HDLLX0
XU453 n400 VSS n402 n437 n401 VDD_1V8 OUT[6] ON211HDLLX0
XU452 VSS VDD_1V8 n400 A[6] n2 B[6] n399 AN22HDLLX0
XU451 VSS n399 VDD_1V8 n430 n431 n398 ON21HDLLX0
XU450 VSS VDD_1V8 n401 final_shift[6] final_suma[6] n429 n428 AN22HDLLX0
XU449 n394 VSS n397 n396 n395 VDD_1V8 OUT[7] ON211HDLLX0
XU448 VSS VDD_1V8 n394 n393 n2 B[7] n7 AN22HDLLX0
XU447 VSS VDD_1V8 n395 final_shift[7] final_suma[7] n429 n428 AN22HDLLX0
Xplace15 n13 VSS VDD_1V8 B[16] INHDLLX0
Xplace16 n14 VSS VDD_1V8 B[15] INHDLLX0
Xplace17 n15 VSS VDD_1V8 B[11] INHDLLX0
Xplace18 n16 VSS VDD_1V8 B[9] INHDLLX0
Xplace22 n20 VSS VDD_1V8 B[29] INHDLLX0
Xplace23 n21 VSS VDD_1V8 B[27] INHDLLX0
Xplace24 n22 VSS VDD_1V8 B[0] INHDLLX0
Xplace25 n23 VSS VDD_1V8 A[16] INHDLLX0
Xplace26 n24 VSS VDD_1V8 A[2] INHDLLX0
Xplace27 n25 VSS VDD_1V8 A[0] INHDLLX0
Xplace14 n12 VSS VDD_1V8 n238 INHDLLX0
Xplace8 n6 VSS VDD_1V8 n1 INHDLLX0
Xplace13 n11 VSS VDD_1V8 n10 INHDLLX0
Xplace12 VSS VDD_1V8 n10 n429 BUHDLLX0
Xplace9 n7 VSS VDD_1V8 n437 INHDLLX0
Xplace6 n4 VSS VDD_1V8 n430 INHDLLX0
Xplace7 n5 VSS VDD_1V8 n431 INHDLLX0
Xplace4 n2 VSS VDD_1V8 n430 INHDLLX0
Xplace19 n17 VSS VDD_1V8 B[4] INHDLLX0
Xplace28 n26 VSS VDD_1V8 B[2] INHDLLX0
Xplace20 n18 VSS VDD_1V8 B[3] INHDLLX0
Xplace21 n19 VSS VDD_1V8 B[1] INHDLLX0
.ENDS

.SUBCKT fifo_flops_no_full_depth3_bits65_1 Din[64] Din[63] Din[62] Din[61] Din[60]
+ Din[59] Din[58] Din[57] Din[56] Din[55] Din[54] Din[53] Din[52] Din[51] Din[50]
+ Din[49] Din[48] Din[47] Din[46] Din[45] Din[44] Din[43] Din[42] Din[41] Din[40]
+ Din[39] Din[38] Din[37] Din[36] Din[35] Din[34] Din[33] Din[32] Din[31] Din[30]
+ Din[29] Din[28] Din[27] Din[26] Din[25] Din[24] Din[23] Din[22] Din[21] Din[20]
+ Din[19] Din[18] Din[17] Din[16] Din[15] Din[14] Din[13] Din[12] Din[11] Din[10]
+ Din[9] Din[8] Din[7] Din[6] Din[5] Din[4] Din[3] Din[2] Din[1] Din[0] Dout[64]
+ Dout[63] Dout[62] Dout[61] Dout[60] Dout[59] Dout[58] Dout[57] Dout[56] Dout[55]
+ Dout[54] Dout[53] Dout[52] Dout[51] Dout[50] Dout[49] Dout[48] Dout[47] Dout[46]
+ Dout[45] Dout[44] Dout[43] Dout[42] Dout[41] Dout[40] Dout[39] Dout[38] Dout[37]
+ Dout[36] Dout[35] Dout[34] Dout[33] Dout[32] Dout[31] Dout[30] Dout[29] Dout[28]
+ Dout[27] Dout[26] Dout[25] Dout[24] Dout[23] Dout[22] Dout[21] Dout[20] Dout[19]
+ Dout[18] Dout[17] Dout[16] Dout[15] Dout[14] Dout[13] Dout[12] Dout[11] Dout[10]
+ Dout[9] Dout[8] Dout[7] Dout[6] Dout[5] Dout[4] Dout[3] Dout[2] Dout[1] Dout[0]
+ push pop clk pndng rst VSS VDD_1V8 IN0 IN1 IN2 IN3 IN4 IN5 IN6 IN7 IN8 IN9 IN10
+ IN11 IN12 IN13 IN14 IN15 IN16 IN17 IN18 IN19 IN20 IN21 IN22 IN23 IN24 IN25 IN26
+ IN27 IN28 IN29 IN30 IN31 IN32 IN33 IN34 IN35 IN36 IN37 IN38 IN39 IN40 IN41 IN42
+ IN43 IN44 IN45 IN46 IN47 IN48 IN49 IN50 IN51 IN52 IN53 IN54 IN55 IN56 IN57 IN58
+ IN59 IN60 IN61 IN62 IN63 IN64 IN65 IN66 IN67 IN68 IN69 IN70 IN71 IN72 IN73 IN74
+ IN75 IN76 IN77 IN78 IN79 IN80 IN81 IN82 IN83 IN84 IN85 IN86 IN87 IN88 IN89 IN90
+ IN91 IN92 IN93 IN94 IN95 IN96 IN97 IN98 IN99 IN100 IN101 IN102 IN103 IN104 IN105
+ IN106 IN107 IN108 IN109 IN110 IN111 IN112 IN113 IN114 IN115 IN116 IN117 IN118
+ IN119 IN120 IN121 IN122 IN123 IN124 IN125 IN126 IN127 IN128 IN129 IN130 IN131
+ IN132 IN133 IN134 IN135 IN136 IN137 IN138 IN139 IN140 IN141 IN142 IN143 IN144
+ IN145 IN146 IN147 IN148 IN149 IN150 IN151 IN152 IN153 IN154 IN155 IN156 IN157
+ IN158 IN159 IN160 IN161 IN162 IN163 IN164 IN165 IN166 IN167 IN168 IN169 IN170
+ IN171 IN172 IN173 IN174 IN175 IN176 IN177 IN178 clk_cts_4
Xu_dp__2___dp3__D_reg clk_gen_G4B2I3 rst VSS VSS VSS q[123] q[122] q[121] q[120]
+ q[119] q[118] q[117] q[116] q[115] q[114] q[113] q[112] q[111] q[110] q[109] q[108]
+ q[107] q[106] q[105] q[104] q[103] q[102] q[101] q[100] q[99] q[98] q[97] q[96]
+ q[95] q[94] q[93] q[92] q[91] q[90] q[89] q[88] q[87] q[86] q[85] q[84] q[83]
+ q[82] q[81] q[80] q[79] q[78] q[77] q[76] q[75] q[74] q[73] q[72] q[71] q[70]
+ q[69] q[68] q[67] q[66] q[65] q[64] q[63] q[62] SYNOPSYS_UNCONNECTED_1 SYNOPSYS_UNCONNECTED_2
+ SYNOPSYS_UNCONNECTED_3 q[185] q[184] q[183] q[182] q[181] q[180] q[179] q[178]
+ q[177] q[176] q[175] q[174] q[173] q[172] q[171] q[170] q[169] q[168] q[167] q[166]
+ q[165] q[164] q[163] q[162] q[161] q[160] q[159] q[158] q[157] q[156] q[155] q[154]
+ q[153] q[152] q[151] q[150] q[149] q[148] q[147] q[146] q[145] q[144] q[143] q[142]
+ q[141] q[140] q[139] q[138] q[137] q[136] q[135] q[134] q[133] q[132] q[131] q[130]
+ q[129] q[128] q[127] q[126] q[125] q[124] VSS VDD_1V8 IN1 IN2 IN3 IN4 IN6 IN8
+ IN11 IN14 IN17 IN19 IN21 IN22 IN25 IN27 IN28 IN29 IN37 IN38 IN40 IN41 IN48 IN53
+ IN65 IN66 IN68 IN69 IN72 IN73 IN76 IN77 IN79 IN82 IN94 IN101 IN103 IN104 IN105
+ IN108 IN111 IN114 IN118 IN128 IN132 IN133 IN135 IN136 IN140 IN141 IN142 IN143
+ IN144 IN146 IN149 IN155 IN162 IN166 IN170 IN171 IN172 IN173 IN178 clk_gen_G4B2I2
+ clk_gen_G4B2I1 prll_d_reg_bits65_11
Xu_dp__1___dp3__D_reg clk_gen_G4B2I3 rst VSS VSS VSS q[61] q[60] q[59] q[58] q[57]
+ q[56] q[55] q[54] q[53] q[52] q[51] q[50] q[49] q[48] q[47] q[46] q[45] q[44]
+ q[43] q[42] q[41] q[40] q[39] q[38] q[37] q[36] q[35] q[34] q[33] q[32] q[31]
+ q[30] q[29] q[28] q[27] q[26] q[25] q[24] q[23] q[22] q[21] q[20] q[19] q[18]
+ q[17] q[16] q[15] q[14] q[13] q[12] q[11] q[10] q[9] q[8] q[7] q[6] q[5] q[4]
+ q[3] q[2] q[1] q[0] SYNOPSYS_UNCONNECTED_4 SYNOPSYS_UNCONNECTED_5 SYNOPSYS_UNCONNECTED_6
+ q[123] q[122] q[121] q[120] q[119] q[118] q[117] q[116] q[115] q[114] q[113] q[112]
+ q[111] q[110] q[109] q[108] q[107] q[106] q[105] q[104] q[103] q[102] q[101] q[100]
+ q[99] q[98] q[97] q[96] q[95] q[94] q[93] q[92] q[91] q[90] q[89] q[88] q[87]
+ q[86] q[85] q[84] q[83] q[82] q[81] q[80] q[79] q[78] q[77] q[76] q[75] q[74]
+ q[73] q[72] q[71] q[70] q[69] q[68] q[67] q[66] q[65] q[64] q[63] q[62] VSS VDD_1V8
+ IN0 IN5 IN7 IN9 IN10 IN12 IN13 IN15 IN18 IN20 IN23 IN24 IN26 IN30 IN31 IN32 IN33
+ IN42 IN43 IN44 IN45 IN52 IN57 IN58 IN67 IN71 IN74 IN75 IN78 IN83 IN84 IN86 IN90
+ IN95 IN102 IN106 IN107 IN109 IN110 IN117 IN121 IN125 IN130 IN134 IN137 IN139 IN145
+ IN147 IN148 IN150 IN151 IN153 IN157 IN158 IN164 IN167 IN169 IN174 IN175 IN176
+ IN177 clk_gen_G4B2I2 clk_gen_G4B2I1 prll_d_reg_bits65_12
Xu_dp__0___dp2__D_reg clk_gen_G4B2I3 IN16 VSS VSS VSS Din[61] Din[60] Din[59] Din[58]
+ Din[57] Din[56] Din[55] Din[54] Din[53] Din[52] Din[51] Din[50] Din[49] Din[48]
+ Din[47] Din[46] Din[45] Din[44] Din[43] Din[42] Din[41] Din[40] Din[39] Din[38]
+ Din[37] Din[36] Din[35] Din[34] Din[33] Din[32] Din[31] Din[30] Din[29] Din[28]
+ Din[27] Din[26] Din[25] Din[24] Din[23] Din[22] Din[21] Din[20] Din[19] Din[18]
+ Din[17] Din[16] Din[15] Din[14] Din[13] Din[12] Din[11] Din[10] Din[9] Din[8]
+ Din[7] Din[6] Din[5] Din[4] Din[3] Din[2] Din[1] Din[0] SYNOPSYS_UNCONNECTED_7
+ SYNOPSYS_UNCONNECTED_8 SYNOPSYS_UNCONNECTED_9 q[61] q[60] q[59] q[58] q[57] q[56]
+ q[55] q[54] q[53] q[52] q[51] q[50] q[49] q[48] q[47] q[46] q[45] q[44] q[43]
+ q[42] q[41] q[40] q[39] q[38] q[37] q[36] q[35] q[34] q[33] q[32] q[31] q[30]
+ q[29] q[28] q[27] q[26] q[25] q[24] q[23] q[22] q[21] q[20] q[19] q[18] q[17]
+ q[16] q[15] q[14] q[13] q[12] q[11] q[10] q[9] q[8] q[7] q[6] q[5] q[4] q[3] q[2]
+ q[1] q[0] VSS VDD_1V8 IN34 IN35 IN36 IN39 IN46 IN47 IN49 IN50 IN51 IN54 IN55 IN56
+ IN59 IN60 IN61 IN62 IN63 IN64 IN70 IN80 IN81 IN85 IN87 IN88 IN89 IN91 IN92 IN93
+ IN96 IN97 IN98 IN99 IN100 IN112 IN113 IN115 IN116 IN119 IN120 IN122 IN123 IN124
+ IN126 IN127 IN129 IN131 IN152 IN154 IN156 IN159 IN160 IN161 IN163 IN165 IN168
+ clk_gen_G4B2I2 clk_gen_G4B2I1 prll_d_reg_bits65_13
XINHDLLX3_G4B2I1 VSS VDD_1V8 clk_gen_G4B1I1 clk_gen INHDLLX8
XINHDLLX8_G4B1I3 VSS VDD_1V8 clk_gen_G4B2I3 clk_gen_G4B1I1 INHDLLX8
XINHDLLX4_G4B1I2 VSS VDD_1V8 clk_gen_G4B1I1 clk_gen_G4B2I2 INHDLLX6
XINHDLLX12_G4B1I1 VDD_1V8 VSS clk_gen_G4B2I1 clk_gen_G4B1I1 INHDLLX12
XU84 VSS VDD_1V8 clk_gen push clk_cts_4 NO2I1HDLLX4
XU9 VSS VDD_1V8 n1 n13 n14 NO2I1HDLLX1
XU8 VSS n6 n13 n14 VDD_1V8 NO2HDLLX1
XU7 VSS VDD_1V8 n3 n14 n13 NO2I1HDLLX1
XU6 VSS n13 n14 VDD_1V8 pndng NA2HDLLX0
Xcount_reg_0_ IN138 clk n19 SYNOPSYS_UNCONNECTED_60 n14 VSS VDD_1V8 DFRRHDLLX0
Xcount_reg_1_ IN138 clk n18 SYNOPSYS_UNCONNECTED_61 n13 VSS VDD_1V8 DFRRHDLLX0
XU79 VSS n18 VDD_1V8 n8 n9 n13 ON21HDLLX0
XU78 pndng VSS n196 n7 VDD_1V8 n8 AN21HDLLX0
XU77 VSS n19 VDD_1V8 n5 n9 n14 ON21HDLLX0
XU76 VSS VDD_1V8 n5 n14 n199 n4 n7 AN22HDLLX0
XU75 n197 VSS VDD_1V8 n4 n7 n9 AO21HDLLX0
XU74 VSS VDD_1V8 n4 pop push NO2I1HDLLX0
XU73 VSS VDD_1V8 n7 push pop NO2I1HDLLX0
XU71 VSS Dout[0] q[62] n196 q[0] q[124] VDD_1V8 n199 n194 AO222HDLLX0
XU70 VSS Dout[1] q[63] n196 q[1] q[125] VDD_1V8 n199 n194 AO222HDLLX0
XU69 VSS Dout[2] q[64] n6 q[2] q[126] VDD_1V8 n3 n1 AO222HDLLX0
XU68 VSS Dout[3] q[65] n196 q[3] q[127] VDD_1V8 n199 n194 AO222HDLLX0
XU67 VSS Dout[4] q[66] n196 q[4] q[128] VDD_1V8 n199 n194 AO222HDLLX0
XU66 VSS Dout[5] q[67] n196 q[5] q[129] VDD_1V8 n199 n194 AO222HDLLX0
XU65 VSS Dout[6] q[68] n196 q[6] q[130] VDD_1V8 n199 n194 AO222HDLLX0
XU64 VSS Dout[7] q[69] n196 q[7] q[131] VDD_1V8 n199 n194 AO222HDLLX0
XU63 VSS Dout[8] q[70] n196 q[8] q[132] VDD_1V8 n199 n194 AO222HDLLX0
XU62 VSS Dout[9] q[71] n196 q[9] q[133] VDD_1V8 n3 n194 AO222HDLLX0
XU61 VSS Dout[10] q[72] n196 q[10] q[134] VDD_1V8 n199 n194 AO222HDLLX0
XU60 VSS Dout[11] q[73] n6 q[11] q[135] VDD_1V8 n3 n1 AO222HDLLX0
XU59 VSS Dout[12] q[74] n196 q[12] q[136] VDD_1V8 n3 n1 AO222HDLLX0
XU58 VSS Dout[13] q[75] n6 q[13] q[137] VDD_1V8 n199 n1 AO222HDLLX0
XU57 VSS Dout[14] q[76] n196 q[14] q[138] VDD_1V8 n199 n1 AO222HDLLX0
XU56 VSS Dout[15] q[77] n196 q[15] q[139] VDD_1V8 n3 n1 AO222HDLLX0
XU55 VSS Dout[16] q[78] n6 q[16] q[140] VDD_1V8 n199 n194 AO222HDLLX0
XU54 VSS Dout[17] q[79] n6 q[17] q[141] VDD_1V8 n3 n1 AO222HDLLX0
XU53 VSS Dout[18] q[80] n6 q[18] q[142] VDD_1V8 n3 n194 AO222HDLLX0
XU52 VSS Dout[19] q[81] n6 q[19] q[143] VDD_1V8 n3 n1 AO222HDLLX0
XU51 VSS Dout[20] q[82] n6 q[20] q[144] VDD_1V8 n3 n1 AO222HDLLX0
XU50 VSS Dout[21] q[83] n196 q[21] q[145] VDD_1V8 n3 n1 AO222HDLLX0
XU49 VSS Dout[22] q[84] n6 q[22] q[146] VDD_1V8 n199 n1 AO222HDLLX0
XU48 VSS Dout[23] q[85] n6 q[23] q[147] VDD_1V8 n199 n194 AO222HDLLX0
XU47 VSS Dout[24] q[86] n6 q[24] q[148] VDD_1V8 n3 n1 AO222HDLLX0
XU46 VSS Dout[25] q[87] n6 q[25] q[149] VDD_1V8 n3 n1 AO222HDLLX0
XU45 VSS Dout[26] q[88] n6 q[26] q[150] VDD_1V8 n3 n1 AO222HDLLX0
XU44 VSS Dout[27] q[89] n6 q[27] q[151] VDD_1V8 n3 n1 AO222HDLLX0
XU43 VSS Dout[28] q[90] n6 q[28] q[152] VDD_1V8 n3 n194 AO222HDLLX0
XU42 VSS Dout[29] q[91] n6 q[29] q[153] VDD_1V8 n3 n1 AO222HDLLX0
XU41 VSS Dout[30] q[92] n196 q[30] q[154] VDD_1V8 n3 n1 AO222HDLLX0
XU40 VSS Dout[31] q[93] n196 q[31] q[155] VDD_1V8 n199 n194 AO222HDLLX0
XU39 VSS Dout[32] q[94] n196 q[32] q[156] VDD_1V8 n3 n1 AO222HDLLX0
XU38 VSS Dout[33] q[95] n6 q[33] q[157] VDD_1V8 n3 n1 AO222HDLLX0
XU37 VSS Dout[34] q[96] n6 q[34] q[158] VDD_1V8 n3 n1 AO222HDLLX0
XU36 VSS Dout[35] q[97] n6 q[35] q[159] VDD_1V8 n3 n1 AO222HDLLX0
XU35 VSS Dout[36] q[98] n196 q[36] q[160] VDD_1V8 n199 n194 AO222HDLLX0
XU34 VSS Dout[37] q[99] n196 q[37] q[161] VDD_1V8 n199 n194 AO222HDLLX0
XU33 VSS Dout[38] q[100] n196 q[38] q[162] VDD_1V8 n199 n194 AO222HDLLX0
XU32 VSS Dout[39] q[101] n196 q[39] q[163] VDD_1V8 n199 n194 AO222HDLLX0
XU31 VSS Dout[40] q[102] n196 q[40] q[164] VDD_1V8 n199 n194 AO222HDLLX0
XU30 VSS Dout[41] q[103] n196 q[41] q[165] VDD_1V8 n199 n194 AO222HDLLX0
XU29 VSS Dout[42] q[104] n196 q[42] q[166] VDD_1V8 n199 n194 AO222HDLLX0
XU28 VSS Dout[43] q[105] n196 q[43] q[167] VDD_1V8 n199 n194 AO222HDLLX0
XU27 VSS Dout[44] q[106] n196 q[44] q[168] VDD_1V8 n199 n194 AO222HDLLX0
XU26 VSS Dout[45] q[107] n6 q[45] q[169] VDD_1V8 n3 n1 AO222HDLLX0
XU25 VSS Dout[46] q[108] n6 q[46] q[170] VDD_1V8 n3 n194 AO222HDLLX0
XU24 VSS Dout[47] q[109] n196 q[47] q[171] VDD_1V8 n199 n194 AO222HDLLX0
XU23 VSS Dout[48] q[110] n196 q[48] q[172] VDD_1V8 n3 n194 AO222HDLLX0
XU22 VSS Dout[49] q[111] n6 q[49] q[173] VDD_1V8 n3 n1 AO222HDLLX0
XU21 VSS Dout[50] q[112] n6 q[50] q[174] VDD_1V8 n3 n1 AO222HDLLX0
XU20 VSS Dout[51] q[113] n6 q[51] q[175] VDD_1V8 n3 n1 AO222HDLLX0
XU19 VSS Dout[52] q[114] n6 q[52] q[176] VDD_1V8 n3 n1 AO222HDLLX0
XU18 VSS Dout[53] q[115] n6 q[53] q[177] VDD_1V8 n3 n1 AO222HDLLX0
XU17 VSS Dout[54] q[116] n6 q[54] q[178] VDD_1V8 n199 n1 AO222HDLLX0
XU16 VSS Dout[55] q[117] n6 q[55] q[179] VDD_1V8 n3 n1 AO222HDLLX0
XU15 VSS Dout[56] q[118] n6 q[56] q[180] VDD_1V8 n199 n1 AO222HDLLX0
XU14 VSS Dout[57] q[119] n6 q[57] q[181] VDD_1V8 n3 n1 AO222HDLLX0
XU13 VSS Dout[58] q[120] n6 q[58] q[182] VDD_1V8 n199 n1 AO222HDLLX0
XU12 VSS Dout[59] q[121] n6 q[59] q[183] VDD_1V8 n3 n1 AO222HDLLX0
XU11 VSS Dout[60] q[122] n196 q[60] q[184] VDD_1V8 n199 n194 AO222HDLLX0
XU10 VSS Dout[61] q[123] q[61] q[185] n194 VDD_1V8 n199 n196 AO222HDLLX0
Xplace7 n197 VSS VDD_1V8 n196 INHDLLX0
Xplace4 VSS VDD_1V8 n194 n1 BUHDLLX0
Xplace6 VSS VDD_1V8 n196 n6 BUHDLLX0
Xplace9 VSS VDD_1V8 n199 n3 BUHDLLX0
.ENDS

.SUBCKT fifo_flops_no_full_depth3_bits65_0 Din[64] Din[63] Din[62] Din[61] Din[60]
+ Din[59] Din[58] Din[57] Din[56] Din[55] Din[54] Din[53] Din[52] Din[51] Din[50]
+ Din[49] Din[48] Din[47] Din[46] Din[45] Din[44] Din[43] Din[42] Din[41] Din[40]
+ Din[39] Din[38] Din[37] Din[36] Din[35] Din[34] Din[33] Din[32] Din[31] Din[30]
+ Din[29] Din[28] Din[27] Din[26] Din[25] Din[24] Din[23] Din[22] Din[21] Din[20]
+ Din[19] Din[18] Din[17] Din[16] Din[15] Din[14] Din[13] Din[12] Din[11] Din[10]
+ Din[9] Din[8] Din[7] Din[6] Din[5] Din[4] Din[3] Din[2] Din[1] Din[0] Dout[64]
+ Dout[63] Dout[62] Dout[61] Dout[60] Dout[59] Dout[58] Dout[57] Dout[56] Dout[55]
+ Dout[54] Dout[53] Dout[52] Dout[51] Dout[50] Dout[49] Dout[48] Dout[47] Dout[46]
+ Dout[45] Dout[44] Dout[43] Dout[42] Dout[41] Dout[40] Dout[39] Dout[38] Dout[37]
+ Dout[36] Dout[35] Dout[34] Dout[33] Dout[32] Dout[31] Dout[30] Dout[29] Dout[28]
+ Dout[27] Dout[26] Dout[25] Dout[24] Dout[23] Dout[22] Dout[21] Dout[20] Dout[19]
+ Dout[18] Dout[17] Dout[16] Dout[15] Dout[14] Dout[13] Dout[12] Dout[11] Dout[10]
+ Dout[9] Dout[8] Dout[7] Dout[6] Dout[5] Dout[4] Dout[3] Dout[2] Dout[1] Dout[0]
+ push pop clk pndng rst VSS VDD_1V8 IN0 IN1 IN2 IN3 IN4 IN5 IN6 IN7 IN8 IN9 IN10
+ IN11 IN12 IN13 IN14 IN15 IN16 IN17 IN18 IN19 IN20 IN21 IN22 IN23 IN24 IN25 IN26
+ IN27 IN28 IN29 IN30 IN31 IN32 IN33 IN34 IN35 IN36 IN37 IN38 IN39 IN40 IN41 IN42
+ IN43 IN44 IN45 IN46 IN47 IN48 IN49 IN50 IN51 IN52 IN53 IN54 IN55 IN56 IN57 IN58
+ IN59 IN60 IN61 IN62 IN63 IN64 IN65 IN66 IN67 IN68 IN69 IN70 IN71 clk_cts_4
Xu_dp__2___dp3__D_reg clk_gen_G4B2I3 rst VSS q[123] q[122] VSS VSS q[121] q[120]
+ q[119] q[118] q[117] q[116] q[115] q[114] q[113] q[112] q[111] q[110] q[109] q[108]
+ q[107] q[106] q[105] q[104] q[103] q[102] q[101] q[100] q[99] q[98] q[97] q[96]
+ q[95] q[94] q[93] q[92] q[91] q[90] q[89] q[88] q[87] q[86] q[85] q[84] q[83]
+ q[82] q[81] q[80] q[79] q[78] q[77] q[76] q[75] q[74] q[73] q[72] q[71] q[70]
+ q[69] q[68] q[67] q[66] q[65] q[64] q[63] q[62] SYNOPSYS_UNCONNECTED_1 q[185]
+ q[184] SYNOPSYS_UNCONNECTED_2 SYNOPSYS_UNCONNECTED_3 q[183] q[182] q[181] q[180]
+ q[179] q[178] q[177] q[176] q[175] q[174] q[173] q[172] q[171] q[170] q[169] q[168]
+ q[167] q[166] q[165] q[164] q[163] q[162] q[161] q[160] q[159] q[158] q[157] q[156]
+ q[155] q[154] q[153] q[152] q[151] q[150] q[149] q[148] q[147] q[146] q[145] q[144]
+ q[143] q[142] q[141] q[140] q[139] q[138] q[137] q[136] q[135] q[134] q[133] q[132]
+ q[131] q[130] q[129] q[128] q[127] q[126] q[125] q[124] VSS VDD_1V8 IN0 IN21 IN22
+ IN24 IN25 IN26 IN27 IN29 IN30 IN32 n53 n53 n53 n53 n53 n53 n53 n53 n53 n53 n53
+ IN34 IN35 IN36 IN37 IN40 IN44 IN45 IN46 IN53 IN56 IN57 IN60 n17 n17 n17 n17 n17
+ n17 n17 n17 n17 n17 n17 n17 n17 n17 n17 n17 clk_gen_G4B2I2 clk_gen_G4B2I1 prll_d_reg_bits65_8
Xu_dp__1___dp3__D_reg clk_gen_G4B2I3 rst VSS q[61] q[60] VSS VSS q[59] q[58] q[57]
+ q[56] q[55] q[54] q[53] q[52] q[51] q[50] q[49] q[48] q[47] q[46] q[45] q[44]
+ q[43] q[42] q[41] q[40] q[39] q[38] q[37] q[36] q[35] q[34] q[33] q[32] q[31]
+ q[30] q[29] q[28] q[27] q[26] q[25] q[24] q[23] q[22] q[21] q[20] q[19] q[18]
+ q[17] q[16] q[15] q[14] q[13] q[12] q[11] q[10] q[9] q[8] q[7] q[6] q[5] q[4]
+ q[3] q[2] q[1] q[0] SYNOPSYS_UNCONNECTED_4 q[123] q[122] SYNOPSYS_UNCONNECTED_5
+ SYNOPSYS_UNCONNECTED_6 q[121] q[120] q[119] q[118] q[117] q[116] q[115] q[114]
+ q[113] q[112] q[111] q[110] q[109] q[108] q[107] q[106] q[105] q[104] q[103] q[102]
+ q[101] q[100] q[99] q[98] q[97] q[96] q[95] q[94] q[93] q[92] q[91] q[90] q[89]
+ q[88] q[87] q[86] q[85] q[84] q[83] q[82] q[81] q[80] q[79] q[78] q[77] q[76]
+ q[75] q[74] q[73] q[72] q[71] q[70] q[69] q[68] q[67] q[66] q[65] q[64] q[63]
+ q[62] VSS VDD_1V8 IN15 IN17 IN18 IN19 IN20 IN23 IN28 IN31 n53 n53 n53 n53 n53
+ n53 n53 n53 n53 n53 n53 n53 IN33 IN38 IN39 IN41 IN42 IN49 IN50 IN54 IN61 IN62
+ IN63 IN64 n17 n17 n17 n17 n17 n17 n17 n17 n17 n17 n17 n17 n17 n17 n17 n17 n17
+ clk_gen_G4B2I2 clk_gen_G4B2I1 prll_d_reg_bits65_9
Xu_dp__0___dp2__D_reg clk_gen_G4B2I3 rst VSS Din[63] Din[62] VSS VSS Din[59] Din[58]
+ Din[57] Din[56] Din[55] Din[54] Din[53] Din[52] Din[51] Din[50] Din[49] Din[48]
+ Din[47] Din[46] Din[45] Din[44] Din[43] Din[42] Din[41] Din[40] Din[39] Din[38]
+ Din[37] Din[36] Din[35] Din[34] Din[33] Din[32] Din[31] Din[30] Din[29] Din[28]
+ Din[27] Din[26] Din[25] Din[24] Din[23] Din[22] Din[21] Din[20] Din[19] Din[18]
+ Din[17] Din[16] Din[15] Din[14] Din[13] Din[12] Din[11] Din[10] Din[9] Din[8]
+ Din[7] Din[6] Din[5] Din[4] Din[3] Din[2] Din[1] Din[0] SYNOPSYS_UNCONNECTED_7
+ q[61] q[60] SYNOPSYS_UNCONNECTED_8 SYNOPSYS_UNCONNECTED_9 q[59] q[58] q[57] q[56]
+ q[55] q[54] q[53] q[52] q[51] q[50] q[49] q[48] q[47] q[46] q[45] q[44] q[43]
+ q[42] q[41] q[40] q[39] q[38] q[37] q[36] q[35] q[34] q[33] q[32] q[31] q[30]
+ q[29] q[28] q[27] q[26] q[25] q[24] q[23] q[22] q[21] q[20] q[19] q[18] q[17]
+ q[16] q[15] q[14] q[13] q[12] q[11] q[10] q[9] q[8] q[7] q[6] q[5] q[4] q[3] q[2]
+ q[1] q[0] VSS VDD_1V8 IN1 IN2 IN3 IN4 IN5 IN6 IN7 IN8 IN9 IN10 IN11 IN12 IN13
+ IN14 IN16 n53 n53 n53 n53 n53 n53 n53 n53 n53 n53 n53 n53 n53 n53 n53 n53 n53
+ n53 IN43 IN47 IN48 IN51 IN52 IN55 IN59 n17 n17 n17 n17 n17 n17 n17 n17 n17 IN65
+ IN66 IN67 IN68 IN69 IN70 clk_gen_G4B2I2 clk_gen_G4B2I1 prll_d_reg_bits65_10
XINHDLLX3_G4B2I1 VSS VDD_1V8 clk_gen clk_gen_G4B1I1 INHDLLX6
XINHDLLX8_G4B1I3 VSS VDD_1V8 clk_gen_G4B2I3 clk_gen_G4B1I1 INHDLLX8
XINHDLLX6_G4B1I2 VSS VDD_1V8 clk_gen_G4B1I1 clk_gen_G4B2I2 INHDLLX6
XINHDLLX8_G4B1I1 VSS VDD_1V8 clk_gen_G4B2I1 clk_gen_G4B1I1 INHDLLX8
XU88 VSS VDD_1V8 clk_gen push clk_cts_4 NO2I1HDLLX4
XU21 VSS Dout[51] q[113] q[175] q[51] n9 VDD_1V8 n6 n4 AO222HDLLX0
XU20 VSS Dout[52] q[114] q[176] q[52] n9 VDD_1V8 n6 n4 AO222HDLLX0
XU19 VSS Dout[53] q[115] q[177] q[53] n9 VDD_1V8 n6 n4 AO222HDLLX0
XU18 VSS Dout[54] q[116] q[178] q[54] n9 VDD_1V8 n6 n4 AO222HDLLX0
XU17 VSS Dout[55] q[117] q[179] q[55] n9 VDD_1V8 n6 n4 AO222HDLLX0
XU16 VSS Dout[56] q[118] q[180] q[56] n9 VDD_1V8 n6 n4 AO222HDLLX0
XU15 VSS Dout[57] q[119] q[181] q[57] n9 VDD_1V8 n6 n4 AO222HDLLX0
XU14 VSS Dout[58] q[120] q[182] q[58] n9 VDD_1V8 n6 n4 AO222HDLLX0
XU13 VSS Dout[59] q[121] q[183] q[59] n9 VDD_1V8 n6 n4 AO222HDLLX0
XU12 VSS Dout[62] q[122] q[184] q[60] n9 VDD_1V8 n6 n4 AO222HDLLX0
XU11 VSS Dout[63] q[123] q[61] n9 n4 VDD_1V8 n6 q[185] AO222HDLLX0
XU10 VSS n4 count_1_ n14 VDD_1V8 NO2HDLLX1
XU9 VSS n9 n14 n28 VDD_1V8 NO2HDLLX1
XU8 VSS VDD_1V8 n6 n14 n28 NO2I1HDLLX1
XU7 VSS n14 n28 VDD_1V8 pndng NA2HDLLX0
Xcount_reg_0_ IN58 clk n19 SYNOPSYS_UNCONNECTED_59 n14 VSS VDD_1V8 DFRRHDLLX0
Xcount_reg_1_ IN58 clk n18 count_1_ n28 VSS VDD_1V8 DFRRHDLLX0
XU80 VSS n18 VDD_1V8 n11 n12 n28 ON21HDLLX0
XU79 pndng VSS n9 n10 VDD_1V8 n11 AN21HDLLX0
XU78 VSS n19 VDD_1V8 n8 n12 n14 ON21HDLLX0
XU77 VSS VDD_1V8 n8 n14 n6 n7 n10 AN22HDLLX0
XU76 n91 VSS VDD_1V8 n7 n10 n12 AO21HDLLX0
XU75 VSS VDD_1V8 n7 pop push NO2I1HDLLX0
XU74 VSS VDD_1V8 n10 push pop NO2I1HDLLX0
XU72 VSS Dout[0] q[62] q[124] q[0] n9 VDD_1V8 n6 n4 AO222HDLLX0
XU71 VSS Dout[1] q[63] q[125] q[1] n9 VDD_1V8 n6 n4 AO222HDLLX0
XU70 VSS Dout[2] q[64] q[126] q[2] n9 VDD_1V8 n6 n4 AO222HDLLX0
XU69 VSS Dout[3] q[65] q[127] q[3] n9 VDD_1V8 n6 n4 AO222HDLLX0
XU68 VSS Dout[4] q[66] q[128] q[4] n9 VDD_1V8 n6 n4 AO222HDLLX0
XU67 VSS Dout[5] q[67] q[129] q[5] n9 VDD_1V8 n6 n4 AO222HDLLX0
XU66 VSS Dout[6] q[68] q[130] q[6] n9 VDD_1V8 n6 n4 AO222HDLLX0
XU65 VSS Dout[7] q[69] q[131] q[7] n9 VDD_1V8 n6 n4 AO222HDLLX0
XU64 VSS Dout[8] q[70] q[132] q[8] n9 VDD_1V8 n6 n4 AO222HDLLX0
XU63 VSS Dout[9] q[71] q[133] q[9] n92 VDD_1V8 n94 n89 AO222HDLLX0
XU62 VSS Dout[10] q[72] q[134] q[10] n9 VDD_1V8 n6 n4 AO222HDLLX0
XU61 VSS Dout[11] q[73] q[135] q[11] n9 VDD_1V8 n6 n4 AO222HDLLX0
XU60 VSS Dout[12] q[74] q[136] q[12] n92 VDD_1V8 n94 n89 AO222HDLLX0
XU59 VSS Dout[13] q[75] q[137] q[13] n92 VDD_1V8 n94 n89 AO222HDLLX0
XU58 VSS Dout[14] q[76] q[138] q[14] n92 VDD_1V8 n94 n89 AO222HDLLX0
XU57 VSS Dout[15] q[77] q[139] q[15] n9 VDD_1V8 n6 n4 AO222HDLLX0
XU56 VSS Dout[16] q[78] q[140] q[16] n92 VDD_1V8 n94 n89 AO222HDLLX0
XU55 VSS Dout[17] q[79] q[141] q[17] n92 VDD_1V8 n94 n89 AO222HDLLX0
XU54 VSS Dout[18] q[80] q[142] q[18] n92 VDD_1V8 n94 n89 AO222HDLLX0
XU53 VSS Dout[19] q[81] q[143] q[19] n92 VDD_1V8 n94 n89 AO222HDLLX0
XU52 VSS Dout[20] q[82] q[144] q[20] n92 VDD_1V8 n94 n89 AO222HDLLX0
XU51 VSS Dout[21] q[83] q[145] q[21] n92 VDD_1V8 n94 n89 AO222HDLLX0
XU50 VSS Dout[22] q[84] q[146] q[22] n92 VDD_1V8 n94 n89 AO222HDLLX0
XU49 VSS Dout[23] q[85] q[147] q[23] n92 VDD_1V8 n94 n89 AO222HDLLX0
XU48 VSS Dout[24] q[86] q[148] q[24] n92 VDD_1V8 n94 n89 AO222HDLLX0
XU47 VSS Dout[25] q[87] q[149] q[25] n92 VDD_1V8 n94 n89 AO222HDLLX0
XU46 VSS Dout[26] q[88] q[150] q[26] n92 VDD_1V8 n94 n89 AO222HDLLX0
XU45 VSS Dout[27] q[89] q[151] q[27] n92 VDD_1V8 n94 n89 AO222HDLLX0
XU44 VSS Dout[28] q[90] q[152] q[28] n92 VDD_1V8 n94 n89 AO222HDLLX0
XU43 VSS Dout[29] q[91] q[153] q[29] n92 VDD_1V8 n94 n89 AO222HDLLX0
XU42 VSS Dout[30] q[92] q[154] q[30] n92 VDD_1V8 n94 n89 AO222HDLLX0
XU41 VSS Dout[31] q[93] q[155] q[31] n92 VDD_1V8 n94 n89 AO222HDLLX0
XU40 VSS Dout[32] q[94] q[156] q[32] n92 VDD_1V8 n94 n89 AO222HDLLX0
XU39 VSS Dout[33] q[95] q[157] q[33] n92 VDD_1V8 n94 n89 AO222HDLLX0
XU38 VSS Dout[34] q[96] q[158] q[34] n92 VDD_1V8 n94 n89 AO222HDLLX0
XU37 VSS Dout[35] q[97] q[159] q[35] n92 VDD_1V8 n94 n89 AO222HDLLX0
XU36 VSS Dout[36] q[98] q[160] q[36] n92 VDD_1V8 n94 n89 AO222HDLLX0
XU35 VSS Dout[37] q[99] q[161] q[37] n9 VDD_1V8 n6 n4 AO222HDLLX0
XU34 VSS Dout[38] q[100] q[162] q[38] n9 VDD_1V8 n6 n4 AO222HDLLX0
XU33 VSS Dout[39] q[101] q[163] q[39] n9 VDD_1V8 n6 n4 AO222HDLLX0
XU32 VSS Dout[40] q[102] q[164] q[40] n9 VDD_1V8 n6 n4 AO222HDLLX0
XU31 VSS Dout[41] q[103] q[165] q[41] n9 VDD_1V8 n6 n4 AO222HDLLX0
XU30 VSS Dout[42] q[104] q[166] q[42] n9 VDD_1V8 n6 n4 AO222HDLLX0
XU29 VSS Dout[43] q[105] q[167] q[43] n9 VDD_1V8 n6 n4 AO222HDLLX0
XU28 VSS Dout[44] q[106] q[168] q[44] n9 VDD_1V8 n6 n4 AO222HDLLX0
XU27 VSS Dout[45] q[107] q[169] q[45] n9 VDD_1V8 n6 n4 AO222HDLLX0
XU26 VSS Dout[46] q[108] q[170] q[46] n9 VDD_1V8 n6 n4 AO222HDLLX0
XU25 VSS Dout[47] q[109] q[171] q[47] n9 VDD_1V8 n6 n4 AO222HDLLX0
XU24 VSS Dout[48] q[110] q[172] q[48] n9 VDD_1V8 n6 n4 AO222HDLLX0
XU23 VSS Dout[49] q[111] q[173] q[49] n9 VDD_1V8 n6 n4 AO222HDLLX0
XU22 VSS Dout[50] q[112] q[174] q[50] n9 VDD_1V8 n6 n4 AO222HDLLX0
Xplace8 n91 VSS VDD_1V8 n9 INHDLLX0
Xplace4 n53 VSS VDD_1V8 IN71 INHDLLX1
Xplace3 n17 VSS VDD_1V8 IN71 INHDLLX1
Xplace11 VSS VDD_1V8 n94 n6 BUHDLLX0
Xplace9 VSS VDD_1V8 n92 n9 BUHDLLX0
Xplace6 VSS VDD_1V8 n89 n4 BUHDLLX0
.ENDS

.SUBCKT fifo_flops_no_full_depth2_bits65_3 Din[64] Din[63] Din[62] Din[61] Din[60]
+ Din[59] Din[58] Din[57] Din[56] Din[55] Din[54] Din[53] Din[52] Din[51] Din[50]
+ Din[49] Din[48] Din[47] Din[46] Din[45] Din[44] Din[43] Din[42] Din[41] Din[40]
+ Din[39] Din[38] Din[37] Din[36] Din[35] Din[34] Din[33] Din[32] Din[31] Din[30]
+ Din[29] Din[28] Din[27] Din[26] Din[25] Din[24] Din[23] Din[22] Din[21] Din[20]
+ Din[19] Din[18] Din[17] Din[16] Din[15] Din[14] Din[13] Din[12] Din[11] Din[10]
+ Din[9] Din[8] Din[7] Din[6] Din[5] Din[4] Din[3] Din[2] Din[1] Din[0] Dout[64]
+ Dout[63] Dout[62] Dout[61] Dout[60] Dout[59] Dout[58] Dout[57] Dout[56] Dout[55]
+ Dout[54] Dout[53] Dout[52] Dout[51] Dout[50] Dout[49] Dout[48] Dout[47] Dout[46]
+ Dout[45] Dout[44] Dout[43] Dout[42] Dout[41] Dout[40] Dout[39] Dout[38] Dout[37]
+ Dout[36] Dout[35] Dout[34] Dout[33] Dout[32] Dout[31] Dout[30] Dout[29] Dout[28]
+ Dout[27] Dout[26] Dout[25] Dout[24] Dout[23] Dout[22] Dout[21] Dout[20] Dout[19]
+ Dout[18] Dout[17] Dout[16] Dout[15] Dout[14] Dout[13] Dout[12] Dout[11] Dout[10]
+ Dout[9] Dout[8] Dout[7] Dout[6] Dout[5] Dout[4] Dout[3] Dout[2] Dout[1] Dout[0]
+ push pop clk pndng rst VSS VDD_1V8 IN0 IN1 IN2 IN3 IN4 IN5 IN6 IN7 IN8 IN9 IN10
+ IN11 IN12 IN13 IN14 IN15 IN16 IN17 IN18 IN19 IN20 IN21 IN22 IN23 IN24 IN25 IN26
+ IN27 IN28 IN29 clk_cts_4
Xu_dp__1___dp3__D_reg clk_gen_G4B2I2 n47 q[60] q[59] q[58] VSS VSS q[57] q[56] q[55]
+ VSS VSS q[54] q[53] q[52] q[51] q[50] q[49] q[48] q[47] q[46] q[45] q[44] q[43]
+ q[42] q[41] q[40] q[39] q[38] q[37] q[36] q[35] q[34] q[33] q[32] q[31] q[30]
+ q[29] q[28] q[27] q[26] q[25] q[24] q[23] q[22] q[21] q[20] q[19] q[18] q[17]
+ q[16] q[15] q[14] q[13] q[12] q[11] q[10] q[9] q[8] q[7] q[6] q[5] q[4] q[3] q[2]
+ q[1] q[0] q[121] q[120] q[119] SYNOPSYS_UNCONNECTED_1 SYNOPSYS_UNCONNECTED_2 q[118]
+ q[117] q[116] SYNOPSYS_UNCONNECTED_3 SYNOPSYS_UNCONNECTED_4 q[115] q[114] q[113]
+ q[112] q[111] q[110] q[109] q[108] q[107] q[106] q[105] q[104] q[103] q[102] q[101]
+ q[100] q[99] q[98] q[97] q[96] q[95] q[94] q[93] q[92] q[91] q[90] q[89] q[88]
+ q[87] q[86] q[85] q[84] q[83] q[82] q[81] q[80] q[79] q[78] q[77] q[76] q[75]
+ q[74] q[73] q[72] q[71] q[70] q[69] q[68] q[67] q[66] q[65] q[64] q[63] q[62]
+ q[61] VSS VDD_1V8 n40 n40 n40 n40 n40 n40 n40 n40 n40 n40 n40 n40 n40 n40 n40
+ n40 n40 n40 n40 IN5 IN6 IN7 IN8 IN9 IN10 IN11 IN13 IN14 IN15 IN17 IN19 IN21 IN23
+ clk_gen_G4B2I1 prll_d_reg_bits65_6
Xu_dp__0___dp2__D_reg clk_gen_G4B2I2 n47 Din[64] Din[63] Din[62] VSS VSS Din[59]
+ Din[58] Din[57] VSS VSS Din[54] Din[53] Din[52] Din[51] Din[50] Din[49] Din[48]
+ Din[47] Din[46] Din[45] Din[44] Din[43] Din[42] Din[41] Din[40] Din[39] Din[38]
+ Din[37] Din[36] Din[35] Din[34] Din[33] Din[32] Din[31] Din[30] Din[29] Din[28]
+ Din[27] Din[26] Din[25] Din[24] Din[23] Din[22] Din[21] Din[20] Din[19] Din[18]
+ Din[17] Din[16] Din[15] Din[14] Din[13] Din[12] Din[11] Din[10] Din[9] Din[8]
+ Din[7] Din[6] Din[5] Din[4] Din[3] Din[2] Din[1] Din[0] q[60] q[59] q[58] SYNOPSYS_UNCONNECTED_5
+ SYNOPSYS_UNCONNECTED_6 q[57] q[56] q[55] SYNOPSYS_UNCONNECTED_7 SYNOPSYS_UNCONNECTED_8
+ q[54] q[53] q[52] q[51] q[50] q[49] q[48] q[47] q[46] q[45] q[44] q[43] q[42]
+ q[41] q[40] q[39] q[38] q[37] q[36] q[35] q[34] q[33] q[32] q[31] q[30] q[29]
+ q[28] q[27] q[26] q[25] q[24] q[23] q[22] q[21] q[20] q[19] q[18] q[17] q[16]
+ q[15] q[14] q[13] q[12] q[11] q[10] q[9] q[8] q[7] q[6] q[5] q[4] q[3] q[2] q[1]
+ q[0] VSS VDD_1V8 rst IN0 IN1 IN2 IN3 IN4 n40 n40 n40 n40 n40 n40 n40 n40 n40 n40
+ n40 n40 n40 n40 n40 n40 n40 n40 n40 IN12 IN16 IN18 IN20 IN22 IN24 IN25 IN27 IN28
+ clk_gen_G4B2I1 prll_d_reg_bits65_7
XINHDLLX2_G4B2I1 clk_gen_G4B1I1 VSS VDD_1V8 clk_gen INHDLLX2
XINHDLLX8_G4B1I2 VSS VDD_1V8 clk_gen_G4B2I2 clk_gen_G4B1I1 INHDLLX8
XU77 VSS clk_gen clk_cts_4 n11 VDD_1V8 NO2HDLLX2
XINHDLLX6_G4B1I1 VSS VDD_1V8 clk_gen_G4B1I1 clk_gen_G4B2I1 INHDLLX6
XU32 n51 VSS VDD_1V8 n49 q[101] q[40] Dout[40] AO22HDLLX1
XU31 n51 VSS VDD_1V8 n49 q[102] q[41] Dout[41] AO22HDLLX1
XU30 n51 VSS VDD_1V8 n49 q[103] q[42] Dout[42] AO22HDLLX1
XU29 n51 VSS VDD_1V8 n49 q[104] q[43] Dout[43] AO22HDLLX1
XU28 n51 VSS VDD_1V8 n49 q[105] q[44] Dout[44] AO22HDLLX1
XU27 n51 VSS VDD_1V8 n49 q[106] q[45] Dout[45] AO22HDLLX1
XU26 n3 VSS VDD_1V8 n49 q[107] q[46] Dout[46] AO22HDLLX1
XU25 n51 VSS VDD_1V8 n49 q[108] q[47] Dout[47] AO22HDLLX1
XU24 n51 VSS VDD_1V8 n49 q[109] q[48] Dout[48] AO22HDLLX1
XU23 n51 VSS VDD_1V8 n49 q[110] q[49] Dout[49] AO22HDLLX1
XU22 n51 VSS VDD_1V8 n49 q[111] q[50] Dout[50] AO22HDLLX1
XU21 n51 VSS VDD_1V8 n49 q[112] q[51] Dout[51] AO22HDLLX1
XU20 n3 VSS VDD_1V8 n1 q[113] q[52] Dout[52] AO22HDLLX1
XU19 n51 VSS VDD_1V8 n49 q[114] q[53] Dout[53] AO22HDLLX1
XU18 n3 VSS VDD_1V8 n1 q[115] q[54] Dout[54] AO22HDLLX1
XU17 n51 VSS VDD_1V8 n49 q[116] q[55] Dout[57] AO22HDLLX1
XU16 n51 VSS VDD_1V8 n49 q[117] q[56] Dout[58] AO22HDLLX1
XU15 n51 VSS VDD_1V8 n49 q[118] q[57] Dout[59] AO22HDLLX1
XU14 n3 VSS VDD_1V8 n1 q[119] q[58] Dout[62] AO22HDLLX1
XU13 n3 VSS VDD_1V8 n1 q[120] q[59] Dout[63] AO22HDLLX1
XU12 n51 VSS VDD_1V8 n1 q[121] q[60] Dout[64] AO22HDLLX1
XU11 VSS n1 n8 count_1_ VDD_1V8 NO2HDLLX1
XU10 VSS n3 n23 n10 VDD_1V8 NO2HDLLX1
XU7 VSS n8 n10 VDD_1V8 pndng NA2HDLLX0
XU6 n10 VSS VDD_1V8 count_1_ INHDLLX0
XU5 n11 VSS VDD_1V8 push INHDLLX0
Xcount_reg_0_ IN26 clk n13 n23 n8 VSS VDD_1V8 DFRRHDLLX0
Xcount_reg_1_ IN26 clk n12 count_1_ VSS VDD_1V8 DFRRQHDLLX0
XU81 n12 n11 n8 VSS VDD_1V8 pop n14 AN31HDLLX0
XU80 VSS VDD_1V8 n14 count_1_ n9 n10 MU2IHDLLX0
XU79 n9 VSS VDD_1V8 n8 n11 pop NO3HDLLX0
XU78 VSS n13 VDD_1V8 n6 pndng n7 ON21HDLLX0
XU76 n6 VSS VDD_1V8 n51 n2 n4 n7 n23 AN32HDLLX0
XU75 n2 VSS VDD_1V8 n4 INHDLLX0
XU74 VSS pop n11 VDD_1V8 n4 NA2HDLLX0
XU73 n7 VSS pop VDD_1V8 push NA2I1HDLLX0
XU72 n51 VSS VDD_1V8 n49 q[61] q[0] Dout[0] AO22HDLLX1
XU71 n51 VSS VDD_1V8 n49 q[62] q[1] Dout[1] AO22HDLLX1
XU70 n51 VSS VDD_1V8 n49 q[63] q[2] Dout[2] AO22HDLLX1
XU69 n51 VSS VDD_1V8 n49 q[64] q[3] Dout[3] AO22HDLLX1
XU68 n3 VSS VDD_1V8 n1 q[65] q[4] Dout[4] AO22HDLLX1
XU67 n51 VSS VDD_1V8 n49 q[66] q[5] Dout[5] AO22HDLLX1
XU66 n51 VSS VDD_1V8 n49 q[67] q[6] Dout[6] AO22HDLLX1
XU65 n51 VSS VDD_1V8 n49 q[68] q[7] Dout[7] AO22HDLLX1
XU64 n3 VSS VDD_1V8 n1 q[69] q[8] Dout[8] AO22HDLLX1
XU63 n51 VSS VDD_1V8 n1 q[70] q[9] Dout[9] AO22HDLLX1
XU62 n3 VSS VDD_1V8 n1 q[71] q[10] Dout[10] AO22HDLLX1
XU61 n3 VSS VDD_1V8 n1 q[72] q[11] Dout[11] AO22HDLLX1
XU60 n3 VSS VDD_1V8 n1 q[73] q[12] Dout[12] AO22HDLLX1
XU59 n51 VSS VDD_1V8 n1 q[74] q[13] Dout[13] AO22HDLLX1
XU58 n51 VSS VDD_1V8 n49 q[75] q[14] Dout[14] AO22HDLLX1
XU57 n3 VSS VDD_1V8 n49 q[76] q[15] Dout[15] AO22HDLLX1
XU56 n3 VSS VDD_1V8 n1 q[77] q[16] Dout[16] AO22HDLLX1
XU55 n3 VSS VDD_1V8 n1 q[78] q[17] Dout[17] AO22HDLLX1
XU54 n3 VSS VDD_1V8 n49 q[79] q[18] Dout[18] AO22HDLLX1
XU53 n3 VSS VDD_1V8 n1 q[80] q[19] Dout[19] AO22HDLLX1
XU52 n51 VSS VDD_1V8 n49 q[81] q[20] Dout[20] AO22HDLLX1
XU51 n3 VSS VDD_1V8 n49 q[82] q[21] Dout[21] AO22HDLLX1
XU50 n51 VSS VDD_1V8 n1 q[83] q[22] Dout[22] AO22HDLLX1
XU49 n51 VSS VDD_1V8 n1 q[84] q[23] Dout[23] AO22HDLLX1
XU48 n51 VSS VDD_1V8 n49 q[85] q[24] Dout[24] AO22HDLLX1
XU47 n3 VSS VDD_1V8 n1 q[86] q[25] Dout[25] AO22HDLLX1
XU46 n3 VSS VDD_1V8 n1 q[87] q[26] Dout[26] AO22HDLLX1
XU45 n51 VSS VDD_1V8 n1 q[88] q[27] Dout[27] AO22HDLLX1
XU44 n3 VSS VDD_1V8 n1 q[89] q[28] Dout[28] AO22HDLLX1
XU43 n3 VSS VDD_1V8 n49 q[90] q[29] Dout[29] AO22HDLLX1
XU42 n3 VSS VDD_1V8 n1 q[91] q[30] Dout[30] AO22HDLLX1
XU41 n3 VSS VDD_1V8 n1 q[92] q[31] Dout[31] AO22HDLLX1
XU40 n3 VSS VDD_1V8 n1 q[93] q[32] Dout[32] AO22HDLLX1
XU39 n3 VSS VDD_1V8 n49 q[94] q[33] Dout[33] AO22HDLLX1
XU38 n51 VSS VDD_1V8 n49 q[95] q[34] Dout[34] AO22HDLLX1
XU37 n3 VSS VDD_1V8 n1 q[96] q[35] Dout[35] AO22HDLLX1
XU36 n51 VSS VDD_1V8 n49 q[97] q[36] Dout[36] AO22HDLLX1
XU35 n51 VSS VDD_1V8 n49 q[98] q[37] Dout[37] AO22HDLLX1
XU34 n51 VSS VDD_1V8 n49 q[99] q[38] Dout[38] AO22HDLLX1
XU33 n51 VSS VDD_1V8 n49 q[100] q[39] Dout[39] AO22HDLLX1
Xplace4 n47 VSS VDD_1V8 IN29 INHDLLX1
Xplace3 n40 VSS VDD_1V8 IN29 INHDLLX1
Xplace6 VSS VDD_1V8 n49 n1 BUHDLLX0
Xplace8 VSS VDD_1V8 n51 n3 BUHDLLX0
.ENDS

.SUBCKT fifo_flops_no_full_depth2_bits65_2 Din[64] Din[63] Din[62] Din[61] Din[60]
+ Din[59] Din[58] Din[57] Din[56] Din[55] Din[54] Din[53] Din[52] Din[51] Din[50]
+ Din[49] Din[48] Din[47] Din[46] Din[45] Din[44] Din[43] Din[42] Din[41] Din[40]
+ Din[39] Din[38] Din[37] Din[36] Din[35] Din[34] Din[33] Din[32] Din[31] Din[30]
+ Din[29] Din[28] Din[27] Din[26] Din[25] Din[24] Din[23] Din[22] Din[21] Din[20]
+ Din[19] Din[18] Din[17] Din[16] Din[15] Din[14] Din[13] Din[12] Din[11] Din[10]
+ Din[9] Din[8] Din[7] Din[6] Din[5] Din[4] Din[3] Din[2] Din[1] Din[0] Dout[64]
+ Dout[63] Dout[62] Dout[61] Dout[60] Dout[59] Dout[58] Dout[57] Dout[56] Dout[55]
+ Dout[54] Dout[53] Dout[52] Dout[51] Dout[50] Dout[49] Dout[48] Dout[47] Dout[46]
+ Dout[45] Dout[44] Dout[43] Dout[42] Dout[41] Dout[40] Dout[39] Dout[38] Dout[37]
+ Dout[36] Dout[35] Dout[34] Dout[33] Dout[32] Dout[31] Dout[30] Dout[29] Dout[28]
+ Dout[27] Dout[26] Dout[25] Dout[24] Dout[23] Dout[22] Dout[21] Dout[20] Dout[19]
+ Dout[18] Dout[17] Dout[16] Dout[15] Dout[14] Dout[13] Dout[12] Dout[11] Dout[10]
+ Dout[9] Dout[8] Dout[7] Dout[6] Dout[5] Dout[4] Dout[3] Dout[2] Dout[1] Dout[0]
+ push pop clk pndng rst VSS VDD_1V8 IN0 IN1 IN2 IN3 IN4 IN5 IN6 IN7 IN8 IN9 IN10
+ IN11 IN12 IN13 IN14 IN15 IN16 IN17 IN18 IN19 IN20 IN21 IN22 IN23 IN24 IN25 IN26
+ IN27 IN28 IN29 IN30 IN31 IN32 IN33 IN34 IN35 IN36 IN37 IN38 IN39 IN40 IN41 IN42
+ IN43 IN44 IN45 IN46 IN47 IN48 IN49 IN50 IN51 IN52 IN53 IN54 IN55 IN56 IN57 IN58
+ IN59 IN60 IN61 IN62 IN63 IN64 clk_cts_4
Xu_dp__1___dp3__D_reg clk_gen_G4B2I2 n81 VSS VSS VSS VSS q[60] q[59] q[58] q[57]
+ q[56] q[55] q[54] q[53] q[52] q[51] q[50] q[49] q[48] q[47] q[46] q[45] q[44]
+ q[43] q[42] q[41] q[40] q[39] q[38] q[37] q[36] q[35] q[34] q[33] q[32] q[31]
+ q[30] q[29] q[28] q[27] q[26] q[25] q[24] q[23] q[22] q[21] q[20] q[19] q[18]
+ q[17] q[16] q[15] q[14] q[13] q[12] q[11] q[10] q[9] q[8] q[7] q[6] q[5] q[4]
+ q[3] q[2] q[1] q[0] SYNOPSYS_UNCONNECTED_1 SYNOPSYS_UNCONNECTED_2 SYNOPSYS_UNCONNECTED_3
+ SYNOPSYS_UNCONNECTED_4 q[121] q[120] q[119] q[118] q[117] q[116] q[115] q[114]
+ q[113] q[112] q[111] q[110] q[109] q[108] q[107] q[106] q[105] q[104] q[103] q[102]
+ q[101] q[100] q[99] q[98] q[97] q[96] q[95] q[94] q[93] q[92] q[91] q[90] q[89]
+ q[88] q[87] q[86] q[85] q[84] q[83] q[82] q[81] q[80] q[79] q[78] q[77] q[76]
+ q[75] q[74] q[73] q[72] q[71] q[70] q[69] q[68] q[67] q[66] q[65] q[64] q[63]
+ q[62] q[61] VSS VDD_1V8 rst rst rst rst rst rst rst rst IN1 IN2 IN3 IN4 IN5 IN6
+ IN8 IN15 IN16 IN17 IN18 IN19 IN20 IN21 IN22 IN23 IN24 IN25 IN26 IN27 IN28 IN29
+ IN30 IN31 IN32 IN53 IN57 IN58 IN60 IN63 clk_gen_G4B2I1 prll_d_reg_bits65_4
Xu_dp__0___dp2__D_reg clk_gen_G4B2I2 n81 VSS VSS VSS VSS Din[60] Din[59] Din[58]
+ Din[57] Din[56] Din[55] Din[54] Din[53] Din[52] Din[51] Din[50] Din[49] Din[48]
+ Din[47] Din[46] Din[45] Din[44] Din[43] Din[42] Din[41] Din[40] Din[39] Din[38]
+ Din[37] Din[36] Din[35] Din[34] Din[33] Din[32] Din[31] Din[30] Din[29] Din[28]
+ Din[27] Din[26] Din[25] Din[24] Din[23] Din[22] Din[21] Din[20] Din[19] Din[18]
+ Din[17] Din[16] Din[15] Din[14] Din[13] Din[12] Din[11] Din[10] Din[9] Din[8]
+ Din[7] Din[6] Din[5] Din[4] Din[3] Din[2] Din[1] Din[0] SYNOPSYS_UNCONNECTED_5
+ SYNOPSYS_UNCONNECTED_6 SYNOPSYS_UNCONNECTED_7 SYNOPSYS_UNCONNECTED_8 q[60] q[59]
+ q[58] q[57] q[56] q[55] q[54] q[53] q[52] q[51] q[50] q[49] q[48] q[47] q[46]
+ q[45] q[44] q[43] q[42] q[41] q[40] q[39] q[38] q[37] q[36] q[35] q[34] q[33]
+ q[32] q[31] q[30] q[29] q[28] q[27] q[26] q[25] q[24] q[23] q[22] q[21] q[20]
+ q[19] q[18] q[17] q[16] q[15] q[14] q[13] q[12] q[11] q[10] q[9] q[8] q[7] q[6]
+ q[5] q[4] q[3] q[2] q[1] q[0] VSS VDD_1V8 rst rst rst rst rst rst rst rst IN7
+ IN9 IN10 IN11 IN12 IN13 IN14 IN33 IN34 IN35 IN36 IN37 IN38 IN39 IN40 IN41 IN42
+ IN43 IN44 IN45 IN46 IN47 IN48 IN49 IN50 IN51 IN52 IN54 IN55 IN56 IN59 IN61 IN62
+ clk_gen_G4B2I1 prll_d_reg_bits65_5
XINHDLLX6_G4B1I1 VSS VDD_1V8 clk_gen_G4B1I1 clk_gen_G4B2I1 INHDLLX6
XINHDLLX3_G4B2I1 clk_gen_G4B1I1 VSS VDD_1V8 clk_gen INHDLLX2
XINHDLLX3_G4B2I2 clk_gen_G4B1I2 VSS VDD_1V8 clk_gen INHDLLX2
XINHDLLX8_G4B1I2 VSS VDD_1V8 clk_gen_G4B2I2 clk_gen_G4B1I2 INHDLLX8
XU81 VSS clk_gen clk_cts_4 n11 VDD_1V8 NO2HDLLX4
XU44 n84 VSS VDD_1V8 n82 q[91] q[30] Dout[30] AO22HDLLX1
XU43 n84 VSS VDD_1V8 n82 q[92] q[31] Dout[31] AO22HDLLX1
XU42 n85 VSS VDD_1V8 n83 q[93] q[32] Dout[32] AO22HDLLX1
XU41 n85 VSS VDD_1V8 n83 q[94] q[33] Dout[33] AO22HDLLX1
XU40 n85 VSS VDD_1V8 n83 q[95] q[34] Dout[34] AO22HDLLX1
XU39 n85 VSS VDD_1V8 n83 q[96] q[35] Dout[35] AO22HDLLX1
XU38 n85 VSS VDD_1V8 n83 q[97] q[36] Dout[36] AO22HDLLX1
XU37 n85 VSS VDD_1V8 n83 q[98] q[37] Dout[37] AO22HDLLX1
XU36 n85 VSS VDD_1V8 n83 q[99] q[38] Dout[38] AO22HDLLX1
XU35 n85 VSS VDD_1V8 n83 q[100] q[39] Dout[39] AO22HDLLX1
XU34 n85 VSS VDD_1V8 n83 q[101] q[40] Dout[40] AO22HDLLX1
XU33 n85 VSS VDD_1V8 n83 q[102] q[41] Dout[41] AO22HDLLX1
XU32 n85 VSS VDD_1V8 n83 q[103] q[42] Dout[42] AO22HDLLX1
XU31 n85 VSS VDD_1V8 n83 q[104] q[43] Dout[43] AO22HDLLX1
XU30 n85 VSS VDD_1V8 n83 q[105] q[44] Dout[44] AO22HDLLX1
XU29 n85 VSS VDD_1V8 n83 q[106] q[45] Dout[45] AO22HDLLX1
XU28 n85 VSS VDD_1V8 n83 q[107] q[46] Dout[46] AO22HDLLX1
XU27 n85 VSS VDD_1V8 n83 q[108] q[47] Dout[47] AO22HDLLX1
XU26 n85 VSS VDD_1V8 n83 q[109] q[48] Dout[48] AO22HDLLX1
XU25 n85 VSS VDD_1V8 n83 q[110] q[49] Dout[49] AO22HDLLX1
XU24 n85 VSS VDD_1V8 n83 q[111] q[50] Dout[50] AO22HDLLX1
XU23 n85 VSS VDD_1V8 n83 q[112] q[51] Dout[51] AO22HDLLX1
XU22 n85 VSS VDD_1V8 n83 q[113] q[52] Dout[52] AO22HDLLX1
XU21 n85 VSS VDD_1V8 n83 q[114] q[53] Dout[53] AO22HDLLX1
XU20 n85 VSS VDD_1V8 n83 q[115] q[54] Dout[54] AO22HDLLX1
XU19 n85 VSS VDD_1V8 n83 q[116] q[55] Dout[55] AO22HDLLX1
XU18 n85 VSS VDD_1V8 n83 q[117] q[56] Dout[56] AO22HDLLX1
XU17 n85 VSS VDD_1V8 n83 q[118] q[57] Dout[57] AO22HDLLX1
XU16 n85 VSS VDD_1V8 n83 q[119] q[58] Dout[58] AO22HDLLX1
XU15 n85 VSS VDD_1V8 n83 q[120] q[59] Dout[59] AO22HDLLX1
XU14 n84 VSS VDD_1V8 n82 q[121] q[60] Dout[60] AO22HDLLX1
XU13 VSS n3 n8 count_1_ VDD_1V8 NO2HDLLX1
XU12 VSS n6 n23 n4 VDD_1V8 NO2HDLLX0
XU7 n12 n11 n8 VSS VDD_1V8 pop n2 AN31HDLLX0
XU6 VSS VDD_1V8 n2 count_1_ n1 n4 MU2IHDLLX0
XU5 n1 VSS VDD_1V8 n8 n11 pop NO3HDLLX0
XU4 n4 VSS VDD_1V8 count_1_ INHDLLX0
XU3 n11 VSS VDD_1V8 push INHDLLX0
Xcount_reg_0_ IN0 clk n13 n23 n8 VSS VDD_1V8 DFRRHDLLX0
Xcount_reg_1_ IN0 clk n12 count_1_ VSS VDD_1V8 DFRRQHDLLX0
XU80 VSS n13 VDD_1V8 n10 pndng n14 ON21HDLLX0
XU79 n10 VSS VDD_1V8 n85 n5 n7 n14 n23 AN32HDLLX0
XU78 n5 VSS VDD_1V8 n7 INHDLLX0
XU77 VSS pop n11 VDD_1V8 n7 NA2HDLLX0
XU76 n14 VSS pop VDD_1V8 push NA2I1HDLLX0
XU75 VSS n8 n4 VDD_1V8 pndng NA2HDLLX0
XU74 n84 VSS VDD_1V8 n82 q[61] q[0] Dout[0] AO22HDLLX1
XU73 n84 VSS VDD_1V8 n82 q[62] q[1] Dout[1] AO22HDLLX1
XU72 n84 VSS VDD_1V8 n82 q[63] q[2] Dout[2] AO22HDLLX1
XU71 n84 VSS VDD_1V8 n82 q[64] q[3] Dout[3] AO22HDLLX1
XU70 n84 VSS VDD_1V8 n82 q[65] q[4] Dout[4] AO22HDLLX1
XU69 n84 VSS VDD_1V8 n82 q[66] q[5] Dout[5] AO22HDLLX1
XU68 n84 VSS VDD_1V8 n82 q[67] q[6] Dout[6] AO22HDLLX1
XU67 n84 VSS VDD_1V8 n82 q[68] q[7] Dout[7] AO22HDLLX1
XU66 n84 VSS VDD_1V8 n82 q[69] q[8] Dout[8] AO22HDLLX1
XU65 n84 VSS VDD_1V8 n82 q[70] q[9] Dout[9] AO22HDLLX1
XU64 n84 VSS VDD_1V8 n82 q[71] q[10] Dout[10] AO22HDLLX1
XU63 n84 VSS VDD_1V8 n82 q[72] q[11] Dout[11] AO22HDLLX1
XU62 n84 VSS VDD_1V8 n82 q[73] q[12] Dout[12] AO22HDLLX1
XU61 n84 VSS VDD_1V8 n82 q[74] q[13] Dout[13] AO22HDLLX1
XU60 n84 VSS VDD_1V8 n82 q[75] q[14] Dout[14] AO22HDLLX1
XU59 n84 VSS VDD_1V8 n82 q[76] q[15] Dout[15] AO22HDLLX1
XU58 n84 VSS VDD_1V8 n82 q[77] q[16] Dout[16] AO22HDLLX1
XU57 n84 VSS VDD_1V8 n82 q[78] q[17] Dout[17] AO22HDLLX1
XU56 n84 VSS VDD_1V8 n82 q[79] q[18] Dout[18] AO22HDLLX1
XU55 n84 VSS VDD_1V8 n82 q[80] q[19] Dout[19] AO22HDLLX1
XU54 n84 VSS VDD_1V8 n82 q[81] q[20] Dout[20] AO22HDLLX1
XU53 n84 VSS VDD_1V8 n82 q[82] q[21] Dout[21] AO22HDLLX1
XU52 n84 VSS VDD_1V8 n82 q[83] q[22] Dout[22] AO22HDLLX1
XU51 n84 VSS VDD_1V8 n82 q[84] q[23] Dout[23] AO22HDLLX1
XU50 n84 VSS VDD_1V8 n82 q[85] q[24] Dout[24] AO22HDLLX1
XU49 n84 VSS VDD_1V8 n82 q[86] q[25] Dout[25] AO22HDLLX1
XU48 n84 VSS VDD_1V8 n82 q[87] q[26] Dout[26] AO22HDLLX1
XU47 n84 VSS VDD_1V8 n82 q[88] q[27] Dout[27] AO22HDLLX1
XU46 n84 VSS VDD_1V8 n82 q[89] q[28] Dout[28] AO22HDLLX1
XU45 n84 VSS VDD_1V8 n82 q[90] q[29] Dout[29] AO22HDLLX1
Xplace3 n81 VSS VDD_1V8 IN64 INHDLLX1
Xplace6 VSS VDD_1V8 n84 n6 BUHDLLX0
Xplace5 VSS VDD_1V8 n83 n3 BUHDLLX0
Xplace4 VSS VDD_1V8 n82 n3 BUHDLLX0
Xplace7 VSS VDD_1V8 n85 n6 BUHDLLX0
.ENDS

.SUBCKT fifo_flops_no_full_depth2_bits65_1 Din[64] Din[63] Din[62] Din[61] Din[60]
+ Din[59] Din[58] Din[57] Din[56] Din[55] Din[54] Din[53] Din[52] Din[51] Din[50]
+ Din[49] Din[48] Din[47] Din[46] Din[45] Din[44] Din[43] Din[42] Din[41] Din[40]
+ Din[39] Din[38] Din[37] Din[36] Din[35] Din[34] Din[33] Din[32] Din[31] Din[30]
+ Din[29] Din[28] Din[27] Din[26] Din[25] Din[24] Din[23] Din[22] Din[21] Din[20]
+ Din[19] Din[18] Din[17] Din[16] Din[15] Din[14] Din[13] Din[12] Din[11] Din[10]
+ Din[9] Din[8] Din[7] Din[6] Din[5] Din[4] Din[3] Din[2] Din[1] Din[0] Dout[64]
+ Dout[63] Dout[62] Dout[61] Dout[60] Dout[59] Dout[58] Dout[57] Dout[56] Dout[55]
+ Dout[54] Dout[53] Dout[52] Dout[51] Dout[50] Dout[49] Dout[48] Dout[47] Dout[46]
+ Dout[45] Dout[44] Dout[43] Dout[42] Dout[41] Dout[40] Dout[39] Dout[38] Dout[37]
+ Dout[36] Dout[35] Dout[34] Dout[33] Dout[32] Dout[31] Dout[30] Dout[29] Dout[28]
+ Dout[27] Dout[26] Dout[25] Dout[24] Dout[23] Dout[22] Dout[21] Dout[20] Dout[19]
+ Dout[18] Dout[17] Dout[16] Dout[15] Dout[14] Dout[13] Dout[12] Dout[11] Dout[10]
+ Dout[9] Dout[8] Dout[7] Dout[6] Dout[5] Dout[4] Dout[3] Dout[2] Dout[1] Dout[0]
+ push pop clk pndng rst VSS VDD_1V8 IN0 IN1 IN2 IN3 IN4 IN5 IN6 IN7 IN8 IN9 IN10
+ IN11 IN12 IN13 IN14 IN15 IN16 IN17 IN18 IN19 IN20 IN21 IN22 IN23 IN24 IN25 IN26
+ IN27 IN28 IN29 IN30 IN31 IN32 IN33 IN34 IN35 IN36 IN37 IN38 IN39 IN40 IN41 IN42
+ IN43 IN44 IN45 IN46 IN47 IN48 IN49 IN50 IN51 IN52 IN53 IN54 IN55 IN56 IN57 IN58
+ IN59 IN60 IN61 IN62 IN63 IN64 IN65 IN66 IN67 IN68 IN69 IN70 IN71 IN72 IN73 IN74
+ IN75 IN76 IN77 IN78 IN79 IN80 IN81 IN82 IN83 IN84 IN85 IN86 IN87 IN88 IN89 IN90
+ IN91 IN92 IN93 IN94 IN95 IN96 IN97 IN98 IN99 IN100 IN101 IN102 IN103 IN104 clk_cts_4
Xu_dp__1___dp3__D_reg clk_gen_G4B2I2 IN0 VSS q[63] q[62] q[61] q[60] q[59] q[58]
+ q[57] q[56] q[55] q[54] q[53] q[52] q[51] q[50] q[49] q[48] q[47] q[46] q[45]
+ q[44] q[43] q[42] q[41] q[40] q[39] q[38] q[37] q[36] q[35] q[34] q[33] q[32]
+ q[31] q[30] q[29] q[28] q[27] q[26] q[25] q[24] q[23] q[22] q[21] q[20] q[19]
+ q[18] q[17] q[16] q[15] q[14] q[13] q[12] q[11] q[10] q[9] q[8] q[7] q[6] q[5]
+ q[4] q[3] q[2] q[1] q[0] SYNOPSYS_UNCONNECTED_1 q[127] q[126] q[125] q[124] q[123]
+ q[122] q[121] q[120] q[119] q[118] q[117] q[116] q[115] q[114] q[113] q[112] q[111]
+ q[110] q[109] q[108] q[107] q[106] q[105] q[104] q[103] q[102] q[101] q[100] q[99]
+ q[98] q[97] q[96] q[95] q[94] q[93] q[92] q[91] q[90] q[89] q[88] q[87] q[86]
+ q[85] q[84] q[83] q[82] q[81] q[80] q[79] q[78] q[77] q[76] q[75] q[74] q[73]
+ q[72] q[71] q[70] q[69] q[68] q[67] q[66] q[65] q[64] VSS VDD_1V8 IN23 IN24 IN25
+ IN26 IN27 IN28 IN29 IN31 IN32 IN33 IN36 IN37 IN41 IN59 IN60 IN61 IN62 IN63 IN64
+ IN65 IN66 IN67 IN68 IN69 IN70 IN71 IN72 IN73 IN75 IN81 IN82 IN83 IN84 IN85 IN86
+ IN87 IN88 IN89 IN90 IN91 IN92 IN94 IN95 IN103 clk_gen_G4B2I1 prll_d_reg_bits65_2
Xu_dp__0___dp2__D_reg clk_gen_G4B2I2 rst VSS Din[63] Din[62] Din[61] Din[60] Din[59]
+ Din[58] Din[57] Din[56] Din[55] Din[54] Din[53] Din[52] Din[51] Din[50] Din[49]
+ Din[48] Din[47] Din[46] Din[45] Din[44] Din[43] Din[42] Din[41] Din[40] Din[39]
+ Din[38] Din[37] Din[36] Din[35] Din[34] Din[33] Din[32] Din[31] Din[30] Din[29]
+ Din[28] Din[27] Din[26] Din[25] Din[24] Din[23] Din[22] Din[21] Din[20] Din[19]
+ Din[18] Din[17] Din[16] Din[15] Din[14] Din[13] Din[12] Din[11] Din[10] Din[9]
+ Din[8] Din[7] Din[6] Din[5] Din[4] Din[3] Din[2] Din[1] Din[0] SYNOPSYS_UNCONNECTED_2
+ q[63] q[62] q[61] q[60] q[59] q[58] q[57] q[56] q[55] q[54] q[53] q[52] q[51]
+ q[50] q[49] q[48] q[47] q[46] q[45] q[44] q[43] q[42] q[41] q[40] q[39] q[38]
+ q[37] q[36] q[35] q[34] q[33] q[32] q[31] q[30] q[29] q[28] q[27] q[26] q[25]
+ q[24] q[23] q[22] q[21] q[20] q[19] q[18] q[17] q[16] q[15] q[14] q[13] q[12]
+ q[11] q[10] q[9] q[8] q[7] q[6] q[5] q[4] q[3] q[2] q[1] q[0] VSS VDD_1V8 IN1
+ IN2 IN3 IN4 IN5 IN6 IN7 IN8 IN9 IN10 IN11 IN12 IN13 IN14 IN15 IN16 IN17 IN18 IN19
+ IN20 IN21 IN22 IN30 IN34 IN35 IN38 IN39 IN40 IN42 IN43 IN44 IN45 IN46 IN47 IN48
+ IN49 IN50 IN51 IN52 IN53 IN54 IN55 IN56 IN57 IN58 IN74 IN76 IN77 IN78 IN79 IN93
+ IN96 IN97 IN98 IN99 IN100 IN101 IN102 IN104 clk_gen_G4B2I1 prll_d_reg_bits65_3
XU80 VSS clk_gen clk_cts_4 n11 VDD_1V8 NO2HDLLX2
XINHDLLX3_G4B2I1 clk_gen_G4B1I1 VSS VDD_1V8 clk_gen INHDLLX2
XINHDLLX12_G4B1I2 VDD_1V8 VSS clk_gen_G4B2I2 clk_gen_G4B1I1 INHDLLX12
XINHDLLX6_G4B1I1 VSS VDD_1V8 clk_gen_G4B1I1 clk_gen_G4B2I1 INHDLLX6
XU56 n6 VSS VDD_1V8 n3 q[85] q[21] Dout[21] AO22HDLLX1
XU55 n6 VSS VDD_1V8 n3 q[86] q[22] Dout[22] AO22HDLLX1
XU54 n6 VSS VDD_1V8 n122 q[87] q[23] Dout[23] AO22HDLLX1
XU53 n6 VSS VDD_1V8 n3 q[88] q[24] Dout[24] AO22HDLLX1
XU52 n6 VSS VDD_1V8 n3 q[89] q[25] Dout[25] AO22HDLLX1
XU51 n6 VSS VDD_1V8 n3 q[90] q[26] Dout[26] AO22HDLLX1
XU50 n6 VSS VDD_1V8 n3 q[91] q[27] Dout[27] AO22HDLLX1
XU49 n6 VSS VDD_1V8 n3 q[92] q[28] Dout[28] AO22HDLLX1
XU48 n6 VSS VDD_1V8 n3 q[93] q[29] Dout[29] AO22HDLLX1
XU47 n6 VSS VDD_1V8 n3 q[94] q[30] Dout[30] AO22HDLLX1
XU46 n6 VSS VDD_1V8 n3 q[95] q[31] Dout[31] AO22HDLLX1
XU45 n125 VSS VDD_1V8 n122 q[96] q[32] Dout[32] AO22HDLLX1
XU44 n125 VSS VDD_1V8 n122 q[97] q[33] Dout[33] AO22HDLLX1
XU43 n125 VSS VDD_1V8 n122 q[98] q[34] Dout[34] AO22HDLLX1
XU42 n125 VSS VDD_1V8 n122 q[99] q[35] Dout[35] AO22HDLLX1
XU41 n125 VSS VDD_1V8 n122 q[100] q[36] Dout[36] AO22HDLLX1
XU40 n125 VSS VDD_1V8 n122 q[101] q[37] Dout[37] AO22HDLLX1
XU39 n125 VSS VDD_1V8 n122 q[102] q[38] Dout[38] AO22HDLLX1
XU38 n125 VSS VDD_1V8 n122 q[103] q[39] Dout[39] AO22HDLLX1
XU37 n125 VSS VDD_1V8 n122 q[104] q[40] Dout[40] AO22HDLLX1
XU36 n125 VSS VDD_1V8 n122 q[105] q[41] Dout[41] AO22HDLLX1
XU35 n125 VSS VDD_1V8 n122 q[106] q[42] Dout[42] AO22HDLLX1
XU34 n125 VSS VDD_1V8 n122 q[107] q[43] Dout[43] AO22HDLLX1
XU33 n125 VSS VDD_1V8 n122 q[108] q[44] Dout[44] AO22HDLLX1
XU32 n125 VSS VDD_1V8 n122 q[109] q[45] Dout[45] AO22HDLLX1
XU31 n125 VSS VDD_1V8 n122 q[110] q[46] Dout[46] AO22HDLLX1
XU30 n125 VSS VDD_1V8 n122 q[111] q[47] Dout[47] AO22HDLLX1
XU29 n125 VSS VDD_1V8 n122 q[112] q[48] Dout[48] AO22HDLLX1
XU28 n125 VSS VDD_1V8 n122 q[113] q[49] Dout[49] AO22HDLLX1
XU27 n125 VSS VDD_1V8 n122 q[114] q[50] Dout[50] AO22HDLLX1
XU26 n125 VSS VDD_1V8 n122 q[115] q[51] Dout[51] AO22HDLLX1
XU25 n125 VSS VDD_1V8 n122 q[116] q[52] Dout[52] AO22HDLLX1
XU24 n125 VSS VDD_1V8 n122 q[117] q[53] Dout[53] AO22HDLLX1
XU23 n125 VSS VDD_1V8 n122 q[118] q[54] Dout[54] AO22HDLLX1
XU22 n125 VSS VDD_1V8 n122 q[119] q[55] Dout[55] AO22HDLLX1
XU21 n125 VSS VDD_1V8 n122 q[120] q[56] Dout[56] AO22HDLLX1
XU20 n125 VSS VDD_1V8 n122 q[121] q[57] Dout[57] AO22HDLLX1
XU19 n125 VSS VDD_1V8 n122 q[122] q[58] Dout[58] AO22HDLLX1
XU18 n125 VSS VDD_1V8 n122 q[123] q[59] Dout[59] AO22HDLLX1
XU17 n125 VSS VDD_1V8 n122 q[124] q[60] Dout[60] AO22HDLLX1
XU16 n125 VSS VDD_1V8 n122 q[125] q[61] Dout[61] AO22HDLLX1
XU15 n125 VSS VDD_1V8 n122 q[126] q[62] Dout[62] AO22HDLLX1
XU14 n125 VSS VDD_1V8 n122 q[127] q[63] Dout[63] AO22HDLLX1
XU13 VSS n3 n8 count_1_ VDD_1V8 NO2HDLLX1
XU12 VSS n6 n25 n4 VDD_1V8 NO2HDLLX1
XU9 n12 n11 n8 VSS VDD_1V8 pop n2 AN31HDLLX0
XU8 VSS VDD_1V8 n2 count_1_ n1 n4 MU2IHDLLX0
XU7 n1 VSS VDD_1V8 n8 n11 pop NO3HDLLX0
XU6 n4 VSS VDD_1V8 count_1_ INHDLLX0
XU5 n11 VSS VDD_1V8 push INHDLLX0
Xcount_reg_0_ IN80 clk n13 n25 n8 VSS VDD_1V8 DFRRHDLLX0
Xcount_reg_1_ IN80 clk n12 count_1_ VSS VDD_1V8 DFRRQHDLLX0
XU84 VSS n13 VDD_1V8 n10 pndng n14 ON21HDLLX0
XU83 n10 VSS VDD_1V8 n6 n5 n7 n14 n25 AN32HDLLX0
XU82 n5 VSS VDD_1V8 n7 INHDLLX0
XU81 VSS pop n11 VDD_1V8 n7 NA2HDLLX0
XU79 n14 VSS pop VDD_1V8 push NA2I1HDLLX0
XU78 VSS n8 n4 VDD_1V8 pndng NA2HDLLX0
XU77 n125 VSS VDD_1V8 n122 q[64] q[0] Dout[0] AO22HDLLX1
XU76 n6 VSS VDD_1V8 n122 q[65] q[1] Dout[1] AO22HDLLX1
XU75 n125 VSS VDD_1V8 n122 q[66] q[2] Dout[2] AO22HDLLX1
XU74 n6 VSS VDD_1V8 n3 q[67] q[3] Dout[3] AO22HDLLX1
XU73 n6 VSS VDD_1V8 n3 q[68] q[4] Dout[4] AO22HDLLX1
XU72 n6 VSS VDD_1V8 n3 q[69] q[5] Dout[5] AO22HDLLX1
XU71 n125 VSS VDD_1V8 n122 q[70] q[6] Dout[6] AO22HDLLX1
XU70 n6 VSS VDD_1V8 n122 q[71] q[7] Dout[7] AO22HDLLX1
XU69 n6 VSS VDD_1V8 n3 q[72] q[8] Dout[8] AO22HDLLX1
XU68 n6 VSS VDD_1V8 n3 q[73] q[9] Dout[9] AO22HDLLX1
XU67 n6 VSS VDD_1V8 n3 q[74] q[10] Dout[10] AO22HDLLX1
XU66 n6 VSS VDD_1V8 n3 q[75] q[11] Dout[11] AO22HDLLX1
XU65 n6 VSS VDD_1V8 n3 q[76] q[12] Dout[12] AO22HDLLX1
XU64 n6 VSS VDD_1V8 n3 q[77] q[13] Dout[13] AO22HDLLX1
XU63 n6 VSS VDD_1V8 n3 q[78] q[14] Dout[14] AO22HDLLX1
XU62 n6 VSS VDD_1V8 n3 q[79] q[15] Dout[15] AO22HDLLX1
XU61 n6 VSS VDD_1V8 n122 q[80] q[16] Dout[16] AO22HDLLX1
XU60 n6 VSS VDD_1V8 n3 q[81] q[17] Dout[17] AO22HDLLX1
XU59 n6 VSS VDD_1V8 n3 q[82] q[18] Dout[18] AO22HDLLX1
XU58 n6 VSS VDD_1V8 n3 q[83] q[19] Dout[19] AO22HDLLX1
XU57 n6 VSS VDD_1V8 n3 q[84] q[20] Dout[20] AO22HDLLX1
Xplace7 VSS VDD_1V8 n125 n6 BUHDLLX0
Xplace4 VSS VDD_1V8 n122 n3 BUHDLLX0
.ENDS

.SUBCKT fifo_flops_no_full_depth2_bits65_0 Din[64] Din[63] Din[62] Din[61] Din[60]
+ Din[59] Din[58] Din[57] Din[56] Din[55] Din[54] Din[53] Din[52] Din[51] Din[50]
+ Din[49] Din[48] Din[47] Din[46] Din[45] Din[44] Din[43] Din[42] Din[41] Din[40]
+ Din[39] Din[38] Din[37] Din[36] Din[35] Din[34] Din[33] Din[32] Din[31] Din[30]
+ Din[29] Din[28] Din[27] Din[26] Din[25] Din[24] Din[23] Din[22] Din[21] Din[20]
+ Din[19] Din[18] Din[17] Din[16] Din[15] Din[14] Din[13] Din[12] Din[11] Din[10]
+ Din[9] Din[8] Din[7] Din[6] Din[5] Din[4] Din[3] Din[2] Din[1] Din[0] Dout[64]
+ Dout[63] Dout[62] Dout[61] Dout[60] Dout[59] Dout[58] Dout[57] Dout[56] Dout[55]
+ Dout[54] Dout[53] Dout[52] Dout[51] Dout[50] Dout[49] Dout[48] Dout[47] Dout[46]
+ Dout[45] Dout[44] Dout[43] Dout[42] Dout[41] Dout[40] Dout[39] Dout[38] Dout[37]
+ Dout[36] Dout[35] Dout[34] Dout[33] Dout[32] Dout[31] Dout[30] Dout[29] Dout[28]
+ Dout[27] Dout[26] Dout[25] Dout[24] Dout[23] Dout[22] Dout[21] Dout[20] Dout[19]
+ Dout[18] Dout[17] Dout[16] Dout[15] Dout[14] Dout[13] Dout[12] Dout[11] Dout[10]
+ Dout[9] Dout[8] Dout[7] Dout[6] Dout[5] Dout[4] Dout[3] Dout[2] Dout[1] Dout[0]
+ push pop clk pndng rst VSS VDD_1V8 clk_cts_4
Xu_dp__1___dp3__D_reg clk_gen_G4B2I2 n17 VSS q[63] q[62] q[61] q[60] q[59] q[58]
+ q[57] q[56] q[55] q[54] q[53] q[52] q[51] q[50] q[49] q[48] q[47] q[46] q[45]
+ q[44] q[43] q[42] q[41] q[40] q[39] q[38] q[37] q[36] q[35] q[34] q[33] q[32]
+ q[31] q[30] q[29] q[28] q[27] q[26] q[25] q[24] q[23] q[22] q[21] q[20] q[19]
+ q[18] q[17] q[16] q[15] q[14] q[13] q[12] q[11] q[10] q[9] q[8] q[7] q[6] q[5]
+ q[4] q[3] q[2] q[1] q[0] SYNOPSYS_UNCONNECTED_1 q[127] q[126] q[125] q[124] q[123]
+ q[122] q[121] q[120] q[119] q[118] q[117] q[116] q[115] q[114] q[113] q[112] q[111]
+ q[110] q[109] q[108] q[107] q[106] q[105] q[104] q[103] q[102] q[101] q[100] q[99]
+ q[98] q[97] q[96] q[95] q[94] q[93] q[92] q[91] q[90] q[89] q[88] q[87] q[86]
+ q[85] q[84] q[83] q[82] q[81] q[80] q[79] q[78] q[77] q[76] q[75] q[74] q[73]
+ q[72] q[71] q[70] q[69] q[68] q[67] q[66] q[65] q[64] VSS VDD_1V8 n16 n16 n16
+ n16 n16 n16 n16 n16 n16 n16 n16 n16 n16 n16 n16 n16 n16 n16 n10 n10 n10 n10 n10
+ n10 n10 n10 n10 n10 n10 n10 n10 n10 n10 n10 n10 n10 n10 n10 n10 n10 n10 n10 n10
+ n10 clk_gen_G4B2I1 prll_d_reg_bits65_0
Xu_dp__0___dp2__D_reg clk_gen_G4B2I2 n17 VSS Din[63] Din[62] Din[61] Din[60] Din[59]
+ Din[58] Din[57] Din[56] Din[55] Din[54] Din[53] Din[52] Din[51] Din[50] Din[49]
+ Din[48] Din[47] Din[46] Din[45] Din[44] Din[43] Din[42] Din[41] Din[40] Din[39]
+ Din[38] Din[37] Din[36] Din[35] Din[34] Din[33] Din[32] Din[31] Din[30] Din[29]
+ Din[28] Din[27] Din[26] Din[25] Din[24] Din[23] Din[22] Din[21] Din[20] Din[19]
+ Din[18] Din[17] Din[16] Din[15] Din[14] Din[13] Din[12] Din[11] Din[10] Din[9]
+ Din[8] Din[7] Din[6] Din[5] Din[4] Din[3] Din[2] Din[1] Din[0] SYNOPSYS_UNCONNECTED_2
+ q[63] q[62] q[61] q[60] q[59] q[58] q[57] q[56] q[55] q[54] q[53] q[52] q[51]
+ q[50] q[49] q[48] q[47] q[46] q[45] q[44] q[43] q[42] q[41] q[40] q[39] q[38]
+ q[37] q[36] q[35] q[34] q[33] q[32] q[31] q[30] q[29] q[28] q[27] q[26] q[25]
+ q[24] q[23] q[22] q[21] q[20] q[19] q[18] q[17] q[16] q[15] q[14] q[13] q[12]
+ q[11] q[10] q[9] q[8] q[7] q[6] q[5] q[4] q[3] q[2] q[1] q[0] VSS VDD_1V8 n16
+ n16 n16 n16 n16 n16 n16 n16 n16 n16 n16 n16 n16 n16 n16 n16 n16 n16 n10 n10 n10
+ n10 n10 n10 n10 n10 n10 n10 n10 n10 n10 n10 n10 n10 n10 n10 n10 n10 n10 n10 n10
+ n10 n10 clk_gen_G4B2I1 prll_d_reg_bits65_1
XINHDLLX2_G4B2I1 clk_gen_G4B1I1 VSS VDD_1V8 clk_gen INHDLLX2
XINHDLLX8_G4B1I2 VSS VDD_1V8 clk_gen_G4B2I2 clk_gen_G4B1I1 INHDLLX8
XINHDLLX6_G4B1I1 VSS VDD_1V8 clk_gen_G4B1I1 clk_gen_G4B2I1 INHDLLX6
XU82 VSS clk_gen clk_cts_4 n11 VDD_1V8 NO2HDLLX4
XU65 n21 VSS VDD_1V8 n4 q[76] q[12] Dout[12] AO22HDLLX1
XU64 n21 VSS VDD_1V8 n4 q[77] q[13] Dout[13] AO22HDLLX1
XU63 n21 VSS VDD_1V8 n4 q[78] q[14] Dout[14] AO22HDLLX1
XU62 n21 VSS VDD_1V8 n4 q[79] q[15] Dout[15] AO22HDLLX1
XU61 n21 VSS VDD_1V8 n4 q[80] q[16] Dout[16] AO22HDLLX1
XU60 n21 VSS VDD_1V8 n4 q[81] q[17] Dout[17] AO22HDLLX1
XU59 n21 VSS VDD_1V8 n4 q[82] q[18] Dout[18] AO22HDLLX1
XU58 n21 VSS VDD_1V8 n4 q[83] q[19] Dout[19] AO22HDLLX1
XU57 n21 VSS VDD_1V8 n4 q[84] q[20] Dout[20] AO22HDLLX1
XU56 n21 VSS VDD_1V8 n4 q[85] q[21] Dout[21] AO22HDLLX1
XU55 n21 VSS VDD_1V8 n4 q[86] q[22] Dout[22] AO22HDLLX1
XU54 n21 VSS VDD_1V8 n4 q[87] q[23] Dout[23] AO22HDLLX1
XU53 n7 VSS VDD_1V8 n18 q[88] q[24] Dout[24] AO22HDLLX1
XU52 n7 VSS VDD_1V8 n18 q[89] q[25] Dout[25] AO22HDLLX1
XU51 n7 VSS VDD_1V8 n18 q[90] q[26] Dout[26] AO22HDLLX1
XU50 n7 VSS VDD_1V8 n18 q[91] q[27] Dout[27] AO22HDLLX1
XU49 n21 VSS VDD_1V8 n4 q[92] q[28] Dout[28] AO22HDLLX1
XU48 n7 VSS VDD_1V8 n18 q[93] q[29] Dout[29] AO22HDLLX1
XU47 n7 VSS VDD_1V8 n18 q[94] q[30] Dout[30] AO22HDLLX1
XU46 n21 VSS VDD_1V8 n4 q[95] q[31] Dout[31] AO22HDLLX1
XU45 n7 VSS VDD_1V8 n18 q[96] q[32] Dout[32] AO22HDLLX1
XU44 n7 VSS VDD_1V8 n18 q[97] q[33] Dout[33] AO22HDLLX1
XU43 n7 VSS VDD_1V8 n18 q[98] q[34] Dout[34] AO22HDLLX1
XU42 n7 VSS VDD_1V8 n18 q[99] q[35] Dout[35] AO22HDLLX1
XU41 n7 VSS VDD_1V8 n18 q[100] q[36] Dout[36] AO22HDLLX1
XU40 n7 VSS VDD_1V8 n18 q[101] q[37] Dout[37] AO22HDLLX1
XU39 n7 VSS VDD_1V8 n18 q[102] q[38] Dout[38] AO22HDLLX1
XU38 n7 VSS VDD_1V8 n18 q[103] q[39] Dout[39] AO22HDLLX1
XU37 n7 VSS VDD_1V8 n18 q[104] q[40] Dout[40] AO22HDLLX1
XU36 n7 VSS VDD_1V8 n18 q[105] q[41] Dout[41] AO22HDLLX1
XU35 n7 VSS VDD_1V8 n18 q[106] q[42] Dout[42] AO22HDLLX1
XU34 n7 VSS VDD_1V8 n18 q[107] q[43] Dout[43] AO22HDLLX1
XU33 n7 VSS VDD_1V8 n18 q[108] q[44] Dout[44] AO22HDLLX1
XU32 n7 VSS VDD_1V8 n18 q[109] q[45] Dout[45] AO22HDLLX1
XU31 n7 VSS VDD_1V8 n18 q[110] q[46] Dout[46] AO22HDLLX1
XU30 n7 VSS VDD_1V8 n18 q[111] q[47] Dout[47] AO22HDLLX1
XU29 n7 VSS VDD_1V8 n18 q[112] q[48] Dout[48] AO22HDLLX1
XU28 n7 VSS VDD_1V8 n18 q[113] q[49] Dout[49] AO22HDLLX1
XU27 n7 VSS VDD_1V8 n18 q[114] q[50] Dout[50] AO22HDLLX1
XU26 n7 VSS VDD_1V8 n18 q[115] q[51] Dout[51] AO22HDLLX1
XU25 n7 VSS VDD_1V8 n18 q[116] q[52] Dout[52] AO22HDLLX1
XU24 n7 VSS VDD_1V8 n18 q[117] q[53] Dout[53] AO22HDLLX1
XU23 n7 VSS VDD_1V8 n18 q[118] q[54] Dout[54] AO22HDLLX1
XU22 n7 VSS VDD_1V8 n18 q[119] q[55] Dout[55] AO22HDLLX1
XU21 n7 VSS VDD_1V8 n18 q[120] q[56] Dout[56] AO22HDLLX1
XU20 n7 VSS VDD_1V8 n18 q[121] q[57] Dout[57] AO22HDLLX1
XU19 n7 VSS VDD_1V8 n18 q[122] q[58] Dout[58] AO22HDLLX1
XU18 n7 VSS VDD_1V8 n18 q[123] q[59] Dout[59] AO22HDLLX1
XU17 n7 VSS VDD_1V8 n18 q[124] q[60] Dout[60] AO22HDLLX1
XU16 n7 VSS VDD_1V8 n18 q[125] q[61] Dout[61] AO22HDLLX1
XU15 n7 VSS VDD_1V8 n18 q[126] q[62] Dout[62] AO22HDLLX1
XU14 n7 VSS VDD_1V8 n18 q[127] q[63] Dout[63] AO22HDLLX1
XU13 VSS n4 n8 count_1_ VDD_1V8 NO2HDLLX1
XU12 VSS n7 n24 n5 VDD_1V8 NO2HDLLX1
XU9 n12 n11 n8 VSS VDD_1V8 pop n3 AN31HDLLX0
XU8 VSS VDD_1V8 n3 count_1_ n2 n5 MU2IHDLLX0
XU7 n2 VSS VDD_1V8 n8 n11 pop NO3HDLLX0
XU6 n5 VSS VDD_1V8 count_1_ INHDLLX0
XU5 n11 VSS VDD_1V8 push INHDLLX0
Xcount_reg_0_ n10 clk n13 n24 n8 VSS VDD_1V8 DFRRHDLLX0
Xcount_reg_1_ n10 clk n12 count_1_ VSS VDD_1V8 DFRRQHDLLX0
XU84 VSS n13 VDD_1V8 n14 pndng n15 ON21HDLLX0
XU83 n14 VSS VDD_1V8 n7 n6 n9 n15 n24 AN32HDLLX0
XU81 n6 VSS VDD_1V8 n9 INHDLLX0
XU80 VSS pop n11 VDD_1V8 n9 NA2HDLLX0
XU79 n15 VSS pop VDD_1V8 push NA2I1HDLLX0
XU78 VSS n8 n5 VDD_1V8 pndng NA2HDLLX0
XU77 n21 VSS VDD_1V8 n4 q[64] q[0] Dout[0] AO22HDLLX1
XU76 n21 VSS VDD_1V8 n4 q[65] q[1] Dout[1] AO22HDLLX1
XU75 n21 VSS VDD_1V8 n4 q[66] q[2] Dout[2] AO22HDLLX1
XU74 n21 VSS VDD_1V8 n4 q[67] q[3] Dout[3] AO22HDLLX1
XU73 n21 VSS VDD_1V8 n4 q[68] q[4] Dout[4] AO22HDLLX1
XU72 n21 VSS VDD_1V8 n4 q[69] q[5] Dout[5] AO22HDLLX1
XU71 n21 VSS VDD_1V8 n4 q[70] q[6] Dout[6] AO22HDLLX1
XU70 n21 VSS VDD_1V8 n4 q[71] q[7] Dout[7] AO22HDLLX1
XU69 n21 VSS VDD_1V8 n4 q[72] q[8] Dout[8] AO22HDLLX1
XU68 n21 VSS VDD_1V8 n4 q[73] q[9] Dout[9] AO22HDLLX1
XU67 n21 VSS VDD_1V8 n4 q[74] q[10] Dout[10] AO22HDLLX1
XU66 n21 VSS VDD_1V8 n4 q[75] q[11] Dout[11] AO22HDLLX1
Xplace5 n17 VSS VDD_1V8 rst INHDLLX1
Xplace4 n16 VSS VDD_1V8 rst INHDLLX1
Xplace3 n10 VSS VDD_1V8 rst INHDLLX1
Xplace9 VSS VDD_1V8 n21 n7 BUHDLLX0
Xplace6 VSS VDD_1V8 n18 n4 BUHDLLX0
.ENDS

.SUBCKT uart sys_clk sys_rst_l TX_UART RX_UART pndng_T D_pop_fT[64] D_pop_fT[63]
+ D_pop_fT[62] D_pop_fT[61] D_pop_fT[60] D_pop_fT[59] D_pop_fT[58] D_pop_fT[57]
+ D_pop_fT[56] D_pop_fT[55] D_pop_fT[54] D_pop_fT[53] D_pop_fT[52] D_pop_fT[51]
+ D_pop_fT[50] D_pop_fT[49] D_pop_fT[48] D_pop_fT[47] D_pop_fT[46] D_pop_fT[45]
+ D_pop_fT[44] D_pop_fT[43] D_pop_fT[42] D_pop_fT[41] D_pop_fT[40] D_pop_fT[39]
+ D_pop_fT[38] D_pop_fT[37] D_pop_fT[36] D_pop_fT[35] D_pop_fT[34] D_pop_fT[33]
+ D_pop_fT[32] D_pop_fT[31] D_pop_fT[30] D_pop_fT[29] D_pop_fT[28] D_pop_fT[27]
+ D_pop_fT[26] D_pop_fT[25] D_pop_fT[24] D_pop_fT[23] D_pop_fT[22] D_pop_fT[21]
+ D_pop_fT[20] D_pop_fT[19] D_pop_fT[18] D_pop_fT[17] D_pop_fT[16] D_pop_fT[15]
+ D_pop_fT[14] D_pop_fT[13] D_pop_fT[12] D_pop_fT[11] D_pop_fT[10] D_pop_fT[9] D_pop_fT[8]
+ D_pop_fT[7] D_pop_fT[6] D_pop_fT[5] D_pop_fT[4] D_pop_fT[3] D_pop_fT[2] D_pop_fT[1]
+ D_pop_fT[0] pop_T D_push_fR[64] D_push_fR[63] D_push_fR[62] D_push_fR[61] D_push_fR[60]
+ D_push_fR[59] D_push_fR[58] D_push_fR[57] D_push_fR[56] D_push_fR[55] D_push_fR[54]
+ D_push_fR[53] D_push_fR[52] D_push_fR[51] D_push_fR[50] D_push_fR[49] D_push_fR[48]
+ D_push_fR[47] D_push_fR[46] D_push_fR[45] D_push_fR[44] D_push_fR[43] D_push_fR[42]
+ D_push_fR[41] D_push_fR[40] D_push_fR[39] D_push_fR[38] D_push_fR[37] D_push_fR[36]
+ D_push_fR[35] D_push_fR[34] D_push_fR[33] D_push_fR[32] D_push_fR[31] D_push_fR[30]
+ D_push_fR[29] D_push_fR[28] D_push_fR[27] D_push_fR[26] D_push_fR[25] D_push_fR[24]
+ D_push_fR[23] D_push_fR[22] D_push_fR[21] D_push_fR[20] D_push_fR[19] D_push_fR[18]
+ D_push_fR[17] D_push_fR[16] D_push_fR[15] D_push_fR[14] D_push_fR[13] D_push_fR[12]
+ D_push_fR[11] D_push_fR[10] D_push_fR[9] D_push_fR[8] D_push_fR[7] D_push_fR[6]
+ D_push_fR[5] D_push_fR[4] D_push_fR[3] D_push_fR[2] D_push_fR[1] D_push_fR[0]
+ push_fR VSS VDD_1V8
Xutf_reg enable_reg[7] enable_reg[6] enable_reg[5] enable_reg[4] enable_reg[3] enable_reg[2]
+ enable_reg[1] enable_reg[0] rst CTS_1_G3B2I2 rec_dataH[7] rec_dataH[6] rec_dataH[5]
+ rec_dataH[4] rec_dataH[3] rec_dataH[2] rec_dataH[1] rec_dataH[0] D_push_fR[63]
+ D_push_fR[62] D_push_fR[61] D_push_fR[60] D_push_fR[59] D_push_fR[58] D_push_fR[57]
+ D_push_fR[56] D_push_fR[55] D_push_fR[54] D_push_fR[53] D_push_fR[52] D_push_fR[51]
+ D_push_fR[50] D_push_fR[49] D_push_fR[48] D_push_fR[47] D_push_fR[46] D_push_fR[45]
+ D_push_fR[44] D_push_fR[43] D_push_fR[42] D_push_fR[41] D_push_fR[40] D_push_fR[39]
+ D_push_fR[38] D_push_fR[37] D_push_fR[36] D_push_fR[35] D_push_fR[34] D_push_fR[33]
+ D_push_fR[32] D_push_fR[31] D_push_fR[30] D_push_fR[29] D_push_fR[28] D_push_fR[27]
+ D_push_fR[26] D_push_fR[25] D_push_fR[24] D_push_fR[23] D_push_fR[22] D_push_fR[21]
+ D_push_fR[20] D_push_fR[19] D_push_fR[18] D_push_fR[17] D_push_fR[16] D_push_fR[15]
+ D_push_fR[14] D_push_fR[13] D_push_fR[12] D_push_fR[11] D_push_fR[10] D_push_fR[9]
+ D_push_fR[8] D_push_fR[7] D_push_fR[6] D_push_fR[5] D_push_fR[4] D_push_fR[3]
+ D_push_fR[2] D_push_fR[1] D_push_fR[0] VSS VDD_1V8 uart_to_fifo_reg_pos_array8_data_fifo64_byte_out8
Xlog_utf n13 CTS_1_G3B2I2 rec_readyH n3 push_fR rst enable_reg[7] enable_reg[6]
+ enable_reg[5] enable_reg[4] enable_reg[3] enable_reg[2] enable_reg[1] enable_reg[0]
+ VSS VDD_1V8 n2 log_utf_pos_array8
Xu_rec n3 CTS_1_G3B2I2 n14 RX_UART rec_dataH[7] rec_dataH[6] rec_dataH[5] rec_dataH[4]
+ rec_dataH[3] rec_dataH[2] rec_dataH[1] rec_dataH[0] rec_readyH VSS VDD_1V8 n13
+ rec_dataH[7] rec_dataH[6] rec_dataH[5] rec_dataH[4] rec_dataH[3] rec_dataH[2]
+ rec_dataH[1] u_rec_WORD_LEN_PLUS19
Xu_xmit CTS_1_G3B2I1 n14 n4 xmit xmit_dataH[7] xmit_dataH[6] xmit_dataH[5] xmit_dataH[4]
+ xmit_dataH[3] xmit_dataH[2] xmit_dataH[1] xmit_dataH[0] TX_UART xmit_doneH VSS
+ VDD_1V8 n13 n1 u_xmit_WORD_LEN8
Xlog_ftu n14 CTS_1_G3B2I1 xmit_doneH pndng_T n4 Dout_ftu[63] Dout_ftu[62] Dout_ftu[61]
+ Dout_ftu[60] Dout_ftu[59] Dout_ftu[58] Dout_ftu[57] Dout_ftu[56] Dout_ftu[55]
+ Dout_ftu[54] Dout_ftu[53] Dout_ftu[52] Dout_ftu[51] Dout_ftu[50] Dout_ftu[49]
+ Dout_ftu[48] Dout_ftu[47] Dout_ftu[46] Dout_ftu[45] Dout_ftu[44] Dout_ftu[43]
+ Dout_ftu[42] Dout_ftu[41] Dout_ftu[40] Dout_ftu[39] Dout_ftu[38] Dout_ftu[37]
+ Dout_ftu[36] Dout_ftu[35] Dout_ftu[34] Dout_ftu[33] Dout_ftu[32] Dout_ftu[31]
+ Dout_ftu[30] Dout_ftu[29] Dout_ftu[28] Dout_ftu[27] Dout_ftu[26] Dout_ftu[25]
+ Dout_ftu[24] Dout_ftu[23] Dout_ftu[22] Dout_ftu[21] Dout_ftu[20] Dout_ftu[19]
+ Dout_ftu[18] Dout_ftu[17] Dout_ftu[16] Dout_ftu[15] Dout_ftu[14] Dout_ftu[13]
+ Dout_ftu[12] Dout_ftu[11] Dout_ftu[10] Dout_ftu[9] Dout_ftu[8] Dout_ftu[7] Dout_ftu[6]
+ Dout_ftu[5] Dout_ftu[4] Dout_ftu[3] Dout_ftu[2] Dout_ftu[1] Dout_ftu[0] xmit_dataH[7]
+ xmit_dataH[6] xmit_dataH[5] xmit_dataH[4] xmit_dataH[3] xmit_dataH[2] xmit_dataH[1]
+ xmit_dataH[0] xmit pop_T VSS VDD_1V8 n13 pop_T log_ftu_pos_array8_data_fifo64_byte_out8
Xftu_reg sys_clk pop_T n4 D_pop_fT[63] D_pop_fT[62] D_pop_fT[61] D_pop_fT[60] D_pop_fT[59]
+ D_pop_fT[58] D_pop_fT[57] D_pop_fT[56] D_pop_fT[55] D_pop_fT[54] D_pop_fT[53]
+ D_pop_fT[52] D_pop_fT[51] D_pop_fT[50] D_pop_fT[49] D_pop_fT[48] D_pop_fT[47]
+ D_pop_fT[46] D_pop_fT[45] D_pop_fT[44] D_pop_fT[43] D_pop_fT[42] D_pop_fT[41]
+ D_pop_fT[40] D_pop_fT[39] D_pop_fT[38] D_pop_fT[37] D_pop_fT[36] D_pop_fT[35]
+ D_pop_fT[34] D_pop_fT[33] D_pop_fT[32] D_pop_fT[31] D_pop_fT[30] D_pop_fT[29]
+ D_pop_fT[28] D_pop_fT[27] D_pop_fT[26] D_pop_fT[25] D_pop_fT[24] D_pop_fT[23]
+ D_pop_fT[22] D_pop_fT[21] D_pop_fT[20] D_pop_fT[19] D_pop_fT[18] D_pop_fT[17]
+ D_pop_fT[16] D_pop_fT[15] D_pop_fT[14] D_pop_fT[13] D_pop_fT[12] D_pop_fT[11]
+ D_pop_fT[10] D_pop_fT[9] D_pop_fT[8] D_pop_fT[7] D_pop_fT[6] D_pop_fT[5] D_pop_fT[4]
+ D_pop_fT[3] D_pop_fT[2] D_pop_fT[1] D_pop_fT[0] Dout_ftu[63] Dout_ftu[62] Dout_ftu[61]
+ Dout_ftu[60] Dout_ftu[59] Dout_ftu[58] Dout_ftu[57] Dout_ftu[56] Dout_ftu[55]
+ Dout_ftu[54] Dout_ftu[53] Dout_ftu[52] Dout_ftu[51] Dout_ftu[50] Dout_ftu[49]
+ Dout_ftu[48] Dout_ftu[47] Dout_ftu[46] Dout_ftu[45] Dout_ftu[44] Dout_ftu[43]
+ Dout_ftu[42] Dout_ftu[41] Dout_ftu[40] Dout_ftu[39] Dout_ftu[38] Dout_ftu[37]
+ Dout_ftu[36] Dout_ftu[35] Dout_ftu[34] Dout_ftu[33] Dout_ftu[32] Dout_ftu[31]
+ Dout_ftu[30] Dout_ftu[29] Dout_ftu[28] Dout_ftu[27] Dout_ftu[26] Dout_ftu[25]
+ Dout_ftu[24] Dout_ftu[23] Dout_ftu[22] Dout_ftu[21] Dout_ftu[20] Dout_ftu[19]
+ Dout_ftu[18] Dout_ftu[17] Dout_ftu[16] Dout_ftu[15] Dout_ftu[14] Dout_ftu[13]
+ Dout_ftu[12] Dout_ftu[11] Dout_ftu[10] Dout_ftu[9] Dout_ftu[8] Dout_ftu[7] Dout_ftu[6]
+ Dout_ftu[5] Dout_ftu[4] Dout_ftu[3] Dout_ftu[2] Dout_ftu[1] Dout_ftu[0] VSS VDD_1V8
+ pop_T n1 n1 n1 n1 n1 n1 n1 n1 n1 n1 n1 n1 fifo_to_uart_reg_pos_array8_data_fifo64_byte_out8
Xdetector_flanco CTS_1_G3B2I1 n4 uart_clk flag_sincr VSS VDD_1V8 detector_flanco
Xbaud CTS_1_G3B2I1 sys_rst_l uart_clk VSS VDD_1V8 baud_XTAL_CLK20000000_BAUD19200_CLK_DIV32_CW9
XINHDLLX3_G3B2I2 CTS_1_G3B1I2 VSS n25 VDD_1V8 INHDLLX3
XINHDLLX3_G3B2I1 CTS_1_G3B1I1 VSS VDD_1V8 n25 INHDLLX2
XBUHDLLX12_GB_MV n25 VSS VDD_1V8 sys_clk BUHDLLX3
XINHDLLX12_G3B1I2 VDD_1V8 VSS CTS_1_G3B2I2 CTS_1_G3B1I2 INHDLLX12
XINHDLLX6_G3B1I1 VSS VDD_1V8 CTS_1_G3B1I1 CTS_1_G3B2I1 INHDLLX6
Xplace2 n1 VSS VDD_1V8 sys_rst_l INHDLLX1
Xplace4 n3 VSS VDD_1V8 n2 INHDLLX0
Xplace3 VSS VDD_1V8 n2 sys_rst_l BUHDLLX0
Xplace5 n4 VSS VDD_1V8 sys_rst_l INHDLLX1
Xplace15 n14 VSS VDD_1V8 n13 INHDLLX1
Xplace14 VSS VDD_1V8 n13 flag_sincr BUHDLLX1
.ENDS

.SUBCKT Banco_registros_latches csr_id[3] csr_id[2] csr_id[1] csr_id[0] rs1[4] rs1[3]
+ rs1[2] rs1[1] rs1[0] rs2[4] rs2[3] rs2[2] rs2[1] rs2[0] rd[4] rd[3] rd[2] rd[1]
+ rd[0] csr_write reg_write_data[31] reg_write_data[30] reg_write_data[29] reg_write_data[28]
+ reg_write_data[27] reg_write_data[26] reg_write_data[25] reg_write_data[24] reg_write_data[23]
+ reg_write_data[22] reg_write_data[21] reg_write_data[20] reg_write_data[19] reg_write_data[18]
+ reg_write_data[17] reg_write_data[16] reg_write_data[15] reg_write_data[14] reg_write_data[13]
+ reg_write_data[12] reg_write_data[11] reg_write_data[10] reg_write_data[9] reg_write_data[8]
+ reg_write_data[7] reg_write_data[6] reg_write_data[5] reg_write_data[4] reg_write_data[3]
+ reg_write_data[2] reg_write_data[1] reg_write_data[0] write R1[31] R1[30] R1[29]
+ R1[28] R1[27] R1[26] R1[25] R1[24] R1[23] R1[22] R1[21] R1[20] R1[19] R1[18] R1[17]
+ R1[16] R1[15] R1[14] R1[13] R1[12] R1[11] R1[10] R1[9] R1[8] R1[7] R1[6] R1[5]
+ R1[4] R1[3] R1[2] R1[1] R1[0] R2[31] R2[30] R2[29] R2[28] R2[27] R2[26] R2[25]
+ R2[24] R2[23] R2[22] R2[21] R2[20] R2[19] R2[18] R2[17] R2[16] R2[15] R2[14] R2[13]
+ R2[12] R2[11] R2[10] R2[9] R2[8] R2[7] R2[6] R2[5] R2[4] R2[3] R2[2] R2[1] R2[0]
+ clk rst mip_IO mip_time mie_time mie_IO comparation[31] comparation[30] comparation[29]
+ comparation[28] comparation[27] comparation[26] comparation[25] comparation[24]
+ comparation[23] comparation[22] comparation[21] comparation[20] comparation[19]
+ comparation[18] comparation[17] comparation[16] comparation[15] comparation[14]
+ comparation[13] comparation[12] comparation[11] comparation[10] comparation[9]
+ comparation[8] comparation[7] comparation[6] comparation[5] comparation[4] comparation[3]
+ comparation[2] comparation[1] comparation[0] timer[31] timer[30] timer[29] timer[28]
+ timer[27] timer[26] timer[25] timer[24] timer[23] timer[22] timer[21] timer[20]
+ timer[19] timer[18] timer[17] timer[16] timer[15] timer[14] timer[13] timer[12]
+ timer[11] timer[10] timer[9] timer[8] timer[7] timer[6] timer[5] timer[4] timer[3]
+ timer[2] timer[1] timer[0] CSR[31] CSR[30] CSR[29] CSR[28] CSR[27] CSR[26] CSR[25]
+ CSR[24] CSR[23] CSR[22] CSR[21] CSR[20] CSR[19] CSR[18] CSR[17] CSR[16] CSR[15]
+ CSR[14] CSR[13] CSR[12] CSR[11] CSR[10] CSR[9] CSR[8] CSR[7] CSR[6] CSR[5] CSR[4]
+ CSR[3] CSR[2] CSR[1] CSR[0] full_range_level_shifter[7] full_range_level_shifter[6]
+ full_range_level_shifter[5] full_range_level_shifter[4] full_range_level_shifter[3]
+ full_range_level_shifter[2] full_range_level_shifter[1] full_range_level_shifter[0]
+ IS_Val[31] IS_Val[30] IS_Val[29] IS_Val[28] IS_Val[27] IS_Val[26] IS_Val[25] IS_Val[24]
+ IS_Val[23] IS_Val[22] IS_Val[21] IS_Val[20] IS_Val[19] IS_Val[18] IS_Val[17] IS_Val[16]
+ IS_Val[15] IS_Val[14] IS_Val[13] IS_Val[12] IS_Val[11] IS_Val[10] IS_Val[9] IS_Val[8]
+ IS_Val[7] IS_Val[6] IS_Val[5] IS_Val[4] IS_Val[3] IS_Val[2] IS_Val[1] IS_Val[0]
+ IS_Config[31] IS_Config[30] IS_Config[29] IS_Config[28] IS_Config[27] IS_Config[26]
+ IS_Config[25] IS_Config[24] IS_Config[23] IS_Config[22] IS_Config[21] IS_Config[20]
+ IS_Config[19] IS_Config[18] IS_Config[17] IS_Config[16] IS_Config[15] IS_Config[14]
+ IS_Config[13] IS_Config[12] IS_Config[11] IS_Config[10] IS_Config[9] IS_Config[8]
+ IS_Config[7] IS_Config[6] IS_Config[5] IS_Config[4] IS_Config[3] IS_Config[2]
+ IS_Config[1] IS_Config[0] IS_Trigger[3] IS_Trigger[2] IS_Trigger[1] IS_Trigger[0]
+ Mie_analogic mip_analogic Reg_GPIO_en[7] Reg_GPIO_en[6] Reg_GPIO_en[5] Reg_GPIO_en[4]
+ Reg_GPIO_en[3] Reg_GPIO_en[2] Reg_GPIO_en[1] Reg_GPIO_en[0] Reg_GPIO_int[7] Reg_GPIO_int[6]
+ Reg_GPIO_int[5] Reg_GPIO_int[4] Reg_GPIO_int[3] Reg_GPIO_int[2] Reg_GPIO_int[1]
+ Reg_GPIO_int[0] Reg_GPIO_out[7] Reg_GPIO_out[6] Reg_GPIO_out[5] Reg_GPIO_out[4]
+ Reg_GPIO_out[3] Reg_GPIO_out[2] Reg_GPIO_out[1] Reg_GPIO_out[0] VSS VDD_1V8 IN0
+ IN1 IN2 IN3 IN4 IN5 IN6 IN7 IN8 IN9 IN10 IN11 IN12 IN13 IN14 IN15 IN16 IN17 IN18
+ IN19 IN20 IN21 IN22 IN23 IN24 IN25 IN26 IN27 IN28 IN29 IN30 IN31 IN32 IN33 IN34
+ IN35 IN36 IN37 IN38 IN39 IN40 IN41 IN42 IN43 IN44 IN45 IN46 IN47 IN48 IN49 IN50
+ IN51 IN52 IN53 IN54 IN55 IN56 IN57 IN58 IN59 IN60 IN61 IN62 IN63 IN64 IN65 IN66
+ IN67 IN68 IN69 IN70 IN71 IN72 IN73 IN74 IN75 IN76 IN77 IN78 IN79 IN80 IN81 IN82
+ IN83 IN84 IN85 IN86 IN87 IN88 IN89 IN90 IN91 IN92 IN93 IN94 IN95 IN96 IN97 IN98
+ IN99 IN100 IN101 IN102 IN103 IN104 IN105 IN106 IN107 IN108 IN109 IN110 IN111 IN112
+ IN113 IN114 IN115 IN116 IN117 IN118 IN119 IN120 IN121 IN122 IN123 IN124 IN125
+ IN126 IN127 IN128 IN129 IN130 IN131 IN132 IN133 IN134 IN135 IN136 IN137 IN138
+ IN139 IN140 IN141 IN142 IN143 IN144 IN145 IN146 IN147 IN148 IN149 IN150 IN151
+ IN152 IN153 IN154 IN155 IN156 IN157 IN158 IN159 IN160 IN161 IN162 IN163 IN164
+ IN165 IN166 IN167 IN168 IN169 IN170 IN171 IN172 IN173 IN174 IN175 IN176 IN177
+ IN178 IN179 IN180 IN181 IN182 IN183 IN184 IN185 IN186 IN187 IN188 IN189 IN190
+ IN191 IN192 IN193 IN194 IN195 IN196 IN197 IN198 IN199 IN200 IN201 clk_cts_0
XLatch_entrada write_negado reg_write_data[31] reg_write_data[30] reg_write_data[29]
+ reg_write_data[28] reg_write_data[27] reg_write_data[26] reg_write_data[25] reg_write_data[24]
+ reg_write_data[23] reg_write_data[22] reg_write_data[21] reg_write_data[20] reg_write_data[19]
+ reg_write_data[18] reg_write_data[17] reg_write_data[16] reg_write_data[15] reg_write_data[14]
+ reg_write_data[13] reg_write_data[12] reg_write_data[11] reg_write_data[10] reg_write_data[9]
+ reg_write_data[8] reg_write_data[7] reg_write_data[6] reg_write_data[5] reg_write_data[4]
+ reg_write_data[3] reg_write_data[2] reg_write_data[1] reg_write_data[0] dato_escribe[31]
+ dato_escribe[30] dato_escribe[29] dato_escribe[28] dato_escribe[27] dato_escribe[26]
+ dato_escribe[25] dato_escribe[24] dato_escribe[23] dato_escribe[22] dato_escribe[21]
+ dato_escribe[20] dato_escribe[19] dato_escribe[18] dato_escribe[17] dato_escribe[16]
+ dato_escribe[15] dato_escribe[14] dato_escribe[13] dato_escribe[12] dato_escribe[11]
+ dato_escribe[10] dato_escribe[9] dato_escribe[8] dato_escribe[7] dato_escribe[6]
+ dato_escribe[5] dato_escribe[4] dato_escribe[3] dato_escribe[2] dato_escribe[1]
+ dato_escribe[0] VSS VDD_1V8 latch_entrada
XReg_csr n210 n206 n212 n217 n220 n218 n219 dato_escribe[24] n226 n224 n229 n232
+ dato_escribe[19] dato_escribe[18] dato_escribe[17] n222 n223 dato_escribe[14]
+ n225 n209 n215 n216 n213 n208 dato_escribe[7] dato_escribe[6] n204 n234 n233 n235
+ n211 n214 CSR[31] CSR[30] CSR[29] CSR[28] CSR[27] CSR[26] CSR[25] CSR[24] CSR[23]
+ CSR[22] CSR[21] CSR[20] CSR[19] CSR[18] CSR[17] CSR[16] CSR[15] CSR[14] CSR[13]
+ CSR[12] CSR[11] CSR[10] CSR[9] CSR[8] CSR[7] CSR[6] CSR[5] CSR[4] CSR[3] CSR[2]
+ CSR[1] CSR[0] csr_id[3] csr_id[2] csr_id[1] csr_id[0] csr_write clk IN116 mip_IO
+ mip_time mie_IO mie_time comparation[31] comparation[30] comparation[29] comparation[28]
+ comparation[27] comparation[26] comparation[25] comparation[24] comparation[23]
+ comparation[22] comparation[21] comparation[20] comparation[19] comparation[18]
+ comparation[17] comparation[16] comparation[15] comparation[14] comparation[13]
+ comparation[12] comparation[11] comparation[10] comparation[9] comparation[8]
+ comparation[7] comparation[6] comparation[5] comparation[4] comparation[3] comparation[2]
+ comparation[1] comparation[0] timer[31] timer[30] timer[29] timer[28] timer[27]
+ timer[26] timer[25] timer[24] timer[23] timer[22] timer[21] timer[20] timer[19]
+ timer[18] timer[17] timer[16] timer[15] timer[14] timer[13] timer[12] timer[11]
+ timer[10] timer[9] timer[8] timer[7] timer[6] timer[5] timer[4] timer[3] timer[2]
+ timer[1] timer[0] full_range_level_shifter[7] full_range_level_shifter[6] full_range_level_shifter[5]
+ full_range_level_shifter[4] full_range_level_shifter[3] full_range_level_shifter[2]
+ full_range_level_shifter[1] full_range_level_shifter[0] IS_Val[31] IS_Val[30]
+ IS_Val[29] IS_Val[28] IS_Val[27] IS_Val[26] IS_Val[25] IS_Val[24] IS_Val[23] IS_Val[22]
+ IS_Val[21] IS_Val[20] IS_Val[19] IS_Val[18] IS_Val[17] IS_Val[16] IS_Val[15] IS_Val[14]
+ IS_Val[13] IS_Val[12] IS_Val[11] IS_Val[10] IS_Val[9] IS_Val[8] IS_Val[7] IS_Val[6]
+ IS_Val[5] IS_Val[4] IS_Val[3] IS_Val[2] IS_Val[1] IS_Val[0] SYNOPSYS_UNCONNECTED_1
+ SYNOPSYS_UNCONNECTED_2 SYNOPSYS_UNCONNECTED_3 SYNOPSYS_UNCONNECTED_4 SYNOPSYS_UNCONNECTED_5
+ SYNOPSYS_UNCONNECTED_6 SYNOPSYS_UNCONNECTED_7 SYNOPSYS_UNCONNECTED_8 SYNOPSYS_UNCONNECTED_9
+ SYNOPSYS_UNCONNECTED_10 SYNOPSYS_UNCONNECTED_11 SYNOPSYS_UNCONNECTED_12 SYNOPSYS_UNCONNECTED_13
+ SYNOPSYS_UNCONNECTED_14 SYNOPSYS_UNCONNECTED_15 SYNOPSYS_UNCONNECTED_16 SYNOPSYS_UNCONNECTED_17
+ SYNOPSYS_UNCONNECTED_18 SYNOPSYS_UNCONNECTED_19 SYNOPSYS_UNCONNECTED_20 SYNOPSYS_UNCONNECTED_21
+ SYNOPSYS_UNCONNECTED_22 SYNOPSYS_UNCONNECTED_23 SYNOPSYS_UNCONNECTED_24 SYNOPSYS_UNCONNECTED_25
+ SYNOPSYS_UNCONNECTED_26 SYNOPSYS_UNCONNECTED_27 SYNOPSYS_UNCONNECTED_28 SYNOPSYS_UNCONNECTED_29
+ SYNOPSYS_UNCONNECTED_30 SYNOPSYS_UNCONNECTED_31 SYNOPSYS_UNCONNECTED_32 IS_Trigger[3]
+ IS_Trigger[2] IS_Trigger[1] IS_Trigger[0] Mie_analogic mip_analogic Reg_GPIO_en[7]
+ Reg_GPIO_en[6] Reg_GPIO_en[5] Reg_GPIO_en[4] Reg_GPIO_en[3] Reg_GPIO_en[2] Reg_GPIO_en[1]
+ Reg_GPIO_en[0] Reg_GPIO_int[7] Reg_GPIO_int[6] Reg_GPIO_int[5] Reg_GPIO_int[4]
+ Reg_GPIO_int[3] Reg_GPIO_int[2] Reg_GPIO_int[1] Reg_GPIO_int[0] Reg_GPIO_out[7]
+ Reg_GPIO_out[6] Reg_GPIO_out[5] Reg_GPIO_out[4] Reg_GPIO_out[3] Reg_GPIO_out[2]
+ Reg_GPIO_out[1] Reg_GPIO_out[0] VSS VDD_1V8 IN200 csr_file_width32_number_reg12
XReg_integer n210 n206 n212 n217 n220 n218 n219 dato_escribe[24] n226 n224 n229
+ n232 dato_escribe[19] dato_escribe[18] dato_escribe[17] n222 n223 dato_escribe[14]
+ n225 n209 n215 n216 n213 n208 dato_escribe[7] dato_escribe[6] n204 n234 n233 n235
+ n211 n214 R1[31] R1[30] R1[29] R1[28] R1[27] R1[26] R1[25] R1[24] R1[23] R1[22]
+ R1[21] R1[20] R1[19] R1[18] R1[17] R1[16] R1[15] R1[14] R1[13] R1[12] R1[11] R1[10]
+ R1[9] R1[8] R1[7] R1[6] R1[5] R1[4] R1[3] R1[2] R1[1] R1[0] R2[31] R2[30] R2[29]
+ R2[28] R2[27] R2[26] R2[25] R2[24] R2[23] R2[22] R2[21] R2[20] R2[19] R2[18] R2[17]
+ R2[16] R2[15] R2[14] R2[13] R2[12] R2[11] R2[10] R2[9] R2[8] R2[7] R2[6] R2[5]
+ R2[4] R2[3] R2[2] R2[1] R2[0] rs1[4] rs1[3] rs1[2] rs1[1] rs1[0] rs2[4] rs2[3]
+ rs2[2] rs2[1] rs2[0] rd[4] rd[3] rd[2] rd[1] rd[0] write clk_cts_0 rst VSS VDD_1V8
+ IN0 IN1 IN2 IN3 IN4 IN5 IN6 IN7 IN8 IN9 IN10 IN11 IN12 IN13 IN14 IN15 IN16 IN17
+ IN18 IN19 IN20 IN21 IN22 IN23 IN24 IN25 IN26 IN27 IN28 IN29 IN30 IN31 IN32 IN33
+ IN34 IN35 IN36 IN37 IN38 IN39 IN40 IN41 IN42 IN43 IN44 IN45 IN46 IN47 IN48 IN49
+ IN50 IN51 IN52 IN53 IN54 IN55 IN56 IN57 IN58 IN59 IN60 IN61 IN62 IN63 IN64 IN65
+ IN66 IN67 IN68 IN69 IN70 IN71 IN72 IN73 IN74 IN75 IN76 IN77 IN78 IN79 IN80 IN81
+ IN82 IN83 IN84 IN85 IN86 IN87 IN88 IN89 IN90 IN91 IN92 IN93 IN94 IN95 IN96 IN97
+ IN98 IN99 IN100 IN101 IN102 IN103 IN104 IN105 IN106 IN107 IN108 IN109 IN110 IN111
+ IN112 IN113 IN114 IN115 IN117 IN118 IN119 IN120 IN121 IN122 IN123 IN124 IN125
+ IN126 IN127 IN128 IN129 IN130 IN131 IN132 IN133 IN134 IN135 IN136 IN137 IN138
+ IN139 IN140 IN141 IN142 IN143 IN144 IN145 IN146 IN147 IN148 IN149 IN150 IN151
+ IN152 IN153 IN154 IN155 IN156 IN157 IN158 IN159 IN160 IN161 IN162 IN163 IN164
+ IN165 IN166 IN167 IN168 IN169 IN170 IN171 IN172 IN173 IN174 IN175 IN176 IN177
+ IN178 IN179 IN180 IN181 IN182 IN183 IN184 IN185 IN186 IN187 IN188 IN189 IN190
+ IN191 IN192 IN193 IN194 IN195 IN196 IN197 IN198 IN199 IN201 Reg_32_bit_width32_number_reg32
Xplace32 VSS VDD_1V8 n235 dato_escribe[2] BUHDLLX1
Xplace31 VSS VDD_1V8 n234 dato_escribe[4] BUHDLLX1
Xplace30 VSS VDD_1V8 n233 dato_escribe[3] BUHDLLX1
Xplace11 VSS VDD_1V8 n214 dato_escribe[0] BUHDLLX1
Xplace1 VSS VDD_1V8 n204 dato_escribe[5] BUHDLLX1
Xplace8 VSS VDD_1V8 n211 dato_escribe[1] BUHDLLX1
XU2 VSS write_negado csr_write write VDD_1V8 NO2HDLLX1
Xplace3 VSS VDD_1V8 n206 dato_escribe[30] BUHDLLX1
Xplace5 VSS VDD_1V8 n208 dato_escribe[8] BUHDLLX1
Xplace6 VSS VDD_1V8 n209 dato_escribe[12] BUHDLLX1
Xplace7 VSS VDD_1V8 n210 dato_escribe[31] BUHDLLX1
Xplace9 VSS VDD_1V8 n212 dato_escribe[29] BUHDLLX1
Xplace10 VSS VDD_1V8 n213 dato_escribe[9] BUHDLLX1
Xplace12 VSS VDD_1V8 n215 dato_escribe[11] BUHDLLX1
Xplace13 VSS VDD_1V8 n216 dato_escribe[10] BUHDLLX1
Xplace14 VSS VDD_1V8 n217 dato_escribe[28] BUHDLLX1
Xplace15 VSS VDD_1V8 n218 dato_escribe[26] BUHDLLX1
Xplace16 VSS VDD_1V8 n219 dato_escribe[25] BUHDLLX1
Xplace17 VSS VDD_1V8 n220 dato_escribe[27] BUHDLLX1
Xplace19 VSS VDD_1V8 n222 dato_escribe[16] BUHDLLX1
Xplace20 VSS VDD_1V8 n223 dato_escribe[15] BUHDLLX1
Xplace21 VSS VDD_1V8 n224 dato_escribe[22] BUHDLLX1
Xplace22 VSS VDD_1V8 n225 dato_escribe[13] BUHDLLX1
Xplace23 VSS VDD_1V8 n226 dato_escribe[23] BUHDLLX1
Xplace26 VSS VDD_1V8 n229 dato_escribe[21] BUHDLLX1
Xplace29 VSS VDD_1V8 n232 dato_escribe[20] BUHDLLX1
.ENDS

.SUBCKT prll_bs_ntrfs_riscv_3_65_0_7 D_push[64] D_push[63] D_push[62] D_push[61]
+ D_push[60] D_push[59] D_push[58] D_push[57] D_push[56] D_push[55] D_push[54] D_push[53]
+ D_push[52] D_push[51] D_push[50] D_push[49] D_push[48] D_push[47] D_push[46] D_push[45]
+ D_push[44] D_push[43] D_push[42] D_push[41] D_push[40] D_push[39] D_push[38] D_push[37]
+ D_push[36] D_push[35] D_push[34] D_push[33] D_push[32] D_push[31] D_push[30] D_push[29]
+ D_push[28] D_push[27] D_push[26] D_push[25] D_push[24] D_push[23] D_push[22] D_push[21]
+ D_push[20] D_push[19] D_push[18] D_push[17] D_push[16] D_push[15] D_push[14] D_push[13]
+ D_push[12] D_push[11] D_push[10] D_push[9] D_push[8] D_push[7] D_push[6] D_push[5]
+ D_push[4] D_push[3] D_push[2] D_push[1] D_push[0] pndng clk reset bus[64] bus[63]
+ bus[62] bus[61] bus[60] bus[59] bus[58] bus[57] bus[56] bus[55] bus[54] bus[53]
+ bus[52] bus[51] bus[50] bus[49] bus[48] bus[47] bus[46] bus[45] bus[44] bus[43]
+ bus[42] bus[41] bus[40] bus[39] bus[38] bus[37] bus[36] bus[35] bus[34] bus[33]
+ bus[32] bus[31] bus[30] bus[29] bus[28] bus[27] bus[26] bus[25] bus[24] bus[23]
+ bus[22] bus[21] bus[20] bus[19] bus[18] bus[17] bus[16] bus[15] bus[14] bus[13]
+ bus[12] bus[11] bus[10] bus[9] bus[8] bus[7] bus[6] bus[5] bus[4] bus[3] bus[2]
+ bus[1] bus[0] trn_chng wrt pop push D_pop[64] D_pop[63] D_pop[62] D_pop[61] D_pop[60]
+ D_pop[59] D_pop[58] D_pop[57] D_pop[56] D_pop[55] D_pop[54] D_pop[53] D_pop[52]
+ D_pop[51] D_pop[50] D_pop[49] D_pop[48] D_pop[47] D_pop[46] D_pop[45] D_pop[44]
+ D_pop[43] D_pop[42] D_pop[41] D_pop[40] D_pop[39] D_pop[38] D_pop[37] D_pop[36]
+ D_pop[35] D_pop[34] D_pop[33] D_pop[32] D_pop[31] D_pop[30] D_pop[29] D_pop[28]
+ D_pop[27] D_pop[26] D_pop[25] D_pop[24] D_pop[23] D_pop[22] D_pop[21] D_pop[20]
+ D_pop[19] D_pop[18] D_pop[17] D_pop[16] D_pop[15] D_pop[14] D_pop[13] D_pop[12]
+ D_pop[11] D_pop[10] D_pop[9] D_pop[8] D_pop[7] D_pop[6] D_pop[5] D_pop[4] D_pop[3]
+ D_pop[2] D_pop[1] D_pop[0] VSS VDD_1V8 IN0 IN1
Xbit__64__bus_buf VSS bus[64] n8 VSS VDD_1V8 tri_buf_136
Xbit__63__bus_buf bus_pre_w[63] bus[63] n8 VSS VDD_1V8 tri_buf_137
Xbit__62__bus_buf bus_pre_w[62] bus[62] n8 VSS VDD_1V8 tri_buf_138
Xbit__61__bus_buf VSS bus[61] n8 VSS VDD_1V8 tri_buf_139
Xbit__60__bus_buf VSS bus[60] n8 VSS VDD_1V8 tri_buf_140
Xbit__59__bus_buf bus_pre_w[59] bus[59] n8 VSS VDD_1V8 tri_buf_141
Xbit__58__bus_buf bus_pre_w[58] bus[58] n8 VSS VDD_1V8 tri_buf_142
Xbit__57__bus_buf bus_pre_w[57] bus[57] n8 VSS VDD_1V8 tri_buf_143
Xbit__56__bus_buf bus_pre_w[56] bus[56] n8 VSS VDD_1V8 tri_buf_144
Xbit__55__bus_buf bus_pre_w[55] bus[55] n8 VSS VDD_1V8 tri_buf_145
Xbit__54__bus_buf bus_pre_w[54] bus[54] n8 VSS VDD_1V8 tri_buf_146
Xbit__53__bus_buf bus_pre_w[53] bus[53] n8 VSS VDD_1V8 tri_buf_147
Xbit__52__bus_buf bus_pre_w[52] bus[52] n8 VSS VDD_1V8 tri_buf_148
Xbit__51__bus_buf bus_pre_w[51] bus[51] n8 VSS VDD_1V8 tri_buf_149
Xbit__50__bus_buf bus_pre_w[50] bus[50] n8 VSS VDD_1V8 tri_buf_150
Xbit__49__bus_buf bus_pre_w[49] bus[49] n8 VSS VDD_1V8 tri_buf_151
Xbit__48__bus_buf bus_pre_w[48] bus[48] n8 VSS VDD_1V8 tri_buf_152
Xbit__47__bus_buf bus_pre_w[47] bus[47] n8 VSS VDD_1V8 tri_buf_153
Xbit__46__bus_buf bus_pre_w[46] bus[46] n8 VSS VDD_1V8 tri_buf_154
Xbit__45__bus_buf bus_pre_w[45] bus[45] n8 VSS VDD_1V8 tri_buf_155
Xbit__44__bus_buf bus_pre_w[44] bus[44] n8 VSS VDD_1V8 tri_buf_156
Xbit__43__bus_buf bus_pre_w[43] bus[43] n8 VSS VDD_1V8 tri_buf_157
Xbit__42__bus_buf bus_pre_w[42] bus[42] n8 VSS VDD_1V8 tri_buf_158
Xbit__41__bus_buf bus_pre_w[41] bus[41] n8 VSS VDD_1V8 tri_buf_159
Xbit__40__bus_buf bus_pre_w[40] bus[40] n8 VSS VDD_1V8 tri_buf_160
Xbit__39__bus_buf bus_pre_w[39] bus[39] n8 VSS VDD_1V8 tri_buf_161
Xbit__38__bus_buf bus_pre_w[38] bus[38] n8 VSS VDD_1V8 tri_buf_162
Xbit__37__bus_buf bus_pre_w[37] bus[37] n8 VSS VDD_1V8 tri_buf_163
Xbit__36__bus_buf bus_pre_w[36] bus[36] n10 VSS VDD_1V8 tri_buf_164
Xbit__35__bus_buf bus_pre_w[35] bus[35] n10 VSS VDD_1V8 tri_buf_165
Xbit__34__bus_buf bus_pre_w[34] bus[34] n10 VSS VDD_1V8 tri_buf_166
Xbit__33__bus_buf bus_pre_w[33] bus[33] n10 VSS VDD_1V8 tri_buf_167
Xbit__32__bus_buf bus_pre_w[32] bus[32] n10 VSS VDD_1V8 tri_buf_168
Xbit__31__bus_buf bus_pre_w[31] bus[31] n10 VSS VDD_1V8 tri_buf_169
Xbit__30__bus_buf bus_pre_w[30] bus[30] n10 VSS VDD_1V8 tri_buf_170
Xbit__29__bus_buf bus_pre_w[29] bus[29] n10 VSS VDD_1V8 tri_buf_171
Xbit__28__bus_buf bus_pre_w[28] bus[28] n10 VSS VDD_1V8 tri_buf_172
Xbit__27__bus_buf bus_pre_w[27] bus[27] n10 VSS VDD_1V8 tri_buf_173
Xbit__26__bus_buf bus_pre_w[26] bus[26] n10 VSS VDD_1V8 tri_buf_174
Xbit__25__bus_buf bus_pre_w[25] bus[25] n10 VSS VDD_1V8 tri_buf_175
Xbit__24__bus_buf bus_pre_w[24] bus[24] n10 VSS VDD_1V8 tri_buf_176
Xbit__23__bus_buf bus_pre_w[23] bus[23] n10 VSS VDD_1V8 tri_buf_177
Xbit__22__bus_buf bus_pre_w[22] bus[22] n10 VSS VDD_1V8 tri_buf_178
Xbit__21__bus_buf bus_pre_w[21] bus[21] n10 VSS VDD_1V8 tri_buf_179
Xbit__20__bus_buf bus_pre_w[20] bus[20] n10 VSS VDD_1V8 tri_buf_180
Xbit__19__bus_buf bus_pre_w[19] bus[19] n10 VSS VDD_1V8 tri_buf_181
Xbit__18__bus_buf bus_pre_w[18] bus[18] n10 VSS VDD_1V8 tri_buf_182
Xbit__17__bus_buf bus_pre_w[17] bus[17] n10 VSS VDD_1V8 tri_buf_183
Xbit__16__bus_buf bus_pre_w[16] bus[16] n10 VSS VDD_1V8 tri_buf_184
Xbit__15__bus_buf bus_pre_w[15] bus[15] n10 VSS VDD_1V8 tri_buf_185
Xbit__14__bus_buf bus_pre_w[14] bus[14] n10 VSS VDD_1V8 tri_buf_186
Xbit__13__bus_buf bus_pre_w[13] bus[13] n10 VSS VDD_1V8 tri_buf_187
Xbit__12__bus_buf bus_pre_w[12] bus[12] n10 VSS VDD_1V8 tri_buf_188
Xbit__11__bus_buf bus_pre_w[11] bus[11] n10 VSS VDD_1V8 tri_buf_189
Xbit__10__bus_buf bus_pre_w[10] bus[10] n10 VSS VDD_1V8 tri_buf_190
Xbit__9__bus_buf bus_pre_w[9] bus[9] n10 VSS VDD_1V8 tri_buf_191
Xbit__8__bus_buf bus_pre_w[8] bus[8] n10 VSS VDD_1V8 tri_buf_192
Xbit__7__bus_buf bus_pre_w[7] bus[7] n8 VSS VDD_1V8 tri_buf_193
Xbit__6__bus_buf bus_pre_w[6] bus[6] n8 VSS VDD_1V8 tri_buf_194
Xbit__5__bus_buf bus_pre_w[5] bus[5] n8 VSS VDD_1V8 tri_buf_195
Xbit__4__bus_buf bus_pre_w[4] bus[4] n8 VSS VDD_1V8 tri_buf_196
Xbit__3__bus_buf bus_pre_w[3] bus[3] n8 VSS VDD_1V8 tri_buf_197
Xbit__2__bus_buf bus_pre_w[2] bus[2] n8 VSS VDD_1V8 tri_buf_198
Xbit__1__bus_buf bus_pre_w[1] bus[1] n8 VSS VDD_1V8 tri_buf_199
Xbit__0__bus_buf bus_pre_w[0] bus[0] n8 VSS VDD_1V8 tri_buf_200
Xprll_cntrl clk reset n2 n3 n4 pndng ld_w rst_w n9 n5 push pop trn_chng wrt n8 VSS
+ VDD_1V8 rst_w IN0 IN1 prll_intrfs_cntrl_riscv_0_7_3
XD_reg_wt ld_w rst_w VSS D_pop[63] D_pop[62] VSS VSS D_pop[59] D_pop[58] D_pop[57]
+ D_pop[56] D_pop[55] D_pop[54] D_pop[53] D_pop[52] D_pop[51] D_pop[50] D_pop[49]
+ D_pop[48] D_pop[47] D_pop[46] D_pop[45] D_pop[44] D_pop[43] D_pop[42] D_pop[41]
+ D_pop[40] D_pop[39] D_pop[38] D_pop[37] D_pop[36] D_pop[35] D_pop[34] D_pop[33]
+ D_pop[32] D_pop[31] D_pop[30] D_pop[29] D_pop[28] D_pop[27] D_pop[26] D_pop[25]
+ D_pop[24] D_pop[23] D_pop[22] D_pop[21] D_pop[20] D_pop[19] D_pop[18] D_pop[17]
+ D_pop[16] D_pop[15] D_pop[14] D_pop[13] D_pop[12] D_pop[11] D_pop[10] D_pop[9]
+ D_pop[8] D_pop[7] D_pop[6] D_pop[5] D_pop[4] D_pop[3] D_pop[2] D_pop[1] D_pop[0]
+ SYNOPSYS_UNCONNECTED_1 bus_pre_w[63] bus_pre_w[62] SYNOPSYS_UNCONNECTED_2 SYNOPSYS_UNCONNECTED_3
+ bus_pre_w[59] bus_pre_w[58] bus_pre_w[57] bus_pre_w[56] bus_pre_w[55] bus_pre_w[54]
+ bus_pre_w[53] bus_pre_w[52] bus_pre_w[51] bus_pre_w[50] bus_pre_w[49] bus_pre_w[48]
+ bus_pre_w[47] bus_pre_w[46] bus_pre_w[45] bus_pre_w[44] bus_pre_w[43] bus_pre_w[42]
+ bus_pre_w[41] bus_pre_w[40] bus_pre_w[39] bus_pre_w[38] bus_pre_w[37] bus_pre_w[36]
+ bus_pre_w[35] bus_pre_w[34] bus_pre_w[33] bus_pre_w[32] bus_pre_w[31] bus_pre_w[30]
+ bus_pre_w[29] bus_pre_w[28] bus_pre_w[27] bus_pre_w[26] bus_pre_w[25] bus_pre_w[24]
+ bus_pre_w[23] bus_pre_w[22] bus_pre_w[21] bus_pre_w[20] bus_pre_w[19] bus_pre_w[18]
+ bus_pre_w[17] bus_pre_w[16] bus_pre_w[15] bus_pre_w[14] bus_pre_w[13] bus_pre_w[12]
+ bus_pre_w[11] bus_pre_w[10] bus_pre_w[9] bus_pre_w[8] bus_pre_w[7] bus_pre_w[6]
+ bus_pre_w[5] bus_pre_w[4] bus_pre_w[3] bus_pre_w[2] bus_pre_w[1] bus_pre_w[0]
+ VSS VDD_1V8 rst_w prll_d_reg_bits65_18
XD_reg_rd ld_r n9 bus[64] bus[63] bus[62] bus[61] bus[60] bus[59] bus[58] bus[57]
+ bus[56] bus[55] bus[54] bus[53] bus[52] bus[51] bus[50] bus[49] bus[48] bus[47]
+ bus[46] bus[45] bus[44] bus[43] bus[42] bus[41] bus[40] bus[39] bus[38] bus[37]
+ bus[36] bus[35] bus[34] bus[33] bus[32] bus[31] bus[30] bus[29] bus[28] bus[27]
+ bus[26] bus[25] bus[24] bus[23] bus[22] bus[21] bus[20] bus[19] bus[18] bus[17]
+ bus[16] bus[15] bus[14] bus[13] bus[12] bus[11] bus[10] bus[9] bus[8] bus[7] bus[6]
+ bus[5] bus[4] bus[3] bus[2] bus[1] bus[0] n2 n3 n4 D_push[61] D_push[60] D_push[59]
+ D_push[58] D_push[57] D_push[56] D_push[55] D_push[54] D_push[53] D_push[52] D_push[51]
+ D_push[50] D_push[49] D_push[48] D_push[47] D_push[46] D_push[45] D_push[44] D_push[43]
+ D_push[42] D_push[41] D_push[40] D_push[39] D_push[38] D_push[37] D_push[36] D_push[35]
+ D_push[34] D_push[33] D_push[32] D_push[31] D_push[30] D_push[29] D_push[28] D_push[27]
+ D_push[26] D_push[25] D_push[24] D_push[23] D_push[22] D_push[21] D_push[20] D_push[19]
+ D_push[18] D_push[17] D_push[16] D_push[15] D_push[14] D_push[13] D_push[12] D_push[11]
+ D_push[10] D_push[9] D_push[8] D_push[7] D_push[6] D_push[5] D_push[4] D_push[3]
+ D_push[2] D_push[1] D_push[0] VSS VDD_1V8 prll_d_reg_bits65_19
XU1 VSS VDD_1V8 ld_r wrt n8 NO2I1HDLLX0
Xplace2 VSS VDD_1V8 n10 n5 BUHDLLX0
Xplace1 VSS VDD_1V8 n8 n5 BUHDLLX4
.ENDS

.SUBCKT prll_bs_ntrfs_riscv_3_65_1_7 D_push[64] D_push[63] D_push[62] D_push[61]
+ D_push[60] D_push[59] D_push[58] D_push[57] D_push[56] D_push[55] D_push[54] D_push[53]
+ D_push[52] D_push[51] D_push[50] D_push[49] D_push[48] D_push[47] D_push[46] D_push[45]
+ D_push[44] D_push[43] D_push[42] D_push[41] D_push[40] D_push[39] D_push[38] D_push[37]
+ D_push[36] D_push[35] D_push[34] D_push[33] D_push[32] D_push[31] D_push[30] D_push[29]
+ D_push[28] D_push[27] D_push[26] D_push[25] D_push[24] D_push[23] D_push[22] D_push[21]
+ D_push[20] D_push[19] D_push[18] D_push[17] D_push[16] D_push[15] D_push[14] D_push[13]
+ D_push[12] D_push[11] D_push[10] D_push[9] D_push[8] D_push[7] D_push[6] D_push[5]
+ D_push[4] D_push[3] D_push[2] D_push[1] D_push[0] pndng clk reset bus[64] bus[63]
+ bus[62] bus[61] bus[60] bus[59] bus[58] bus[57] bus[56] bus[55] bus[54] bus[53]
+ bus[52] bus[51] bus[50] bus[49] bus[48] bus[47] bus[46] bus[45] bus[44] bus[43]
+ bus[42] bus[41] bus[40] bus[39] bus[38] bus[37] bus[36] bus[35] bus[34] bus[33]
+ bus[32] bus[31] bus[30] bus[29] bus[28] bus[27] bus[26] bus[25] bus[24] bus[23]
+ bus[22] bus[21] bus[20] bus[19] bus[18] bus[17] bus[16] bus[15] bus[14] bus[13]
+ bus[12] bus[11] bus[10] bus[9] bus[8] bus[7] bus[6] bus[5] bus[4] bus[3] bus[2]
+ bus[1] bus[0] trn_chng wrt pop push D_pop[64] D_pop[63] D_pop[62] D_pop[61] D_pop[60]
+ D_pop[59] D_pop[58] D_pop[57] D_pop[56] D_pop[55] D_pop[54] D_pop[53] D_pop[52]
+ D_pop[51] D_pop[50] D_pop[49] D_pop[48] D_pop[47] D_pop[46] D_pop[45] D_pop[44]
+ D_pop[43] D_pop[42] D_pop[41] D_pop[40] D_pop[39] D_pop[38] D_pop[37] D_pop[36]
+ D_pop[35] D_pop[34] D_pop[33] D_pop[32] D_pop[31] D_pop[30] D_pop[29] D_pop[28]
+ D_pop[27] D_pop[26] D_pop[25] D_pop[24] D_pop[23] D_pop[22] D_pop[21] D_pop[20]
+ D_pop[19] D_pop[18] D_pop[17] D_pop[16] D_pop[15] D_pop[14] D_pop[13] D_pop[12]
+ D_pop[11] D_pop[10] D_pop[9] D_pop[8] D_pop[7] D_pop[6] D_pop[5] D_pop[4] D_pop[3]
+ D_pop[2] D_pop[1] D_pop[0] VSS VDD_1V8 IN0 IN1 IN2 IN3
Xbit__64__bus_buf VSS bus[64] n1 VSS VDD_1V8 tri_buf_71
Xbit__63__bus_buf VSS bus[63] n7 VSS VDD_1V8 tri_buf_72
Xbit__62__bus_buf VSS bus[62] n7 VSS VDD_1V8 tri_buf_73
Xbit__61__bus_buf VSS bus[61] n7 VSS VDD_1V8 tri_buf_74
Xbit__60__bus_buf bus_pre_w[60] bus[60] n7 VSS VDD_1V8 tri_buf_75
Xbit__59__bus_buf bus_pre_w[59] bus[59] n1 VSS VDD_1V8 tri_buf_76
Xbit__58__bus_buf bus_pre_w[58] bus[58] n1 VSS VDD_1V8 tri_buf_77
Xbit__57__bus_buf bus_pre_w[57] bus[57] n1 VSS VDD_1V8 tri_buf_78
Xbit__56__bus_buf bus_pre_w[56] bus[56] n1 VSS VDD_1V8 tri_buf_79
Xbit__55__bus_buf bus_pre_w[55] bus[55] n1 VSS VDD_1V8 tri_buf_80
Xbit__54__bus_buf bus_pre_w[54] bus[54] n1 VSS VDD_1V8 tri_buf_81
Xbit__53__bus_buf bus_pre_w[53] bus[53] n1 VSS VDD_1V8 tri_buf_82
Xbit__52__bus_buf bus_pre_w[52] bus[52] n1 VSS VDD_1V8 tri_buf_83
Xbit__51__bus_buf bus_pre_w[51] bus[51] n1 VSS VDD_1V8 tri_buf_84
Xbit__50__bus_buf bus_pre_w[50] bus[50] n1 VSS VDD_1V8 tri_buf_85
Xbit__49__bus_buf bus_pre_w[49] bus[49] n1 VSS VDD_1V8 tri_buf_86
Xbit__48__bus_buf bus_pre_w[48] bus[48] n1 VSS VDD_1V8 tri_buf_87
Xbit__47__bus_buf bus_pre_w[47] bus[47] n1 VSS VDD_1V8 tri_buf_88
Xbit__46__bus_buf bus_pre_w[46] bus[46] n1 VSS VDD_1V8 tri_buf_89
Xbit__45__bus_buf bus_pre_w[45] bus[45] n1 VSS VDD_1V8 tri_buf_90
Xbit__44__bus_buf bus_pre_w[44] bus[44] n1 VSS VDD_1V8 tri_buf_91
Xbit__43__bus_buf bus_pre_w[43] bus[43] n1 VSS VDD_1V8 tri_buf_92
Xbit__42__bus_buf bus_pre_w[42] bus[42] n1 VSS VDD_1V8 tri_buf_93
Xbit__41__bus_buf bus_pre_w[41] bus[41] n1 VSS VDD_1V8 tri_buf_94
Xbit__40__bus_buf bus_pre_w[40] bus[40] n1 VSS VDD_1V8 tri_buf_95
Xbit__39__bus_buf bus_pre_w[39] bus[39] n1 VSS VDD_1V8 tri_buf_96
Xbit__38__bus_buf bus_pre_w[38] bus[38] n1 VSS VDD_1V8 tri_buf_97
Xbit__37__bus_buf bus_pre_w[37] bus[37] n1 VSS VDD_1V8 tri_buf_98
Xbit__36__bus_buf bus_pre_w[36] bus[36] n1 VSS VDD_1V8 tri_buf_99
Xbit__35__bus_buf bus_pre_w[35] bus[35] n1 VSS VDD_1V8 tri_buf_100
Xbit__34__bus_buf bus_pre_w[34] bus[34] n1 VSS VDD_1V8 tri_buf_101
Xbit__33__bus_buf bus_pre_w[33] bus[33] n1 VSS VDD_1V8 tri_buf_102
Xbit__32__bus_buf bus_pre_w[32] bus[32] n1 VSS VDD_1V8 tri_buf_103
Xbit__31__bus_buf bus_pre_w[31] bus[31] n7 VSS VDD_1V8 tri_buf_104
Xbit__30__bus_buf bus_pre_w[30] bus[30] n7 VSS VDD_1V8 tri_buf_105
Xbit__29__bus_buf bus_pre_w[29] bus[29] n7 VSS VDD_1V8 tri_buf_106
Xbit__28__bus_buf bus_pre_w[28] bus[28] n7 VSS VDD_1V8 tri_buf_107
Xbit__27__bus_buf bus_pre_w[27] bus[27] n7 VSS VDD_1V8 tri_buf_108
Xbit__26__bus_buf bus_pre_w[26] bus[26] n7 VSS VDD_1V8 tri_buf_109
Xbit__25__bus_buf bus_pre_w[25] bus[25] n7 VSS VDD_1V8 tri_buf_110
Xbit__24__bus_buf bus_pre_w[24] bus[24] n7 VSS VDD_1V8 tri_buf_111
Xbit__23__bus_buf bus_pre_w[23] bus[23] n7 VSS VDD_1V8 tri_buf_112
Xbit__22__bus_buf bus_pre_w[22] bus[22] n7 VSS VDD_1V8 tri_buf_113
Xbit__21__bus_buf bus_pre_w[21] bus[21] n7 VSS VDD_1V8 tri_buf_114
Xbit__20__bus_buf bus_pre_w[20] bus[20] n7 VSS VDD_1V8 tri_buf_115
Xbit__19__bus_buf bus_pre_w[19] bus[19] n7 VSS VDD_1V8 tri_buf_116
Xbit__18__bus_buf bus_pre_w[18] bus[18] n7 VSS VDD_1V8 tri_buf_117
Xbit__17__bus_buf bus_pre_w[17] bus[17] n7 VSS VDD_1V8 tri_buf_118
Xbit__16__bus_buf bus_pre_w[16] bus[16] n7 VSS VDD_1V8 tri_buf_119
Xbit__15__bus_buf bus_pre_w[15] bus[15] n7 VSS VDD_1V8 tri_buf_120
Xbit__14__bus_buf bus_pre_w[14] bus[14] n7 VSS VDD_1V8 tri_buf_121
Xbit__13__bus_buf bus_pre_w[13] bus[13] n7 VSS VDD_1V8 tri_buf_122
Xbit__12__bus_buf bus_pre_w[12] bus[12] n7 VSS VDD_1V8 tri_buf_123
Xbit__11__bus_buf bus_pre_w[11] bus[11] n7 VSS VDD_1V8 tri_buf_124
Xbit__10__bus_buf bus_pre_w[10] bus[10] n7 VSS VDD_1V8 tri_buf_125
Xbit__9__bus_buf bus_pre_w[9] bus[9] n7 VSS VDD_1V8 tri_buf_126
Xbit__8__bus_buf bus_pre_w[8] bus[8] n7 VSS VDD_1V8 tri_buf_127
Xbit__7__bus_buf bus_pre_w[7] bus[7] n7 VSS VDD_1V8 tri_buf_128
Xbit__6__bus_buf bus_pre_w[6] bus[6] n7 VSS VDD_1V8 tri_buf_129
Xbit__5__bus_buf bus_pre_w[5] bus[5] n7 VSS VDD_1V8 tri_buf_130
Xbit__4__bus_buf bus_pre_w[4] bus[4] n7 VSS VDD_1V8 tri_buf_131
Xbit__3__bus_buf bus_pre_w[3] bus[3] n7 VSS VDD_1V8 tri_buf_132
Xbit__2__bus_buf bus_pre_w[2] bus[2] n7 VSS VDD_1V8 tri_buf_133
Xbit__1__bus_buf bus_pre_w[1] bus[1] n7 VSS VDD_1V8 tri_buf_134
Xbit__0__bus_buf bus_pre_w[0] bus[0] n7 VSS VDD_1V8 tri_buf_135
Xprll_cntrl clk reset D_push[64] D_push[63] D_push[62] pndng ld_w rst_w n10 n6 push
+ pop trn_chng wrt n8 VSS VDD_1V8 n9 IN0 IN1 IN2 IN3 prll_intrfs_cntrl_riscv_1_7_3
XD_reg_wt ld_w n9 VSS VSS VSS VSS D_pop[60] D_pop[59] D_pop[58] D_pop[57] D_pop[56]
+ D_pop[55] D_pop[54] D_pop[53] D_pop[52] D_pop[51] D_pop[50] D_pop[49] D_pop[48]
+ D_pop[47] D_pop[46] D_pop[45] D_pop[44] D_pop[43] D_pop[42] D_pop[41] D_pop[40]
+ D_pop[39] D_pop[38] D_pop[37] D_pop[36] D_pop[35] D_pop[34] D_pop[33] D_pop[32]
+ D_pop[31] D_pop[30] D_pop[29] D_pop[28] D_pop[27] D_pop[26] D_pop[25] D_pop[24]
+ D_pop[23] D_pop[22] D_pop[21] D_pop[20] D_pop[19] D_pop[18] D_pop[17] D_pop[16]
+ D_pop[15] D_pop[14] D_pop[13] D_pop[12] D_pop[11] D_pop[10] D_pop[9] D_pop[8]
+ D_pop[7] D_pop[6] D_pop[5] D_pop[4] D_pop[3] D_pop[2] D_pop[1] D_pop[0] SYNOPSYS_UNCONNECTED_1
+ SYNOPSYS_UNCONNECTED_2 SYNOPSYS_UNCONNECTED_3 SYNOPSYS_UNCONNECTED_4 bus_pre_w[60]
+ bus_pre_w[59] bus_pre_w[58] bus_pre_w[57] bus_pre_w[56] bus_pre_w[55] bus_pre_w[54]
+ bus_pre_w[53] bus_pre_w[52] bus_pre_w[51] bus_pre_w[50] bus_pre_w[49] bus_pre_w[48]
+ bus_pre_w[47] bus_pre_w[46] bus_pre_w[45] bus_pre_w[44] bus_pre_w[43] bus_pre_w[42]
+ bus_pre_w[41] bus_pre_w[40] bus_pre_w[39] bus_pre_w[38] bus_pre_w[37] bus_pre_w[36]
+ bus_pre_w[35] bus_pre_w[34] bus_pre_w[33] bus_pre_w[32] bus_pre_w[31] bus_pre_w[30]
+ bus_pre_w[29] bus_pre_w[28] bus_pre_w[27] bus_pre_w[26] bus_pre_w[25] bus_pre_w[24]
+ bus_pre_w[23] bus_pre_w[22] bus_pre_w[21] bus_pre_w[20] bus_pre_w[19] bus_pre_w[18]
+ bus_pre_w[17] bus_pre_w[16] bus_pre_w[15] bus_pre_w[14] bus_pre_w[13] bus_pre_w[12]
+ bus_pre_w[11] bus_pre_w[10] bus_pre_w[9] bus_pre_w[8] bus_pre_w[7] bus_pre_w[6]
+ bus_pre_w[5] bus_pre_w[4] bus_pre_w[3] bus_pre_w[2] bus_pre_w[1] bus_pre_w[0]
+ VSS VDD_1V8 rst_w prll_d_reg_bits65_16
XD_reg_rd ld_r n10 bus[64] bus[63] bus[62] VSS VSS bus[59] bus[58] bus[57] VSS VSS
+ bus[54] bus[53] bus[52] bus[51] bus[50] bus[49] bus[48] bus[47] bus[46] bus[45]
+ bus[44] bus[43] bus[42] bus[41] bus[40] bus[39] bus[38] bus[37] bus[36] bus[35]
+ bus[34] bus[33] bus[32] bus[31] bus[30] bus[29] bus[28] bus[27] bus[26] bus[25]
+ bus[24] bus[23] bus[22] bus[21] bus[20] bus[19] bus[18] bus[17] bus[16] bus[15]
+ bus[14] bus[13] bus[12] bus[11] bus[10] bus[9] bus[8] bus[7] bus[6] bus[5] bus[4]
+ bus[3] bus[2] bus[1] bus[0] D_push[64] D_push[63] D_push[62] SYNOPSYS_UNCONNECTED_5
+ SYNOPSYS_UNCONNECTED_6 D_push[59] D_push[58] D_push[57] SYNOPSYS_UNCONNECTED_7
+ SYNOPSYS_UNCONNECTED_8 D_push[54] D_push[53] D_push[52] D_push[51] D_push[50]
+ D_push[49] D_push[48] D_push[47] D_push[46] D_push[45] D_push[44] D_push[43] D_push[42]
+ D_push[41] D_push[40] D_push[39] D_push[38] D_push[37] D_push[36] D_push[35] D_push[34]
+ D_push[33] D_push[32] D_push[31] D_push[30] D_push[29] D_push[28] D_push[27] D_push[26]
+ D_push[25] D_push[24] D_push[23] D_push[22] D_push[21] D_push[20] D_push[19] D_push[18]
+ D_push[17] D_push[16] D_push[15] D_push[14] D_push[13] D_push[12] D_push[11] D_push[10]
+ D_push[9] D_push[8] D_push[7] D_push[6] D_push[5] D_push[4] D_push[3] D_push[2]
+ D_push[1] D_push[0] VSS VDD_1V8 prll_d_reg_bits65_17
Xplace4 VSS VDD_1V8 n1 n8 BUHDLLX0
XU1 VSS VDD_1V8 ld_r wrt n1 NO2I1HDLLX0
Xplace1 VSS VDD_1V8 n6 n7 BUHDLLX6
Xplace3 VSS VDD_1V8 n9 rst_w BUHDLLX0
Xplace2 VSS VDD_1V8 n8 n6 BUHDLLX0
.ENDS

.SUBCKT prll_bs_ntrfs_riscv_3_65_2_7 D_push[64] D_push[63] D_push[62] D_push[61]
+ D_push[60] D_push[59] D_push[58] D_push[57] D_push[56] D_push[55] D_push[54] D_push[53]
+ D_push[52] D_push[51] D_push[50] D_push[49] D_push[48] D_push[47] D_push[46] D_push[45]
+ D_push[44] D_push[43] D_push[42] D_push[41] D_push[40] D_push[39] D_push[38] D_push[37]
+ D_push[36] D_push[35] D_push[34] D_push[33] D_push[32] D_push[31] D_push[30] D_push[29]
+ D_push[28] D_push[27] D_push[26] D_push[25] D_push[24] D_push[23] D_push[22] D_push[21]
+ D_push[20] D_push[19] D_push[18] D_push[17] D_push[16] D_push[15] D_push[14] D_push[13]
+ D_push[12] D_push[11] D_push[10] D_push[9] D_push[8] D_push[7] D_push[6] D_push[5]
+ D_push[4] D_push[3] D_push[2] D_push[1] D_push[0] pndng clk reset bus[64] bus[63]
+ bus[62] bus[61] bus[60] bus[59] bus[58] bus[57] bus[56] bus[55] bus[54] bus[53]
+ bus[52] bus[51] bus[50] bus[49] bus[48] bus[47] bus[46] bus[45] bus[44] bus[43]
+ bus[42] bus[41] bus[40] bus[39] bus[38] bus[37] bus[36] bus[35] bus[34] bus[33]
+ bus[32] bus[31] bus[30] bus[29] bus[28] bus[27] bus[26] bus[25] bus[24] bus[23]
+ bus[22] bus[21] bus[20] bus[19] bus[18] bus[17] bus[16] bus[15] bus[14] bus[13]
+ bus[12] bus[11] bus[10] bus[9] bus[8] bus[7] bus[6] bus[5] bus[4] bus[3] bus[2]
+ bus[1] bus[0] trn_chng wrt pop push D_pop[64] D_pop[63] D_pop[62] D_pop[61] D_pop[60]
+ D_pop[59] D_pop[58] D_pop[57] D_pop[56] D_pop[55] D_pop[54] D_pop[53] D_pop[52]
+ D_pop[51] D_pop[50] D_pop[49] D_pop[48] D_pop[47] D_pop[46] D_pop[45] D_pop[44]
+ D_pop[43] D_pop[42] D_pop[41] D_pop[40] D_pop[39] D_pop[38] D_pop[37] D_pop[36]
+ D_pop[35] D_pop[34] D_pop[33] D_pop[32] D_pop[31] D_pop[30] D_pop[29] D_pop[28]
+ D_pop[27] D_pop[26] D_pop[25] D_pop[24] D_pop[23] D_pop[22] D_pop[21] D_pop[20]
+ D_pop[19] D_pop[18] D_pop[17] D_pop[16] D_pop[15] D_pop[14] D_pop[13] D_pop[12]
+ D_pop[11] D_pop[10] D_pop[9] D_pop[8] D_pop[7] D_pop[6] D_pop[5] D_pop[4] D_pop[3]
+ D_pop[2] D_pop[1] D_pop[0] VSS VDD_1V8 IN0 IN1 clk_cts_4
Xbit__64__bus_buf VSS bus[64] n3 VSS VDD_1V8 tri_buf_6
Xbit__63__bus_buf bus_pre_w[63] bus[63] n6 VSS VDD_1V8 tri_buf_7
Xbit__62__bus_buf bus_pre_w[62] bus[62] n6 VSS VDD_1V8 tri_buf_8
Xbit__61__bus_buf bus_pre_w[61] bus[61] n6 VSS VDD_1V8 tri_buf_9
Xbit__60__bus_buf bus_pre_w[60] bus[60] n6 VSS VDD_1V8 tri_buf_10
Xbit__59__bus_buf bus_pre_w[59] bus[59] n6 VSS VDD_1V8 tri_buf_11
Xbit__58__bus_buf bus_pre_w[58] bus[58] n6 VSS VDD_1V8 tri_buf_12
Xbit__57__bus_buf bus_pre_w[57] bus[57] n6 VSS VDD_1V8 tri_buf_13
Xbit__56__bus_buf bus_pre_w[56] bus[56] n6 VSS VDD_1V8 tri_buf_14
Xbit__55__bus_buf bus_pre_w[55] bus[55] n6 VSS VDD_1V8 tri_buf_15
Xbit__54__bus_buf bus_pre_w[54] bus[54] n6 VSS VDD_1V8 tri_buf_16
Xbit__53__bus_buf bus_pre_w[53] bus[53] n3 VSS VDD_1V8 tri_buf_17
Xbit__52__bus_buf bus_pre_w[52] bus[52] n6 VSS VDD_1V8 tri_buf_18
Xbit__51__bus_buf bus_pre_w[51] bus[51] n6 VSS VDD_1V8 tri_buf_19
Xbit__50__bus_buf bus_pre_w[50] bus[50] n6 VSS VDD_1V8 tri_buf_20
Xbit__49__bus_buf bus_pre_w[49] bus[49] n6 VSS VDD_1V8 tri_buf_21
Xbit__48__bus_buf bus_pre_w[48] bus[48] n6 VSS VDD_1V8 tri_buf_22
Xbit__47__bus_buf bus_pre_w[47] bus[47] n6 VSS VDD_1V8 tri_buf_23
Xbit__46__bus_buf bus_pre_w[46] bus[46] n6 VSS VDD_1V8 tri_buf_24
Xbit__45__bus_buf bus_pre_w[45] bus[45] n6 VSS VDD_1V8 tri_buf_25
Xbit__44__bus_buf bus_pre_w[44] bus[44] n6 VSS VDD_1V8 tri_buf_26
Xbit__43__bus_buf bus_pre_w[43] bus[43] n6 VSS VDD_1V8 tri_buf_27
Xbit__42__bus_buf bus_pre_w[42] bus[42] n6 VSS VDD_1V8 tri_buf_28
Xbit__41__bus_buf bus_pre_w[41] bus[41] n6 VSS VDD_1V8 tri_buf_29
Xbit__40__bus_buf bus_pre_w[40] bus[40] n6 VSS VDD_1V8 tri_buf_30
Xbit__39__bus_buf bus_pre_w[39] bus[39] n6 VSS VDD_1V8 tri_buf_31
Xbit__38__bus_buf bus_pre_w[38] bus[38] n6 VSS VDD_1V8 tri_buf_32
Xbit__37__bus_buf bus_pre_w[37] bus[37] n6 VSS VDD_1V8 tri_buf_33
Xbit__36__bus_buf bus_pre_w[36] bus[36] n6 VSS VDD_1V8 tri_buf_34
Xbit__35__bus_buf bus_pre_w[35] bus[35] n6 VSS VDD_1V8 tri_buf_35
Xbit__34__bus_buf bus_pre_w[34] bus[34] n6 VSS VDD_1V8 tri_buf_36
Xbit__33__bus_buf bus_pre_w[33] bus[33] n6 VSS VDD_1V8 tri_buf_37
Xbit__32__bus_buf bus_pre_w[32] bus[32] n6 VSS VDD_1V8 tri_buf_38
Xbit__31__bus_buf bus_pre_w[31] bus[31] n9 VSS VDD_1V8 tri_buf_39
Xbit__30__bus_buf bus_pre_w[30] bus[30] n9 VSS VDD_1V8 tri_buf_40
Xbit__29__bus_buf bus_pre_w[29] bus[29] n9 VSS VDD_1V8 tri_buf_41
Xbit__28__bus_buf bus_pre_w[28] bus[28] n9 VSS VDD_1V8 tri_buf_42
Xbit__27__bus_buf bus_pre_w[27] bus[27] n6 VSS VDD_1V8 tri_buf_43
Xbit__26__bus_buf bus_pre_w[26] bus[26] n9 VSS VDD_1V8 tri_buf_44
Xbit__25__bus_buf bus_pre_w[25] bus[25] n6 VSS VDD_1V8 tri_buf_45
Xbit__24__bus_buf bus_pre_w[24] bus[24] n6 VSS VDD_1V8 tri_buf_46
Xbit__23__bus_buf bus_pre_w[23] bus[23] n9 VSS VDD_1V8 tri_buf_47
Xbit__22__bus_buf bus_pre_w[22] bus[22] n9 VSS VDD_1V8 tri_buf_48
Xbit__21__bus_buf bus_pre_w[21] bus[21] n9 VSS VDD_1V8 tri_buf_49
Xbit__20__bus_buf bus_pre_w[20] bus[20] n9 VSS VDD_1V8 tri_buf_50
Xbit__19__bus_buf bus_pre_w[19] bus[19] n9 VSS VDD_1V8 tri_buf_51
Xbit__18__bus_buf bus_pre_w[18] bus[18] n9 VSS VDD_1V8 tri_buf_52
Xbit__17__bus_buf bus_pre_w[17] bus[17] n9 VSS VDD_1V8 tri_buf_53
Xbit__16__bus_buf bus_pre_w[16] bus[16] n9 VSS VDD_1V8 tri_buf_54
Xbit__15__bus_buf bus_pre_w[15] bus[15] n9 VSS VDD_1V8 tri_buf_55
Xbit__14__bus_buf bus_pre_w[14] bus[14] n9 VSS VDD_1V8 tri_buf_56
Xbit__13__bus_buf bus_pre_w[13] bus[13] n9 VSS VDD_1V8 tri_buf_57
Xbit__12__bus_buf bus_pre_w[12] bus[12] n9 VSS VDD_1V8 tri_buf_58
Xbit__11__bus_buf bus_pre_w[11] bus[11] n9 VSS VDD_1V8 tri_buf_59
Xbit__10__bus_buf bus_pre_w[10] bus[10] n9 VSS VDD_1V8 tri_buf_60
Xbit__9__bus_buf bus_pre_w[9] bus[9] n9 VSS VDD_1V8 tri_buf_61
Xbit__8__bus_buf bus_pre_w[8] bus[8] n9 VSS VDD_1V8 tri_buf_62
Xbit__7__bus_buf bus_pre_w[7] bus[7] n9 VSS VDD_1V8 tri_buf_63
Xbit__6__bus_buf bus_pre_w[6] bus[6] n9 VSS VDD_1V8 tri_buf_64
Xbit__5__bus_buf bus_pre_w[5] bus[5] n9 VSS VDD_1V8 tri_buf_65
Xbit__4__bus_buf bus_pre_w[4] bus[4] n9 VSS VDD_1V8 tri_buf_66
Xbit__3__bus_buf bus_pre_w[3] bus[3] n9 VSS VDD_1V8 tri_buf_67
Xbit__2__bus_buf bus_pre_w[2] bus[2] n9 VSS VDD_1V8 tri_buf_68
Xbit__1__bus_buf bus_pre_w[1] bus[1] n9 VSS VDD_1V8 tri_buf_69
Xbit__0__bus_buf bus_pre_w[0] bus[0] n9 VSS VDD_1V8 tri_buf_70
Xprll_cntrl clk reset n2 D_push[63] D_push[62] pndng ld_w rst_w n7 n3 push pop trn_chng
+ wrt n3 VSS VDD_1V8 rst_w n6 IN0 IN1 clk_cts_4 prll_intrfs_cntrl_riscv_2_7_3
XD_reg_wt ld_w rst_w VSS D_pop[63] D_pop[62] D_pop[61] D_pop[60] D_pop[59] D_pop[58]
+ D_pop[57] D_pop[56] D_pop[55] D_pop[54] D_pop[53] D_pop[52] D_pop[51] D_pop[50]
+ D_pop[49] D_pop[48] D_pop[47] D_pop[46] D_pop[45] D_pop[44] D_pop[43] D_pop[42]
+ D_pop[41] D_pop[40] D_pop[39] D_pop[38] D_pop[37] D_pop[36] D_pop[35] D_pop[34]
+ D_pop[33] D_pop[32] D_pop[31] D_pop[30] D_pop[29] D_pop[28] D_pop[27] D_pop[26]
+ D_pop[25] D_pop[24] D_pop[23] D_pop[22] D_pop[21] D_pop[20] D_pop[19] D_pop[18]
+ D_pop[17] D_pop[16] D_pop[15] D_pop[14] D_pop[13] D_pop[12] D_pop[11] D_pop[10]
+ D_pop[9] D_pop[8] D_pop[7] D_pop[6] D_pop[5] D_pop[4] D_pop[3] D_pop[2] D_pop[1]
+ D_pop[0] SYNOPSYS_UNCONNECTED_1 bus_pre_w[63] bus_pre_w[62] bus_pre_w[61] bus_pre_w[60]
+ bus_pre_w[59] bus_pre_w[58] bus_pre_w[57] bus_pre_w[56] bus_pre_w[55] bus_pre_w[54]
+ bus_pre_w[53] bus_pre_w[52] bus_pre_w[51] bus_pre_w[50] bus_pre_w[49] bus_pre_w[48]
+ bus_pre_w[47] bus_pre_w[46] bus_pre_w[45] bus_pre_w[44] bus_pre_w[43] bus_pre_w[42]
+ bus_pre_w[41] bus_pre_w[40] bus_pre_w[39] bus_pre_w[38] bus_pre_w[37] bus_pre_w[36]
+ bus_pre_w[35] bus_pre_w[34] bus_pre_w[33] bus_pre_w[32] bus_pre_w[31] bus_pre_w[30]
+ bus_pre_w[29] bus_pre_w[28] bus_pre_w[27] bus_pre_w[26] bus_pre_w[25] bus_pre_w[24]
+ bus_pre_w[23] bus_pre_w[22] bus_pre_w[21] bus_pre_w[20] bus_pre_w[19] bus_pre_w[18]
+ bus_pre_w[17] bus_pre_w[16] bus_pre_w[15] bus_pre_w[14] bus_pre_w[13] bus_pre_w[12]
+ bus_pre_w[11] bus_pre_w[10] bus_pre_w[9] bus_pre_w[8] bus_pre_w[7] bus_pre_w[6]
+ bus_pre_w[5] bus_pre_w[4] bus_pre_w[3] bus_pre_w[2] bus_pre_w[1] bus_pre_w[0]
+ VSS VDD_1V8 rst_w prll_d_reg_bits65_14
XD_reg_rd ld_r n7 bus[64] bus[63] bus[62] bus[61] bus[60] bus[59] bus[58] bus[57]
+ bus[56] bus[55] bus[54] bus[53] bus[52] bus[51] bus[50] bus[49] bus[48] bus[47]
+ bus[46] bus[45] bus[44] bus[43] bus[42] bus[41] bus[40] bus[39] bus[38] bus[37]
+ bus[36] bus[35] bus[34] bus[33] bus[32] bus[31] bus[30] bus[29] bus[28] bus[27]
+ bus[26] bus[25] bus[24] bus[23] bus[22] bus[21] bus[20] bus[19] bus[18] bus[17]
+ bus[16] bus[15] bus[14] bus[13] bus[12] bus[11] bus[10] bus[9] bus[8] bus[7] bus[6]
+ bus[5] bus[4] bus[3] bus[2] bus[1] bus[0] n2 D_push[63] D_push[62] D_push[61]
+ D_push[60] D_push[59] D_push[58] D_push[57] D_push[56] D_push[55] D_push[54] D_push[53]
+ D_push[52] D_push[51] D_push[50] D_push[49] D_push[48] D_push[47] D_push[46] D_push[45]
+ D_push[44] D_push[43] D_push[42] D_push[41] D_push[40] D_push[39] D_push[38] D_push[37]
+ D_push[36] D_push[35] D_push[34] D_push[33] D_push[32] D_push[31] D_push[30] D_push[29]
+ D_push[28] D_push[27] D_push[26] D_push[25] D_push[24] D_push[23] D_push[22] D_push[21]
+ D_push[20] D_push[19] D_push[18] D_push[17] D_push[16] D_push[15] D_push[14] D_push[13]
+ D_push[12] D_push[11] D_push[10] D_push[9] D_push[8] D_push[7] D_push[6] D_push[5]
+ D_push[4] D_push[3] D_push[2] D_push[1] D_push[0] VSS VDD_1V8 prll_d_reg_bits65_15
Xplace1 VSS VDD_1V8 n6 n3 BUHDLLX1
XU1 VSS VDD_1V8 ld_r wrt n3 NO2I1HDLLX1
Xplace3 VSS VDD_1V8 n9 n3 BUHDLLX0
.ENDS

.SUBCKT tec_riscv_bus clk reset pndng_mbc pndng_spi pndng_uart push_mbc push_spi
+ push_uart pop_mbc pop_spi pop_uart D_pop_mbc[64] D_pop_mbc[63] D_pop_mbc[62] D_pop_mbc[61]
+ D_pop_mbc[60] D_pop_mbc[59] D_pop_mbc[58] D_pop_mbc[57] D_pop_mbc[56] D_pop_mbc[55]
+ D_pop_mbc[54] D_pop_mbc[53] D_pop_mbc[52] D_pop_mbc[51] D_pop_mbc[50] D_pop_mbc[49]
+ D_pop_mbc[48] D_pop_mbc[47] D_pop_mbc[46] D_pop_mbc[45] D_pop_mbc[44] D_pop_mbc[43]
+ D_pop_mbc[42] D_pop_mbc[41] D_pop_mbc[40] D_pop_mbc[39] D_pop_mbc[38] D_pop_mbc[37]
+ D_pop_mbc[36] D_pop_mbc[35] D_pop_mbc[34] D_pop_mbc[33] D_pop_mbc[32] D_pop_mbc[31]
+ D_pop_mbc[30] D_pop_mbc[29] D_pop_mbc[28] D_pop_mbc[27] D_pop_mbc[26] D_pop_mbc[25]
+ D_pop_mbc[24] D_pop_mbc[23] D_pop_mbc[22] D_pop_mbc[21] D_pop_mbc[20] D_pop_mbc[19]
+ D_pop_mbc[18] D_pop_mbc[17] D_pop_mbc[16] D_pop_mbc[15] D_pop_mbc[14] D_pop_mbc[13]
+ D_pop_mbc[12] D_pop_mbc[11] D_pop_mbc[10] D_pop_mbc[9] D_pop_mbc[8] D_pop_mbc[7]
+ D_pop_mbc[6] D_pop_mbc[5] D_pop_mbc[4] D_pop_mbc[3] D_pop_mbc[2] D_pop_mbc[1]
+ D_pop_mbc[0] D_pop_spi[64] D_pop_spi[63] D_pop_spi[62] D_pop_spi[61] D_pop_spi[60]
+ D_pop_spi[59] D_pop_spi[58] D_pop_spi[57] D_pop_spi[56] D_pop_spi[55] D_pop_spi[54]
+ D_pop_spi[53] D_pop_spi[52] D_pop_spi[51] D_pop_spi[50] D_pop_spi[49] D_pop_spi[48]
+ D_pop_spi[47] D_pop_spi[46] D_pop_spi[45] D_pop_spi[44] D_pop_spi[43] D_pop_spi[42]
+ D_pop_spi[41] D_pop_spi[40] D_pop_spi[39] D_pop_spi[38] D_pop_spi[37] D_pop_spi[36]
+ D_pop_spi[35] D_pop_spi[34] D_pop_spi[33] D_pop_spi[32] D_pop_spi[31] D_pop_spi[30]
+ D_pop_spi[29] D_pop_spi[28] D_pop_spi[27] D_pop_spi[26] D_pop_spi[25] D_pop_spi[24]
+ D_pop_spi[23] D_pop_spi[22] D_pop_spi[21] D_pop_spi[20] D_pop_spi[19] D_pop_spi[18]
+ D_pop_spi[17] D_pop_spi[16] D_pop_spi[15] D_pop_spi[14] D_pop_spi[13] D_pop_spi[12]
+ D_pop_spi[11] D_pop_spi[10] D_pop_spi[9] D_pop_spi[8] D_pop_spi[7] D_pop_spi[6]
+ D_pop_spi[5] D_pop_spi[4] D_pop_spi[3] D_pop_spi[2] D_pop_spi[1] D_pop_spi[0]
+ D_pop_uart[64] D_pop_uart[63] D_pop_uart[62] D_pop_uart[61] D_pop_uart[60] D_pop_uart[59]
+ D_pop_uart[58] D_pop_uart[57] D_pop_uart[56] D_pop_uart[55] D_pop_uart[54] D_pop_uart[53]
+ D_pop_uart[52] D_pop_uart[51] D_pop_uart[50] D_pop_uart[49] D_pop_uart[48] D_pop_uart[47]
+ D_pop_uart[46] D_pop_uart[45] D_pop_uart[44] D_pop_uart[43] D_pop_uart[42] D_pop_uart[41]
+ D_pop_uart[40] D_pop_uart[39] D_pop_uart[38] D_pop_uart[37] D_pop_uart[36] D_pop_uart[35]
+ D_pop_uart[34] D_pop_uart[33] D_pop_uart[32] D_pop_uart[31] D_pop_uart[30] D_pop_uart[29]
+ D_pop_uart[28] D_pop_uart[27] D_pop_uart[26] D_pop_uart[25] D_pop_uart[24] D_pop_uart[23]
+ D_pop_uart[22] D_pop_uart[21] D_pop_uart[20] D_pop_uart[19] D_pop_uart[18] D_pop_uart[17]
+ D_pop_uart[16] D_pop_uart[15] D_pop_uart[14] D_pop_uart[13] D_pop_uart[12] D_pop_uart[11]
+ D_pop_uart[10] D_pop_uart[9] D_pop_uart[8] D_pop_uart[7] D_pop_uart[6] D_pop_uart[5]
+ D_pop_uart[4] D_pop_uart[3] D_pop_uart[2] D_pop_uart[1] D_pop_uart[0] D_push_mbc[64]
+ D_push_mbc[63] D_push_mbc[62] D_push_mbc[61] D_push_mbc[60] D_push_mbc[59] D_push_mbc[58]
+ D_push_mbc[57] D_push_mbc[56] D_push_mbc[55] D_push_mbc[54] D_push_mbc[53] D_push_mbc[52]
+ D_push_mbc[51] D_push_mbc[50] D_push_mbc[49] D_push_mbc[48] D_push_mbc[47] D_push_mbc[46]
+ D_push_mbc[45] D_push_mbc[44] D_push_mbc[43] D_push_mbc[42] D_push_mbc[41] D_push_mbc[40]
+ D_push_mbc[39] D_push_mbc[38] D_push_mbc[37] D_push_mbc[36] D_push_mbc[35] D_push_mbc[34]
+ D_push_mbc[33] D_push_mbc[32] D_push_mbc[31] D_push_mbc[30] D_push_mbc[29] D_push_mbc[28]
+ D_push_mbc[27] D_push_mbc[26] D_push_mbc[25] D_push_mbc[24] D_push_mbc[23] D_push_mbc[22]
+ D_push_mbc[21] D_push_mbc[20] D_push_mbc[19] D_push_mbc[18] D_push_mbc[17] D_push_mbc[16]
+ D_push_mbc[15] D_push_mbc[14] D_push_mbc[13] D_push_mbc[12] D_push_mbc[11] D_push_mbc[10]
+ D_push_mbc[9] D_push_mbc[8] D_push_mbc[7] D_push_mbc[6] D_push_mbc[5] D_push_mbc[4]
+ D_push_mbc[3] D_push_mbc[2] D_push_mbc[1] D_push_mbc[0] D_push_spi[64] D_push_spi[63]
+ D_push_spi[62] D_push_spi[61] D_push_spi[60] D_push_spi[59] D_push_spi[58] D_push_spi[57]
+ D_push_spi[56] D_push_spi[55] D_push_spi[54] D_push_spi[53] D_push_spi[52] D_push_spi[51]
+ D_push_spi[50] D_push_spi[49] D_push_spi[48] D_push_spi[47] D_push_spi[46] D_push_spi[45]
+ D_push_spi[44] D_push_spi[43] D_push_spi[42] D_push_spi[41] D_push_spi[40] D_push_spi[39]
+ D_push_spi[38] D_push_spi[37] D_push_spi[36] D_push_spi[35] D_push_spi[34] D_push_spi[33]
+ D_push_spi[32] D_push_spi[31] D_push_spi[30] D_push_spi[29] D_push_spi[28] D_push_spi[27]
+ D_push_spi[26] D_push_spi[25] D_push_spi[24] D_push_spi[23] D_push_spi[22] D_push_spi[21]
+ D_push_spi[20] D_push_spi[19] D_push_spi[18] D_push_spi[17] D_push_spi[16] D_push_spi[15]
+ D_push_spi[14] D_push_spi[13] D_push_spi[12] D_push_spi[11] D_push_spi[10] D_push_spi[9]
+ D_push_spi[8] D_push_spi[7] D_push_spi[6] D_push_spi[5] D_push_spi[4] D_push_spi[3]
+ D_push_spi[2] D_push_spi[1] D_push_spi[0] D_push_uart[64] D_push_uart[63] D_push_uart[62]
+ D_push_uart[61] D_push_uart[60] D_push_uart[59] D_push_uart[58] D_push_uart[57]
+ D_push_uart[56] D_push_uart[55] D_push_uart[54] D_push_uart[53] D_push_uart[52]
+ D_push_uart[51] D_push_uart[50] D_push_uart[49] D_push_uart[48] D_push_uart[47]
+ D_push_uart[46] D_push_uart[45] D_push_uart[44] D_push_uart[43] D_push_uart[42]
+ D_push_uart[41] D_push_uart[40] D_push_uart[39] D_push_uart[38] D_push_uart[37]
+ D_push_uart[36] D_push_uart[35] D_push_uart[34] D_push_uart[33] D_push_uart[32]
+ D_push_uart[31] D_push_uart[30] D_push_uart[29] D_push_uart[28] D_push_uart[27]
+ D_push_uart[26] D_push_uart[25] D_push_uart[24] D_push_uart[23] D_push_uart[22]
+ D_push_uart[21] D_push_uart[20] D_push_uart[19] D_push_uart[18] D_push_uart[17]
+ D_push_uart[16] D_push_uart[15] D_push_uart[14] D_push_uart[13] D_push_uart[12]
+ D_push_uart[11] D_push_uart[10] D_push_uart[9] D_push_uart[8] D_push_uart[7] D_push_uart[6]
+ D_push_uart[5] D_push_uart[4] D_push_uart[3] D_push_uart[2] D_push_uart[1] D_push_uart[0]
+ VSS VDD_1V8 IN0 IN1 IN2 IN3 IN4 IN5 IN6 IN7 IN8 IN9 IN10 IN11 IN12 IN13 IN14 IN15
+ IN16 IN17 IN18 IN19 IN20 IN21 IN22 IN23 IN24 IN25 IN26 IN27 IN28 IN29 IN30 IN31
+ IN32 IN33 IN34 IN35 IN36 IN37 IN38 IN39 IN40 IN41 IN42 IN43 IN44 IN45 IN46 IN47
+ IN48 IN49 IN50 IN51 IN52 IN53 IN54 IN55 IN56 IN57 IN58 IN59 IN60 IN61 IN62 IN63
+ IN64 IN65 IN66 IN67 IN68 IN69 IN70 IN71 IN72 IN73 IN74 IN75 IN76 IN77 IN78 IN79
+ IN80 IN81 IN82 IN83 IN84 IN85 IN86 IN87 IN88 IN89 IN90 IN91 IN92 IN93 IN94 IN95
+ IN96 IN97 IN98 IN99 IN100 IN101 IN102 IN103 IN104 IN105 IN106 IN107 IN108 IN109
+ IN110 IN111 IN112 IN113 IN114 IN115 IN116 IN117 IN118 IN119 IN120 IN121 IN122
+ IN123 IN124 IN125 IN126 IN127 IN128 IN129 IN130 IN131 IN132 IN133 IN134 IN135
+ IN136 IN137 IN138 IN139 IN140 IN141 IN142 IN143 IN144 IN145 IN146 IN147 IN148
+ IN149 IN150 IN151 IN152 IN153 IN154 IN155 IN156 IN157 IN158 IN159 IN160 IN161
+ IN162 IN163 IN164 IN165 IN166 IN167 IN168 IN169 IN170 IN171 IN172 IN173 IN174
+ IN175 IN176 IN177 IN178 IN179 IN180 IN181 IN182 IN183 IN184 IN185 IN186 IN187
+ IN188 IN189 IN190 IN191 IN192 IN193 IN194 IN195 IN196 IN197 IN198 IN199 IN200
+ IN201 IN202 IN203 IN204 IN205 IN206 IN207 IN208 IN209 IN210 IN211 IN212 IN213
+ IN214 IN215 IN216 IN217 IN218 IN219 IN220 IN221 IN222 IN223 IN224 IN225 clk_cts_4
+ clk_cts_6 clk_cts_9 clk_cts_0_1
Xfifo_in_uart VSS D_push_uart[63] D_push_uart[62] D_push_uart[61] D_push_uart[60]
+ D_push_uart[59] D_push_uart[58] D_push_uart[57] D_push_uart[56] D_push_uart[55]
+ D_push_uart[54] D_push_uart[53] D_push_uart[52] D_push_uart[51] D_push_uart[50]
+ D_push_uart[49] D_push_uart[48] D_push_uart[47] D_push_uart[46] D_push_uart[45]
+ D_push_uart[44] D_push_uart[43] D_push_uart[42] D_push_uart[41] D_push_uart[40]
+ D_push_uart[39] D_push_uart[38] D_push_uart[37] D_push_uart[36] D_push_uart[35]
+ D_push_uart[34] D_push_uart[33] D_push_uart[32] D_push_uart[31] D_push_uart[30]
+ D_push_uart[29] D_push_uart[28] D_push_uart[27] D_push_uart[26] D_push_uart[25]
+ D_push_uart[24] D_push_uart[23] D_push_uart[22] D_push_uart[21] D_push_uart[20]
+ D_push_uart[19] D_push_uart[18] D_push_uart[17] D_push_uart[16] D_push_uart[15]
+ D_push_uart[14] D_push_uart[13] D_push_uart[12] D_push_uart[11] D_push_uart[10]
+ D_push_uart[9] D_push_uart[8] D_push_uart[7] D_push_uart[6] D_push_uart[5] D_push_uart[4]
+ D_push_uart[3] D_push_uart[2] D_push_uart[1] D_push_uart[0] SYNOPSYS_UNCONNECTED_1
+ D_pop_uart_int[63] D_pop_uart_int[62] D_pop_uart_int[61] D_pop_uart_int[60] D_pop_uart_int[59]
+ D_pop_uart_int[58] D_pop_uart_int[57] D_pop_uart_int[56] D_pop_uart_int[55] D_pop_uart_int[54]
+ D_pop_uart_int[53] D_pop_uart_int[52] D_pop_uart_int[51] D_pop_uart_int[50] D_pop_uart_int[49]
+ D_pop_uart_int[48] D_pop_uart_int[47] D_pop_uart_int[46] D_pop_uart_int[45] D_pop_uart_int[44]
+ D_pop_uart_int[43] D_pop_uart_int[42] D_pop_uart_int[41] D_pop_uart_int[40] D_pop_uart_int[39]
+ D_pop_uart_int[38] D_pop_uart_int[37] D_pop_uart_int[36] D_pop_uart_int[35] D_pop_uart_int[34]
+ D_pop_uart_int[33] D_pop_uart_int[32] D_pop_uart_int[31] D_pop_uart_int[30] D_pop_uart_int[29]
+ D_pop_uart_int[28] D_pop_uart_int[27] D_pop_uart_int[26] D_pop_uart_int[25] D_pop_uart_int[24]
+ D_pop_uart_int[23] D_pop_uart_int[22] D_pop_uart_int[21] D_pop_uart_int[20] D_pop_uart_int[19]
+ D_pop_uart_int[18] D_pop_uart_int[17] D_pop_uart_int[16] D_pop_uart_int[15] D_pop_uart_int[14]
+ D_pop_uart_int[13] D_pop_uart_int[12] D_pop_uart_int[11] D_pop_uart_int[10] D_pop_uart_int[9]
+ D_pop_uart_int[8] D_pop_uart_int[7] D_pop_uart_int[6] D_pop_uart_int[5] D_pop_uart_int[4]
+ D_pop_uart_int[3] D_pop_uart_int[2] D_pop_uart_int[1] D_pop_uart_int[0] push_uart
+ pop_uart_int clk pndng_uart_int IN220 VSS VDD_1V8 clk_cts_0_1 fifo_flops_no_full_depth2_bits65_0
Xfifo_out_uart VSS D_push_uart_int[63] D_push_uart_int[62] D_push_uart_int[61] D_push_uart_int[60]
+ D_push_uart_int[59] D_push_uart_int[58] D_push_uart_int[57] D_push_uart_int[56]
+ D_push_uart_int[55] D_push_uart_int[54] D_push_uart_int[53] D_push_uart_int[52]
+ D_push_uart_int[51] D_push_uart_int[50] D_push_uart_int[49] D_push_uart_int[48]
+ D_push_uart_int[47] D_push_uart_int[46] D_push_uart_int[45] D_push_uart_int[44]
+ D_push_uart_int[43] D_push_uart_int[42] D_push_uart_int[41] D_push_uart_int[40]
+ D_push_uart_int[39] D_push_uart_int[38] D_push_uart_int[37] D_push_uart_int[36]
+ D_push_uart_int[35] D_push_uart_int[34] D_push_uart_int[33] D_push_uart_int[32]
+ D_push_uart_int[31] D_push_uart_int[30] D_push_uart_int[29] D_push_uart_int[28]
+ D_push_uart_int[27] D_push_uart_int[26] D_push_uart_int[25] D_push_uart_int[24]
+ D_push_uart_int[23] D_push_uart_int[22] D_push_uart_int[21] D_push_uart_int[20]
+ D_push_uart_int[19] D_push_uart_int[18] D_push_uart_int[17] D_push_uart_int[16]
+ D_push_uart_int[15] D_push_uart_int[14] D_push_uart_int[13] D_push_uart_int[12]
+ D_push_uart_int[11] D_push_uart_int[10] D_push_uart_int[9] D_push_uart_int[8]
+ D_push_uart_int[7] D_push_uart_int[6] D_push_uart_int[5] D_push_uart_int[4] D_push_uart_int[3]
+ D_push_uart_int[2] D_push_uart_int[1] D_push_uart_int[0] SYNOPSYS_UNCONNECTED_2
+ D_pop_uart[63] D_pop_uart[62] D_pop_uart[61] D_pop_uart[60] D_pop_uart[59] D_pop_uart[58]
+ D_pop_uart[57] D_pop_uart[56] D_pop_uart[55] D_pop_uart[54] D_pop_uart[53] D_pop_uart[52]
+ D_pop_uart[51] D_pop_uart[50] D_pop_uart[49] D_pop_uart[48] D_pop_uart[47] D_pop_uart[46]
+ D_pop_uart[45] D_pop_uart[44] D_pop_uart[43] D_pop_uart[42] D_pop_uart[41] D_pop_uart[40]
+ D_pop_uart[39] D_pop_uart[38] D_pop_uart[37] D_pop_uart[36] D_pop_uart[35] D_pop_uart[34]
+ D_pop_uart[33] D_pop_uart[32] D_pop_uart[31] D_pop_uart[30] D_pop_uart[29] D_pop_uart[28]
+ D_pop_uart[27] D_pop_uart[26] D_pop_uart[25] D_pop_uart[24] D_pop_uart[23] D_pop_uart[22]
+ D_pop_uart[21] D_pop_uart[20] D_pop_uart[19] D_pop_uart[18] D_pop_uart[17] D_pop_uart[16]
+ D_pop_uart[15] D_pop_uart[14] D_pop_uart[13] D_pop_uart[12] D_pop_uart[11] D_pop_uart[10]
+ D_pop_uart[9] D_pop_uart[8] D_pop_uart[7] D_pop_uart[6] D_pop_uart[5] D_pop_uart[4]
+ D_pop_uart[3] D_pop_uart[2] D_pop_uart[1] D_pop_uart[0] push_uart_int pop_uart
+ clk_cts_6 pndng_uart IN106 VSS VDD_1V8 n123 n123 n123 n123 n123 n123 n123 n123
+ n123 n123 n123 n123 n123 n123 n123 n123 n123 n123 n123 n123 n123 n123 n123 n122
+ n122 n122 n122 n122 n122 n122 n122 n122 n122 n122 n122 n122 n122 n122 n122 n122
+ n122 n122 n122 n122 n122 n122 n122 n122 n122 n122 n122 n122 n122 n122 n122 n122
+ n122 n122 n122 n121 n121 n121 n121 n121 n121 n121 n121 n121 n121 n121 n121 n121
+ n121 n121 n121 n121 n121 n121 n121 n121 IN109 IN110 IN111 IN112 IN113 IN114 IN115
+ IN116 IN117 IN118 IN119 IN120 IN121 IN122 IN123 IN124 IN125 IN126 IN127 IN128
+ IN129 IN130 IN131 IN132 IN133 clk_cts_9 fifo_flops_no_full_depth2_bits65_1
Xfifo_in_spi VSS VSS VSS VSS D_push_spi[60] D_push_spi[59] D_push_spi[58] D_push_spi[57]
+ D_push_spi[56] D_push_spi[55] D_push_spi[54] D_push_spi[53] D_push_spi[52] D_push_spi[51]
+ D_push_spi[50] D_push_spi[49] D_push_spi[48] D_push_spi[47] D_push_spi[46] D_push_spi[45]
+ D_push_spi[44] D_push_spi[43] D_push_spi[42] D_push_spi[41] D_push_spi[40] D_push_spi[39]
+ D_push_spi[38] D_push_spi[37] D_push_spi[36] D_push_spi[35] D_push_spi[34] D_push_spi[33]
+ D_push_spi[32] D_push_spi[31] D_push_spi[30] D_push_spi[29] D_push_spi[28] D_push_spi[27]
+ D_push_spi[26] D_push_spi[25] D_push_spi[24] D_push_spi[23] D_push_spi[22] D_push_spi[21]
+ D_push_spi[20] D_push_spi[19] D_push_spi[18] D_push_spi[17] D_push_spi[16] D_push_spi[15]
+ D_push_spi[14] D_push_spi[13] D_push_spi[12] D_push_spi[11] D_push_spi[10] D_push_spi[9]
+ D_push_spi[8] D_push_spi[7] D_push_spi[6] D_push_spi[5] D_push_spi[4] D_push_spi[3]
+ D_push_spi[2] D_push_spi[1] D_push_spi[0] SYNOPSYS_UNCONNECTED_3 SYNOPSYS_UNCONNECTED_4
+ SYNOPSYS_UNCONNECTED_5 SYNOPSYS_UNCONNECTED_6 D_pop_spi_int[60] D_pop_spi_int[59]
+ D_pop_spi_int[58] D_pop_spi_int[57] D_pop_spi_int[56] D_pop_spi_int[55] D_pop_spi_int[54]
+ D_pop_spi_int[53] D_pop_spi_int[52] D_pop_spi_int[51] D_pop_spi_int[50] D_pop_spi_int[49]
+ D_pop_spi_int[48] D_pop_spi_int[47] D_pop_spi_int[46] D_pop_spi_int[45] D_pop_spi_int[44]
+ D_pop_spi_int[43] D_pop_spi_int[42] D_pop_spi_int[41] D_pop_spi_int[40] D_pop_spi_int[39]
+ D_pop_spi_int[38] D_pop_spi_int[37] D_pop_spi_int[36] D_pop_spi_int[35] D_pop_spi_int[34]
+ D_pop_spi_int[33] D_pop_spi_int[32] D_pop_spi_int[31] D_pop_spi_int[30] D_pop_spi_int[29]
+ D_pop_spi_int[28] D_pop_spi_int[27] D_pop_spi_int[26] D_pop_spi_int[25] D_pop_spi_int[24]
+ D_pop_spi_int[23] D_pop_spi_int[22] D_pop_spi_int[21] D_pop_spi_int[20] D_pop_spi_int[19]
+ D_pop_spi_int[18] D_pop_spi_int[17] D_pop_spi_int[16] D_pop_spi_int[15] D_pop_spi_int[14]
+ D_pop_spi_int[13] D_pop_spi_int[12] D_pop_spi_int[11] D_pop_spi_int[10] D_pop_spi_int[9]
+ D_pop_spi_int[8] D_pop_spi_int[7] D_pop_spi_int[6] D_pop_spi_int[5] D_pop_spi_int[4]
+ D_pop_spi_int[3] D_pop_spi_int[2] D_pop_spi_int[1] D_pop_spi_int[0] push_spi pop_spi_int
+ clk_cts_6 pndng_spi_int IN66 VSS VDD_1V8 n123 n94 n94 n94 n94 n94 n94 n94 n94
+ n94 n94 n94 n94 n94 n94 n59 n59 n59 n59 n59 n59 n59 n59 n59 n59 n59 n59 n59 n59
+ n59 n59 n59 n59 n59 n59 n59 n59 n59 n59 n59 n59 n59 n59 n59 n59 n59 n59 n59 n59
+ n59 n59 n7 n7 n7 n7 n7 n7 n7 n7 n7 n7 n7 n7 n7 IN223 clk_cts_9 fifo_flops_no_full_depth2_bits65_2
Xfifo_out_spi D_push_spi_int[64] D_push_spi_int[63] D_push_spi_int[62] VSS VSS D_push_spi_int[59]
+ D_push_spi_int[58] D_push_spi_int[57] VSS VSS D_push_spi_int[54] D_push_spi_int[53]
+ D_push_spi_int[52] D_push_spi_int[51] D_push_spi_int[50] D_push_spi_int[49] D_push_spi_int[48]
+ D_push_spi_int[47] D_push_spi_int[46] D_push_spi_int[45] D_push_spi_int[44] D_push_spi_int[43]
+ D_push_spi_int[42] D_push_spi_int[41] D_push_spi_int[40] D_push_spi_int[39] D_push_spi_int[38]
+ D_push_spi_int[37] D_push_spi_int[36] D_push_spi_int[35] D_push_spi_int[34] D_push_spi_int[33]
+ D_push_spi_int[32] D_push_spi_int[31] D_push_spi_int[30] D_push_spi_int[29] D_push_spi_int[28]
+ D_push_spi_int[27] D_push_spi_int[26] D_push_spi_int[25] D_push_spi_int[24] D_push_spi_int[23]
+ D_push_spi_int[22] D_push_spi_int[21] D_push_spi_int[20] D_push_spi_int[19] D_push_spi_int[18]
+ D_push_spi_int[17] D_push_spi_int[16] D_push_spi_int[15] D_push_spi_int[14] D_push_spi_int[13]
+ D_push_spi_int[12] D_push_spi_int[11] D_push_spi_int[10] D_push_spi_int[9] D_push_spi_int[8]
+ D_push_spi_int[7] D_push_spi_int[6] D_push_spi_int[5] D_push_spi_int[4] D_push_spi_int[3]
+ D_push_spi_int[2] D_push_spi_int[1] D_push_spi_int[0] D_pop_spi[64] D_pop_spi[63]
+ D_pop_spi[62] SYNOPSYS_UNCONNECTED_7 SYNOPSYS_UNCONNECTED_8 D_pop_spi[59] D_pop_spi[58]
+ D_pop_spi[57] SYNOPSYS_UNCONNECTED_9 SYNOPSYS_UNCONNECTED_10 D_pop_spi[54] D_pop_spi[53]
+ D_pop_spi[52] D_pop_spi[51] D_pop_spi[50] D_pop_spi[49] D_pop_spi[48] D_pop_spi[47]
+ D_pop_spi[46] D_pop_spi[45] D_pop_spi[44] D_pop_spi[43] D_pop_spi[42] D_pop_spi[41]
+ D_pop_spi[40] D_pop_spi[39] D_pop_spi[38] D_pop_spi[37] D_pop_spi[36] D_pop_spi[35]
+ D_pop_spi[34] D_pop_spi[33] D_pop_spi[32] D_pop_spi[31] D_pop_spi[30] D_pop_spi[29]
+ D_pop_spi[28] D_pop_spi[27] D_pop_spi[26] D_pop_spi[25] D_pop_spi[24] D_pop_spi[23]
+ D_pop_spi[22] D_pop_spi[21] D_pop_spi[20] D_pop_spi[19] D_pop_spi[18] D_pop_spi[17]
+ D_pop_spi[16] D_pop_spi[15] D_pop_spi[14] D_pop_spi[13] D_pop_spi[12] D_pop_spi[11]
+ D_pop_spi[10] D_pop_spi[9] D_pop_spi[8] D_pop_spi[7] D_pop_spi[6] D_pop_spi[5]
+ D_pop_spi[4] D_pop_spi[3] D_pop_spi[2] D_pop_spi[1] D_pop_spi[0] push_spi_int
+ pop_spi clk_cts_4 pndng_spi n122 VSS VDD_1V8 n121 n121 n121 n121 n121 n7 n7 n7
+ n7 n7 n7 n7 n7 n7 n7 n7 n7 n7 n7 n7 n7 n7 n7 n7 n7 n7 n7 n7 n7 IN225 clk_cts_9 fifo_flops_no_full_depth2_bits65_3
Xfifo_in_mbc VSS D_push_mbc[63] D_push_mbc[62] VSS VSS D_push_mbc[59] D_push_mbc[58]
+ D_push_mbc[57] D_push_mbc[56] D_push_mbc[55] D_push_mbc[54] D_push_mbc[53] D_push_mbc[52]
+ D_push_mbc[51] D_push_mbc[50] D_push_mbc[49] D_push_mbc[48] D_push_mbc[47] D_push_mbc[46]
+ D_push_mbc[45] D_push_mbc[44] D_push_mbc[43] D_push_mbc[42] D_push_mbc[41] D_push_mbc[40]
+ D_push_mbc[39] D_push_mbc[38] D_push_mbc[37] D_push_mbc[36] D_push_mbc[35] D_push_mbc[34]
+ D_push_mbc[33] D_push_mbc[32] D_push_mbc[31] D_push_mbc[30] D_push_mbc[29] D_push_mbc[28]
+ D_push_mbc[27] D_push_mbc[26] D_push_mbc[25] D_push_mbc[24] D_push_mbc[23] D_push_mbc[22]
+ D_push_mbc[21] D_push_mbc[20] D_push_mbc[19] D_push_mbc[18] D_push_mbc[17] D_push_mbc[16]
+ D_push_mbc[15] D_push_mbc[14] D_push_mbc[13] D_push_mbc[12] D_push_mbc[11] D_push_mbc[10]
+ D_push_mbc[9] D_push_mbc[8] D_push_mbc[7] D_push_mbc[6] D_push_mbc[5] D_push_mbc[4]
+ D_push_mbc[3] D_push_mbc[2] D_push_mbc[1] D_push_mbc[0] SYNOPSYS_UNCONNECTED_11
+ D_pop_mbc_int[63] D_pop_mbc_int[62] SYNOPSYS_UNCONNECTED_12 SYNOPSYS_UNCONNECTED_13
+ D_pop_mbc_int[59] D_pop_mbc_int[58] D_pop_mbc_int[57] D_pop_mbc_int[56] D_pop_mbc_int[55]
+ D_pop_mbc_int[54] D_pop_mbc_int[53] D_pop_mbc_int[52] D_pop_mbc_int[51] D_pop_mbc_int[50]
+ D_pop_mbc_int[49] D_pop_mbc_int[48] D_pop_mbc_int[47] D_pop_mbc_int[46] D_pop_mbc_int[45]
+ D_pop_mbc_int[44] D_pop_mbc_int[43] D_pop_mbc_int[42] D_pop_mbc_int[41] D_pop_mbc_int[40]
+ D_pop_mbc_int[39] D_pop_mbc_int[38] D_pop_mbc_int[37] D_pop_mbc_int[36] D_pop_mbc_int[35]
+ D_pop_mbc_int[34] D_pop_mbc_int[33] D_pop_mbc_int[32] D_pop_mbc_int[31] D_pop_mbc_int[30]
+ D_pop_mbc_int[29] D_pop_mbc_int[28] D_pop_mbc_int[27] D_pop_mbc_int[26] D_pop_mbc_int[25]
+ D_pop_mbc_int[24] D_pop_mbc_int[23] D_pop_mbc_int[22] D_pop_mbc_int[21] D_pop_mbc_int[20]
+ D_pop_mbc_int[19] D_pop_mbc_int[18] D_pop_mbc_int[17] D_pop_mbc_int[16] D_pop_mbc_int[15]
+ D_pop_mbc_int[14] D_pop_mbc_int[13] D_pop_mbc_int[12] D_pop_mbc_int[11] D_pop_mbc_int[10]
+ D_pop_mbc_int[9] D_pop_mbc_int[8] D_pop_mbc_int[7] D_pop_mbc_int[6] D_pop_mbc_int[5]
+ D_pop_mbc_int[4] D_pop_mbc_int[3] D_pop_mbc_int[2] D_pop_mbc_int[1] D_pop_mbc_int[0]
+ push_mbc pop_mbc_int clk pndng_mbc_int n200 VSS VDD_1V8 n1 IN72 IN73 IN74 IN75
+ IN76 IN77 IN78 IN80 IN81 IN82 IN83 IN84 IN85 IN86 IN87 IN88 IN89 IN90 IN91 IN92
+ IN93 IN94 IN95 IN97 IN98 IN99 IN100 IN101 IN102 IN103 IN104 IN105 n94 n94 n94
+ n94 n94 n94 n94 n94 n94 n94 n94 n94 n94 n94 n94 n94 n94 n94 n94 n94 n94 n94 n94
+ n94 n94 n94 n94 n94 n94 n94 n94 n94 IN200 IN203 IN205 IN206 IN208 IN209 IN222
+ clk_cts_0_1 fifo_flops_no_full_depth3_bits65_0
Xfifo_out_mbc VSS VSS VSS D_push_mbc_int[61] D_push_mbc_int[60] D_push_mbc_int[59]
+ D_push_mbc_int[58] D_push_mbc_int[57] D_push_mbc_int[56] D_push_mbc_int[55] D_push_mbc_int[54]
+ D_push_mbc_int[53] D_push_mbc_int[52] D_push_mbc_int[51] D_push_mbc_int[50] D_push_mbc_int[49]
+ D_push_mbc_int[48] D_push_mbc_int[47] D_push_mbc_int[46] D_push_mbc_int[45] D_push_mbc_int[44]
+ D_push_mbc_int[43] D_push_mbc_int[42] D_push_mbc_int[41] D_push_mbc_int[40] D_push_mbc_int[39]
+ D_push_mbc_int[38] D_push_mbc_int[37] D_push_mbc_int[36] D_push_mbc_int[35] D_push_mbc_int[34]
+ D_push_mbc_int[33] D_push_mbc_int[32] D_push_mbc_int[31] D_push_mbc_int[30] D_push_mbc_int[29]
+ D_push_mbc_int[28] D_push_mbc_int[27] D_push_mbc_int[26] D_push_mbc_int[25] D_push_mbc_int[24]
+ D_push_mbc_int[23] D_push_mbc_int[22] D_push_mbc_int[21] D_push_mbc_int[20] D_push_mbc_int[19]
+ D_push_mbc_int[18] D_push_mbc_int[17] D_push_mbc_int[16] D_push_mbc_int[15] D_push_mbc_int[14]
+ D_push_mbc_int[13] D_push_mbc_int[12] D_push_mbc_int[11] D_push_mbc_int[10] D_push_mbc_int[9]
+ D_push_mbc_int[8] D_push_mbc_int[7] D_push_mbc_int[6] D_push_mbc_int[5] D_push_mbc_int[4]
+ D_push_mbc_int[3] D_push_mbc_int[2] D_push_mbc_int[1] D_push_mbc_int[0] SYNOPSYS_UNCONNECTED_14
+ SYNOPSYS_UNCONNECTED_15 SYNOPSYS_UNCONNECTED_16 D_pop_mbc[61] D_pop_mbc[60] D_pop_mbc[59]
+ D_pop_mbc[58] D_pop_mbc[57] D_pop_mbc[56] D_pop_mbc[55] D_pop_mbc[54] D_pop_mbc[53]
+ D_pop_mbc[52] D_pop_mbc[51] D_pop_mbc[50] D_pop_mbc[49] D_pop_mbc[48] D_pop_mbc[47]
+ D_pop_mbc[46] D_pop_mbc[45] D_pop_mbc[44] D_pop_mbc[43] D_pop_mbc[42] D_pop_mbc[41]
+ D_pop_mbc[40] D_pop_mbc[39] D_pop_mbc[38] D_pop_mbc[37] D_pop_mbc[36] D_pop_mbc[35]
+ D_pop_mbc[34] D_pop_mbc[33] D_pop_mbc[32] D_pop_mbc[31] D_pop_mbc[30] D_pop_mbc[29]
+ D_pop_mbc[28] D_pop_mbc[27] D_pop_mbc[26] D_pop_mbc[25] D_pop_mbc[24] D_pop_mbc[23]
+ D_pop_mbc[22] D_pop_mbc[21] D_pop_mbc[20] D_pop_mbc[19] D_pop_mbc[18] D_pop_mbc[17]
+ D_pop_mbc[16] D_pop_mbc[15] D_pop_mbc[14] D_pop_mbc[13] D_pop_mbc[12] D_pop_mbc[11]
+ D_pop_mbc[10] D_pop_mbc[9] D_pop_mbc[8] D_pop_mbc[7] D_pop_mbc[6] D_pop_mbc[5]
+ D_pop_mbc[4] D_pop_mbc[3] D_pop_mbc[2] D_pop_mbc[1] D_pop_mbc[0] push_mbc_int
+ pop_mbc clk pndng_mbc reset VSS VDD_1V8 IN0 IN1 IN2 IN3 IN4 IN5 IN6 IN7 IN8 IN9
+ IN10 IN11 IN12 IN13 IN14 IN15 IN16 IN17 IN18 IN19 IN20 IN21 IN22 IN23 IN24 IN25
+ IN26 IN27 IN28 IN29 IN30 IN31 IN32 IN33 n1 n1 n1 n1 n1 n1 n1 n1 n1 n1 n1 n1 n1
+ n1 n1 n1 n1 n1 n1 n1 n1 n1 n1 n1 n1 n1 n1 n1 n1 n1 n1 IN35 IN36 IN37 IN38 IN39
+ IN40 IN41 IN42 IN43 IN44 IN45 IN46 IN47 IN48 IN49 IN50 IN51 IN52 IN53 IN54 IN55
+ IN56 IN57 IN58 IN59 IN60 IN61 IN62 IN63 IN67 IN68 IN69 IN70 IN71 IN79 IN96 IN135
+ IN136 IN137 IN138 IN139 IN140 IN141 IN142 IN143 IN144 IN145 IN146 IN147 IN148
+ IN149 IN150 IN151 IN152 IN153 IN154 IN155 IN156 IN157 IN158 IN159 IN160 IN161
+ IN162 IN163 IN164 IN165 IN166 IN167 IN168 IN169 IN170 IN171 IN172 IN173 IN174
+ IN175 IN176 IN177 IN178 IN179 IN180 IN181 IN182 IN183 IN184 IN185 IN186 IN187
+ IN188 IN189 IN190 IN191 IN192 IN193 IN194 IN195 IN196 IN197 IN198 IN199 IN201
+ IN202 IN204 IN207 IN211 IN212 IN213 IN214 IN215 IN216 IN217 IN218 IN219 clk_cts_0_1 fifo_flops_no_full_depth3_bits65_1
Xuart_bs_ntrfs SYNOPSYS_UNCONNECTED_17 D_push_uart_int[63] D_push_uart_int[62] D_push_uart_int[61]
+ D_push_uart_int[60] D_push_uart_int[59] D_push_uart_int[58] D_push_uart_int[57]
+ D_push_uart_int[56] D_push_uart_int[55] D_push_uart_int[54] D_push_uart_int[53]
+ D_push_uart_int[52] D_push_uart_int[51] D_push_uart_int[50] D_push_uart_int[49]
+ D_push_uart_int[48] D_push_uart_int[47] D_push_uart_int[46] D_push_uart_int[45]
+ D_push_uart_int[44] D_push_uart_int[43] D_push_uart_int[42] D_push_uart_int[41]
+ D_push_uart_int[40] D_push_uart_int[39] D_push_uart_int[38] D_push_uart_int[37]
+ D_push_uart_int[36] D_push_uart_int[35] D_push_uart_int[34] D_push_uart_int[33]
+ D_push_uart_int[32] D_push_uart_int[31] D_push_uart_int[30] D_push_uart_int[29]
+ D_push_uart_int[28] D_push_uart_int[27] D_push_uart_int[26] D_push_uart_int[25]
+ D_push_uart_int[24] D_push_uart_int[23] D_push_uart_int[22] D_push_uart_int[21]
+ D_push_uart_int[20] D_push_uart_int[19] D_push_uart_int[18] D_push_uart_int[17]
+ D_push_uart_int[16] D_push_uart_int[15] D_push_uart_int[14] D_push_uart_int[13]
+ D_push_uart_int[12] D_push_uart_int[11] D_push_uart_int[10] D_push_uart_int[9]
+ D_push_uart_int[8] D_push_uart_int[7] D_push_uart_int[6] D_push_uart_int[5] D_push_uart_int[4]
+ D_push_uart_int[3] D_push_uart_int[2] D_push_uart_int[1] D_push_uart_int[0] pndng_uart_int
+ clk IN65 bus[64] bus[63] bus[62] bus[61] bus[60] bus[59] bus[58] bus[57] bus[56]
+ bus[55] bus[54] bus[53] bus[52] bus[51] bus[50] bus[49] bus[48] bus[47] bus[46]
+ bus[45] bus[44] bus[43] bus[42] bus[41] bus[40] bus[39] bus[38] bus[37] bus[36]
+ bus[35] bus[34] bus[33] bus[32] bus[31] bus[30] bus[29] bus[28] bus[27] bus[26]
+ bus[25] bus[24] bus[23] bus[22] bus[21] bus[20] bus[19] bus[18] bus[17] bus[16]
+ bus[15] bus[14] bus[13] bus[12] bus[11] bus[10] bus[9] bus[8] bus[7] bus[6] bus[5]
+ bus[4] bus[3] bus[2] bus[1] bus[0] trn_chng wrt pop_uart_int push_uart_int VSS
+ D_pop_uart_int[63] D_pop_uart_int[62] D_pop_uart_int[61] D_pop_uart_int[60] D_pop_uart_int[59]
+ D_pop_uart_int[58] D_pop_uart_int[57] D_pop_uart_int[56] D_pop_uart_int[55] D_pop_uart_int[54]
+ D_pop_uart_int[53] D_pop_uart_int[52] D_pop_uart_int[51] D_pop_uart_int[50] D_pop_uart_int[49]
+ D_pop_uart_int[48] D_pop_uart_int[47] D_pop_uart_int[46] D_pop_uart_int[45] D_pop_uart_int[44]
+ D_pop_uart_int[43] D_pop_uart_int[42] D_pop_uart_int[41] D_pop_uart_int[40] D_pop_uart_int[39]
+ D_pop_uart_int[38] D_pop_uart_int[37] D_pop_uart_int[36] D_pop_uart_int[35] D_pop_uart_int[34]
+ D_pop_uart_int[33] D_pop_uart_int[32] D_pop_uart_int[31] D_pop_uart_int[30] D_pop_uart_int[29]
+ D_pop_uart_int[28] D_pop_uart_int[27] D_pop_uart_int[26] D_pop_uart_int[25] D_pop_uart_int[24]
+ D_pop_uart_int[23] D_pop_uart_int[22] D_pop_uart_int[21] D_pop_uart_int[20] D_pop_uart_int[19]
+ D_pop_uart_int[18] D_pop_uart_int[17] D_pop_uart_int[16] D_pop_uart_int[15] D_pop_uart_int[14]
+ D_pop_uart_int[13] D_pop_uart_int[12] D_pop_uart_int[11] D_pop_uart_int[10] D_pop_uart_int[9]
+ D_pop_uart_int[8] D_pop_uart_int[7] D_pop_uart_int[6] D_pop_uart_int[5] D_pop_uart_int[4]
+ D_pop_uart_int[3] D_pop_uart_int[2] D_pop_uart_int[1] D_pop_uart_int[0] VSS VDD_1V8
+ IN107 n123 clk_cts_6 prll_bs_ntrfs_riscv_3_65_2_7
Xspi_bs_ntrfs D_push_spi_int[64] D_push_spi_int[63] D_push_spi_int[62] SYNOPSYS_UNCONNECTED_18
+ SYNOPSYS_UNCONNECTED_19 D_push_spi_int[59] D_push_spi_int[58] D_push_spi_int[57]
+ SYNOPSYS_UNCONNECTED_20 SYNOPSYS_UNCONNECTED_21 D_push_spi_int[54] D_push_spi_int[53]
+ D_push_spi_int[52] D_push_spi_int[51] D_push_spi_int[50] D_push_spi_int[49] D_push_spi_int[48]
+ D_push_spi_int[47] D_push_spi_int[46] D_push_spi_int[45] D_push_spi_int[44] D_push_spi_int[43]
+ D_push_spi_int[42] D_push_spi_int[41] D_push_spi_int[40] D_push_spi_int[39] D_push_spi_int[38]
+ D_push_spi_int[37] D_push_spi_int[36] D_push_spi_int[35] D_push_spi_int[34] D_push_spi_int[33]
+ D_push_spi_int[32] D_push_spi_int[31] D_push_spi_int[30] D_push_spi_int[29] D_push_spi_int[28]
+ D_push_spi_int[27] D_push_spi_int[26] D_push_spi_int[25] D_push_spi_int[24] D_push_spi_int[23]
+ D_push_spi_int[22] D_push_spi_int[21] D_push_spi_int[20] D_push_spi_int[19] D_push_spi_int[18]
+ D_push_spi_int[17] D_push_spi_int[16] D_push_spi_int[15] D_push_spi_int[14] D_push_spi_int[13]
+ D_push_spi_int[12] D_push_spi_int[11] D_push_spi_int[10] D_push_spi_int[9] D_push_spi_int[8]
+ D_push_spi_int[7] D_push_spi_int[6] D_push_spi_int[5] D_push_spi_int[4] D_push_spi_int[3]
+ D_push_spi_int[2] D_push_spi_int[1] D_push_spi_int[0] pndng_spi_int clk_cts_6
+ IN34 bus[64] bus[63] bus[62] bus[61] bus[60] bus[59] bus[58] bus[57] bus[56] bus[55]
+ bus[54] bus[53] bus[52] bus[51] bus[50] bus[49] bus[48] bus[47] bus[46] bus[45]
+ bus[44] bus[43] bus[42] bus[41] bus[40] bus[39] bus[38] bus[37] bus[36] bus[35]
+ bus[34] bus[33] bus[32] bus[31] bus[30] bus[29] bus[28] bus[27] bus[26] bus[25]
+ bus[24] bus[23] bus[22] bus[21] bus[20] bus[19] bus[18] bus[17] bus[16] bus[15]
+ bus[14] bus[13] bus[12] bus[11] bus[10] bus[9] bus[8] bus[7] bus[6] bus[5] bus[4]
+ bus[3] bus[2] bus[1] bus[0] trn_chng wrt pop_spi_int push_spi_int VSS VSS VSS
+ VSS D_pop_spi_int[60] D_pop_spi_int[59] D_pop_spi_int[58] D_pop_spi_int[57] D_pop_spi_int[56]
+ D_pop_spi_int[55] D_pop_spi_int[54] D_pop_spi_int[53] D_pop_spi_int[52] D_pop_spi_int[51]
+ D_pop_spi_int[50] D_pop_spi_int[49] D_pop_spi_int[48] D_pop_spi_int[47] D_pop_spi_int[46]
+ D_pop_spi_int[45] D_pop_spi_int[44] D_pop_spi_int[43] D_pop_spi_int[42] D_pop_spi_int[41]
+ D_pop_spi_int[40] D_pop_spi_int[39] D_pop_spi_int[38] D_pop_spi_int[37] D_pop_spi_int[36]
+ D_pop_spi_int[35] D_pop_spi_int[34] D_pop_spi_int[33] D_pop_spi_int[32] D_pop_spi_int[31]
+ D_pop_spi_int[30] D_pop_spi_int[29] D_pop_spi_int[28] D_pop_spi_int[27] D_pop_spi_int[26]
+ D_pop_spi_int[25] D_pop_spi_int[24] D_pop_spi_int[23] D_pop_spi_int[22] D_pop_spi_int[21]
+ D_pop_spi_int[20] D_pop_spi_int[19] D_pop_spi_int[18] D_pop_spi_int[17] D_pop_spi_int[16]
+ D_pop_spi_int[15] D_pop_spi_int[14] D_pop_spi_int[13] D_pop_spi_int[12] D_pop_spi_int[11]
+ D_pop_spi_int[10] D_pop_spi_int[9] D_pop_spi_int[8] D_pop_spi_int[7] D_pop_spi_int[6]
+ D_pop_spi_int[5] D_pop_spi_int[4] D_pop_spi_int[3] D_pop_spi_int[2] D_pop_spi_int[1]
+ D_pop_spi_int[0] VSS VDD_1V8 IN108 n122 IN134 IN210 prll_bs_ntrfs_riscv_3_65_1_7
Xmbc_bs_ntrfs SYNOPSYS_UNCONNECTED_22 SYNOPSYS_UNCONNECTED_23 SYNOPSYS_UNCONNECTED_24
+ D_push_mbc_int[61] D_push_mbc_int[60] D_push_mbc_int[59] D_push_mbc_int[58] D_push_mbc_int[57]
+ D_push_mbc_int[56] D_push_mbc_int[55] D_push_mbc_int[54] D_push_mbc_int[53] D_push_mbc_int[52]
+ D_push_mbc_int[51] D_push_mbc_int[50] D_push_mbc_int[49] D_push_mbc_int[48] D_push_mbc_int[47]
+ D_push_mbc_int[46] D_push_mbc_int[45] D_push_mbc_int[44] D_push_mbc_int[43] D_push_mbc_int[42]
+ D_push_mbc_int[41] D_push_mbc_int[40] D_push_mbc_int[39] D_push_mbc_int[38] D_push_mbc_int[37]
+ D_push_mbc_int[36] D_push_mbc_int[35] D_push_mbc_int[34] D_push_mbc_int[33] D_push_mbc_int[32]
+ D_push_mbc_int[31] D_push_mbc_int[30] D_push_mbc_int[29] D_push_mbc_int[28] D_push_mbc_int[27]
+ D_push_mbc_int[26] D_push_mbc_int[25] D_push_mbc_int[24] D_push_mbc_int[23] D_push_mbc_int[22]
+ D_push_mbc_int[21] D_push_mbc_int[20] D_push_mbc_int[19] D_push_mbc_int[18] D_push_mbc_int[17]
+ D_push_mbc_int[16] D_push_mbc_int[15] D_push_mbc_int[14] D_push_mbc_int[13] D_push_mbc_int[12]
+ D_push_mbc_int[11] D_push_mbc_int[10] D_push_mbc_int[9] D_push_mbc_int[8] D_push_mbc_int[7]
+ D_push_mbc_int[6] D_push_mbc_int[5] D_push_mbc_int[4] D_push_mbc_int[3] D_push_mbc_int[2]
+ D_push_mbc_int[1] D_push_mbc_int[0] pndng_mbc_int clk n200 bus[64] bus[63] bus[62]
+ bus[61] bus[60] bus[59] bus[58] bus[57] bus[56] bus[55] bus[54] bus[53] bus[52]
+ bus[51] bus[50] bus[49] bus[48] bus[47] bus[46] bus[45] bus[44] bus[43] bus[42]
+ bus[41] bus[40] bus[39] bus[38] bus[37] bus[36] bus[35] bus[34] bus[33] bus[32]
+ bus[31] bus[30] bus[29] bus[28] bus[27] bus[26] bus[25] bus[24] bus[23] bus[22]
+ bus[21] bus[20] bus[19] bus[18] bus[17] bus[16] bus[15] bus[14] bus[13] bus[12]
+ bus[11] bus[10] bus[9] bus[8] bus[7] bus[6] bus[5] bus[4] bus[3] bus[2] bus[1]
+ bus[0] trn_chng wrt pop_mbc_int push_mbc_int VSS D_pop_mbc_int[63] D_pop_mbc_int[62]
+ VSS VSS D_pop_mbc_int[59] D_pop_mbc_int[58] D_pop_mbc_int[57] D_pop_mbc_int[56]
+ D_pop_mbc_int[55] D_pop_mbc_int[54] D_pop_mbc_int[53] D_pop_mbc_int[52] D_pop_mbc_int[51]
+ D_pop_mbc_int[50] D_pop_mbc_int[49] D_pop_mbc_int[48] D_pop_mbc_int[47] D_pop_mbc_int[46]
+ D_pop_mbc_int[45] D_pop_mbc_int[44] D_pop_mbc_int[43] D_pop_mbc_int[42] D_pop_mbc_int[41]
+ D_pop_mbc_int[40] D_pop_mbc_int[39] D_pop_mbc_int[38] D_pop_mbc_int[37] D_pop_mbc_int[36]
+ D_pop_mbc_int[35] D_pop_mbc_int[34] D_pop_mbc_int[33] D_pop_mbc_int[32] D_pop_mbc_int[31]
+ D_pop_mbc_int[30] D_pop_mbc_int[29] D_pop_mbc_int[28] D_pop_mbc_int[27] D_pop_mbc_int[26]
+ D_pop_mbc_int[25] D_pop_mbc_int[24] D_pop_mbc_int[23] D_pop_mbc_int[22] D_pop_mbc_int[21]
+ D_pop_mbc_int[20] D_pop_mbc_int[19] D_pop_mbc_int[18] D_pop_mbc_int[17] D_pop_mbc_int[16]
+ D_pop_mbc_int[15] D_pop_mbc_int[14] D_pop_mbc_int[13] D_pop_mbc_int[12] D_pop_mbc_int[11]
+ D_pop_mbc_int[10] D_pop_mbc_int[9] D_pop_mbc_int[8] D_pop_mbc_int[7] D_pop_mbc_int[6]
+ D_pop_mbc_int[5] D_pop_mbc_int[4] D_pop_mbc_int[3] D_pop_mbc_int[2] D_pop_mbc_int[1]
+ D_pop_mbc_int[0] VSS VDD_1V8 IN64 n59 prll_bs_ntrfs_riscv_3_65_0_7
Xplace9 VSS VDD_1V8 n1 n199 BUHDLLX0
Xplace8 n200 VSS VDD_1V8 IN221 INHDLLX1
Xplace6 n123 VSS VDD_1V8 IN224 INHDLLX1
Xplace5 n122 VSS VDD_1V8 IN224 INHDLLX1
Xplace4 n121 VSS VDD_1V8 IN224 INHDLLX0
Xplace3 n94 VSS VDD_1V8 IN221 INHDLLX1
Xplace2 n59 VSS VDD_1V8 IN221 INHDLLX1
Xplace1 n7 VSS VDD_1V8 IN224 INHDLLX1
Xplace7 n199 VSS VDD_1V8 IN221 INHDLLX0
.ENDS

.SUBCKT top_CPU_riscv clk reset push_spi push_uart pop_spi pop_uart D_push_spi[64]
+ D_push_spi[63] D_push_spi[62] D_push_spi[61] D_push_spi[60] D_push_spi[59] D_push_spi[58]
+ D_push_spi[57] D_push_spi[56] D_push_spi[55] D_push_spi[54] D_push_spi[53] D_push_spi[52]
+ D_push_spi[51] D_push_spi[50] D_push_spi[49] D_push_spi[48] D_push_spi[47] D_push_spi[46]
+ D_push_spi[45] D_push_spi[44] D_push_spi[43] D_push_spi[42] D_push_spi[41] D_push_spi[40]
+ D_push_spi[39] D_push_spi[38] D_push_spi[37] D_push_spi[36] D_push_spi[35] D_push_spi[34]
+ D_push_spi[33] D_push_spi[32] D_push_spi[31] D_push_spi[30] D_push_spi[29] D_push_spi[28]
+ D_push_spi[27] D_push_spi[26] D_push_spi[25] D_push_spi[24] D_push_spi[23] D_push_spi[22]
+ D_push_spi[21] D_push_spi[20] D_push_spi[19] D_push_spi[18] D_push_spi[17] D_push_spi[16]
+ D_push_spi[15] D_push_spi[14] D_push_spi[13] D_push_spi[12] D_push_spi[11] D_push_spi[10]
+ D_push_spi[9] D_push_spi[8] D_push_spi[7] D_push_spi[6] D_push_spi[5] D_push_spi[4]
+ D_push_spi[3] D_push_spi[2] D_push_spi[1] D_push_spi[0] D_push_uart[64] D_push_uart[63]
+ D_push_uart[62] D_push_uart[61] D_push_uart[60] D_push_uart[59] D_push_uart[58]
+ D_push_uart[57] D_push_uart[56] D_push_uart[55] D_push_uart[54] D_push_uart[53]
+ D_push_uart[52] D_push_uart[51] D_push_uart[50] D_push_uart[49] D_push_uart[48]
+ D_push_uart[47] D_push_uart[46] D_push_uart[45] D_push_uart[44] D_push_uart[43]
+ D_push_uart[42] D_push_uart[41] D_push_uart[40] D_push_uart[39] D_push_uart[38]
+ D_push_uart[37] D_push_uart[36] D_push_uart[35] D_push_uart[34] D_push_uart[33]
+ D_push_uart[32] D_push_uart[31] D_push_uart[30] D_push_uart[29] D_push_uart[28]
+ D_push_uart[27] D_push_uart[26] D_push_uart[25] D_push_uart[24] D_push_uart[23]
+ D_push_uart[22] D_push_uart[21] D_push_uart[20] D_push_uart[19] D_push_uart[18]
+ D_push_uart[17] D_push_uart[16] D_push_uart[15] D_push_uart[14] D_push_uart[13]
+ D_push_uart[12] D_push_uart[11] D_push_uart[10] D_push_uart[9] D_push_uart[8]
+ D_push_uart[7] D_push_uart[6] D_push_uart[5] D_push_uart[4] D_push_uart[3] D_push_uart[2]
+ D_push_uart[1] D_push_uart[0] maip D_pop_spi[64] D_pop_spi[63] D_pop_spi[62] D_pop_spi[61]
+ D_pop_spi[60] D_pop_spi[59] D_pop_spi[58] D_pop_spi[57] D_pop_spi[56] D_pop_spi[55]
+ D_pop_spi[54] D_pop_spi[53] D_pop_spi[52] D_pop_spi[51] D_pop_spi[50] D_pop_spi[49]
+ D_pop_spi[48] D_pop_spi[47] D_pop_spi[46] D_pop_spi[45] D_pop_spi[44] D_pop_spi[43]
+ D_pop_spi[42] D_pop_spi[41] D_pop_spi[40] D_pop_spi[39] D_pop_spi[38] D_pop_spi[37]
+ D_pop_spi[36] D_pop_spi[35] D_pop_spi[34] D_pop_spi[33] D_pop_spi[32] D_pop_spi[31]
+ D_pop_spi[30] D_pop_spi[29] D_pop_spi[28] D_pop_spi[27] D_pop_spi[26] D_pop_spi[25]
+ D_pop_spi[24] D_pop_spi[23] D_pop_spi[22] D_pop_spi[21] D_pop_spi[20] D_pop_spi[19]
+ D_pop_spi[18] D_pop_spi[17] D_pop_spi[16] D_pop_spi[15] D_pop_spi[14] D_pop_spi[13]
+ D_pop_spi[12] D_pop_spi[11] D_pop_spi[10] D_pop_spi[9] D_pop_spi[8] D_pop_spi[7]
+ D_pop_spi[6] D_pop_spi[5] D_pop_spi[4] D_pop_spi[3] D_pop_spi[2] D_pop_spi[1]
+ D_pop_spi[0] D_pop_uart[64] D_pop_uart[63] D_pop_uart[62] D_pop_uart[61] D_pop_uart[60]
+ D_pop_uart[59] D_pop_uart[58] D_pop_uart[57] D_pop_uart[56] D_pop_uart[55] D_pop_uart[54]
+ D_pop_uart[53] D_pop_uart[52] D_pop_uart[51] D_pop_uart[50] D_pop_uart[49] D_pop_uart[48]
+ D_pop_uart[47] D_pop_uart[46] D_pop_uart[45] D_pop_uart[44] D_pop_uart[43] D_pop_uart[42]
+ D_pop_uart[41] D_pop_uart[40] D_pop_uart[39] D_pop_uart[38] D_pop_uart[37] D_pop_uart[36]
+ D_pop_uart[35] D_pop_uart[34] D_pop_uart[33] D_pop_uart[32] D_pop_uart[31] D_pop_uart[30]
+ D_pop_uart[29] D_pop_uart[28] D_pop_uart[27] D_pop_uart[26] D_pop_uart[25] D_pop_uart[24]
+ D_pop_uart[23] D_pop_uart[22] D_pop_uart[21] D_pop_uart[20] D_pop_uart[19] D_pop_uart[18]
+ D_pop_uart[17] D_pop_uart[16] D_pop_uart[15] D_pop_uart[14] D_pop_uart[13] D_pop_uart[12]
+ D_pop_uart[11] D_pop_uart[10] D_pop_uart[9] D_pop_uart[8] D_pop_uart[7] D_pop_uart[6]
+ D_pop_uart[5] D_pop_uart[4] D_pop_uart[3] D_pop_uart[2] D_pop_uart[1] D_pop_uart[0]
+ pndng_spi pndng_uart full_range_level_shifter[7] full_range_level_shifter[6] full_range_level_shifter[5]
+ full_range_level_shifter[4] full_range_level_shifter[3] full_range_level_shifter[2]
+ full_range_level_shifter[1] full_range_level_shifter[0] IS_Val[31] IS_Val[30]
+ IS_Val[29] IS_Val[28] IS_Val[27] IS_Val[26] IS_Val[25] IS_Val[24] IS_Val[23] IS_Val[22]
+ IS_Val[21] IS_Val[20] IS_Val[19] IS_Val[18] IS_Val[17] IS_Val[16] IS_Val[15] IS_Val[14]
+ IS_Val[13] IS_Val[12] IS_Val[11] IS_Val[10] IS_Val[9] IS_Val[8] IS_Val[7] IS_Val[6]
+ IS_Val[5] IS_Val[4] IS_Val[3] IS_Val[2] IS_Val[1] IS_Val[0] IS_Config[31] IS_Config[30]
+ IS_Config[29] IS_Config[28] IS_Config[27] IS_Config[26] IS_Config[25] IS_Config[24]
+ IS_Config[23] IS_Config[22] IS_Config[21] IS_Config[20] IS_Config[19] IS_Config[18]
+ IS_Config[17] IS_Config[16] IS_Config[15] IS_Config[14] IS_Config[13] IS_Config[12]
+ IS_Config[11] IS_Config[10] IS_Config[9] IS_Config[8] IS_Config[7] IS_Config[6]
+ IS_Config[5] IS_Config[4] IS_Config[3] IS_Config[2] IS_Config[1] IS_Config[0]
+ IS_Trigger[3] IS_Trigger[2] IS_Trigger[1] IS_Trigger[0] Reg_GPIO_en[7] Reg_GPIO_en[6]
+ Reg_GPIO_en[5] Reg_GPIO_en[4] Reg_GPIO_en[3] Reg_GPIO_en[2] Reg_GPIO_en[1] Reg_GPIO_en[0]
+ Reg_GPIO_int[7] Reg_GPIO_int[6] Reg_GPIO_int[5] Reg_GPIO_int[4] Reg_GPIO_int[3]
+ Reg_GPIO_int[2] Reg_GPIO_int[1] Reg_GPIO_int[0] Reg_GPIO_out[7] Reg_GPIO_out[6]
+ Reg_GPIO_out[5] Reg_GPIO_out[4] Reg_GPIO_out[3] Reg_GPIO_out[2] Reg_GPIO_out[1]
+ Reg_GPIO_out[0] VSS VDD_1V8SRAM VDD_1V8
Xpc31 pc_pre[31] ld_pc_clk_G4B2I1 n165 pc[31] VSS VDD_1V8 dff_async_rst_1332
Xpc30 pc_pre[30] ld_pc_clk_G4B2I1 n165 pc[30] VSS VDD_1V8 dff_async_rst_1333
Xpc29 pc_pre[29] ld_pc_clk_G4B2I1 n165 pc[29] VSS VDD_1V8 dff_async_rst_1334
Xpc28 pc_pre[28] ld_pc_clk_G4B2I1 n165 pc[28] VSS VDD_1V8 dff_async_rst_1335
Xpc27 pc_pre[27] ld_pc_clk_G4B2I1 n165 pc[27] VSS VDD_1V8 dff_async_rst_1336
Xpc26 pc_pre[26] ld_pc_clk_G4B2I1 n165 pc[26] VSS VDD_1V8 dff_async_rst_1337
Xpc25 pc_pre[25] ld_pc_clk_G4B2I1 n165 pc[25] VSS VDD_1V8 dff_async_rst_1338
Xpc24 pc_pre[24] ld_pc_clk_G4B2I1 n165 pc[24] VSS VDD_1V8 dff_async_rst_1339
Xpc23 pc_pre[23] ld_pc_clk_G4B2I1 n14 pc[23] VSS VDD_1V8 dff_async_rst_1340
Xpc22 pc_pre[22] ld_pc_clk_G4B2I1 n165 pc[22] VSS VDD_1V8 dff_async_rst_1341
Xpc21 pc_pre[21] ld_pc_clk_G4B2I1 n165 pc[21] VSS VDD_1V8 dff_async_rst_1342
Xpc20 pc_pre[20] ld_pc_clk_G4B2I1 n165 pc[20] VSS VDD_1V8 dff_async_rst_1343
Xpc19 pc_pre[19] ld_pc_clk_G4B2I1 n14 pc[19] VSS VDD_1V8 dff_async_rst_1344
Xpc18 pc_pre[18] ld_pc_clk_G4B2I1 n165 pc[18] VSS VDD_1V8 dff_async_rst_1345
Xpc17 pc_pre[17] ld_pc_clk_G4B2I1 n14 pc[17] VSS VDD_1V8 dff_async_rst_1346
Xpc16 pc_pre[16] ld_pc_clk_G4B2I1 n165 pc[16] VSS VDD_1V8 dff_async_rst_1347
Xpc15 pc_pre[15] ld_pc_clk_G4B2I1 n165 pc[15] VSS VDD_1V8 dff_async_rst_1348
Xpc14 pc_pre[14] ld_pc_clk_G4B2I1 n165 pc[14] VSS VDD_1V8 dff_async_rst_1349
Xpc13 pc_pre[13] ld_pc_clk_G4B2I1 n165 pc[13] VSS VDD_1V8 dff_async_rst_1350
Xpc12 pc_pre[12] ld_pc_clk_G4B2I1 n164 pc[12] VSS VDD_1V8 dff_async_rst_1351
Xpc11 pc_pre[11] ld_pc_clk_G4B2I1 n165 pc[11] VSS VDD_1V8 dff_async_rst_1352
Xpc10 pc_pre[10] ld_pc_clk_G4B2I1 n165 pc[10] VSS VDD_1V8 dff_async_rst_1353
Xpc9 pc_pre[9] ld_pc_clk_G4B2I1 n165 pc[9] VSS VDD_1V8 dff_async_rst_1354
Xpc8 pc_pre[8] ld_pc_clk_G4B2I1 n165 pc[8] VSS VDD_1V8 dff_async_rst_1355
Xpc7 pc_pre[7] ld_pc_clk_G4B2I1 n165 pc[7] VSS VDD_1V8 dff_async_rst_1356
Xpc6 pc_pre[6] ld_pc_clk_G4B2I1 n165 pc[6] VSS VDD_1V8 dff_async_rst_1357
Xpc5 pc_pre[5] ld_pc_clk_G4B2I1 n165 pc[5] VSS VDD_1V8 dff_async_rst_1358
Xpc4 pc_pre[4] ld_pc_clk_G4B2I1 n165 pc[4] VSS VDD_1V8 dff_async_rst_1359
Xpc3 pc_pre[3] ld_pc_clk_G4B2I1 n165 pc[3] VSS VDD_1V8 dff_async_rst_1360
Xpc2 pc_pre[2] ld_pc_clk_G4B2I1 n165 pc[2] VSS VDD_1V8 dff_async_rst_1361
Xpc1 pc_pre[1] ld_pc_clk_G4B2I1 n165 pc[1] VSS VDD_1V8 dff_async_rst_1362
Xpc0 pc_pre[0] ld_pc_clk_G4B2I1 n165 pc[0] VSS VDD_1V8 dff_async_rst_1363
Xtemporizador_top clk_timer n3 count_timer[31] count_timer[30] count_timer[29] count_timer[28]
+ count_timer[27] count_timer[26] count_timer[25] count_timer[24] count_timer[23]
+ count_timer[22] count_timer[21] count_timer[20] count_timer[19] count_timer[18]
+ count_timer[17] count_timer[16] count_timer[15] count_timer[14] count_timer[13]
+ count_timer[12] count_timer[11] count_timer[10] count_timer[9] count_timer[8]
+ count_timer[7] count_timer[6] count_timer[5] count_timer[4] count_timer[3] count_timer[2]
+ count_timer[1] count_timer[0] VSS VDD_1V8 Timer
XBus CTS_0_G3B4I2 n197 meip pndng_spi pndng_uart push_mbc push_spi push_uart pop
+ pop_spi pop_uart SYNOPSYS_UNCONNECTED_1 SYNOPSYS_UNCONNECTED_2 SYNOPSYS_UNCONNECTED_3
+ D_pop_mbc[61] D_pop_mbc[60] D_pop_mbc[59] D_pop_mbc[58] D_pop_mbc[57] D_pop_mbc[56]
+ D_pop_mbc[55] D_pop_mbc[54] D_pop_mbc[53] D_pop_mbc[52] D_pop_mbc[51] D_pop_mbc[50]
+ D_pop_mbc[49] D_pop_mbc[48] D_pop_mbc[47] D_pop_mbc[46] D_pop_mbc[45] D_pop_mbc[44]
+ D_pop_mbc[43] D_pop_mbc[42] D_pop_mbc[41] D_pop_mbc[40] D_pop_mbc[39] D_pop_mbc[38]
+ D_pop_mbc[37] D_pop_mbc[36] D_pop_mbc[35] D_pop_mbc[34] D_pop_mbc[33] D_pop_mbc[32]
+ D_pop_mbc[31] D_pop_mbc[30] D_pop_mbc[29] D_pop_mbc[28] D_pop_mbc[27] D_pop_mbc[26]
+ D_pop_mbc[25] D_pop_mbc[24] D_pop_mbc[23] D_pop_mbc[22] D_pop_mbc[21] D_pop_mbc[20]
+ D_pop_mbc[19] D_pop_mbc[18] D_pop_mbc[17] D_pop_mbc[16] D_pop_mbc[15] D_pop_mbc[14]
+ D_pop_mbc[13] D_pop_mbc[12] D_pop_mbc[11] D_pop_mbc[10] D_pop_mbc[9] D_pop_mbc[8]
+ D_pop_mbc[7] D_pop_mbc[6] D_pop_mbc[5] D_pop_mbc[4] D_pop_mbc[3] D_pop_mbc[2]
+ D_pop_mbc[1] D_pop_mbc[0] D_pop_spi[64] D_pop_spi[63] D_pop_spi[62] SYNOPSYS_UNCONNECTED_4
+ SYNOPSYS_UNCONNECTED_5 D_pop_spi[59] D_pop_spi[58] D_pop_spi[57] SYNOPSYS_UNCONNECTED_6
+ SYNOPSYS_UNCONNECTED_7 D_pop_spi[54] D_pop_spi[53] D_pop_spi[52] D_pop_spi[51]
+ D_pop_spi[50] D_pop_spi[49] D_pop_spi[48] D_pop_spi[47] D_pop_spi[46] D_pop_spi[45]
+ D_pop_spi[44] D_pop_spi[43] D_pop_spi[42] D_pop_spi[41] D_pop_spi[40] D_pop_spi[39]
+ D_pop_spi[38] D_pop_spi[37] D_pop_spi[36] D_pop_spi[35] D_pop_spi[34] D_pop_spi[33]
+ D_pop_spi[32] D_pop_spi[31] D_pop_spi[30] D_pop_spi[29] D_pop_spi[28] D_pop_spi[27]
+ D_pop_spi[26] D_pop_spi[25] D_pop_spi[24] D_pop_spi[23] D_pop_spi[22] D_pop_spi[21]
+ D_pop_spi[20] D_pop_spi[19] D_pop_spi[18] D_pop_spi[17] D_pop_spi[16] D_pop_spi[15]
+ D_pop_spi[14] D_pop_spi[13] D_pop_spi[12] D_pop_spi[11] D_pop_spi[10] D_pop_spi[9]
+ D_pop_spi[8] D_pop_spi[7] D_pop_spi[6] D_pop_spi[5] D_pop_spi[4] D_pop_spi[3]
+ D_pop_spi[2] D_pop_spi[1] D_pop_spi[0] SYNOPSYS_UNCONNECTED_8 D_pop_uart[63] D_pop_uart[62]
+ D_pop_uart[61] D_pop_uart[60] D_pop_uart[59] D_pop_uart[58] D_pop_uart[57] D_pop_uart[56]
+ D_pop_uart[55] D_pop_uart[54] D_pop_uart[53] D_pop_uart[52] D_pop_uart[51] D_pop_uart[50]
+ D_pop_uart[49] D_pop_uart[48] D_pop_uart[47] D_pop_uart[46] D_pop_uart[45] D_pop_uart[44]
+ D_pop_uart[43] D_pop_uart[42] D_pop_uart[41] D_pop_uart[40] D_pop_uart[39] D_pop_uart[38]
+ D_pop_uart[37] D_pop_uart[36] D_pop_uart[35] D_pop_uart[34] D_pop_uart[33] D_pop_uart[32]
+ D_pop_uart[31] D_pop_uart[30] D_pop_uart[29] D_pop_uart[28] D_pop_uart[27] D_pop_uart[26]
+ D_pop_uart[25] D_pop_uart[24] D_pop_uart[23] D_pop_uart[22] D_pop_uart[21] D_pop_uart[20]
+ D_pop_uart[19] D_pop_uart[18] D_pop_uart[17] D_pop_uart[16] D_pop_uart[15] D_pop_uart[14]
+ D_pop_uart[13] D_pop_uart[12] D_pop_uart[11] D_pop_uart[10] D_pop_uart[9] D_pop_uart[8]
+ D_pop_uart[7] D_pop_uart[6] D_pop_uart[5] D_pop_uart[4] D_pop_uart[3] D_pop_uart[2]
+ D_pop_uart[1] D_pop_uart[0] VSS D_push_mbc[63] D_push_mbc[62] VSS VSS D_push_mbc[59]
+ D_push_mbc[58] D_push_mbc[57] addrs_reg[24] addrs_reg[23] addrs_reg[22] addrs_reg[21]
+ addrs_reg[20] addrs_reg[19] addrs_reg[18] addrs_reg[17] addrs_reg[16] addrs_reg[15]
+ addrs_reg[14] addrs_reg[13] addrs_reg[12] addrs_reg[11] addrs_reg[10] addrs_reg[9]
+ addrs_reg[8] addrs_reg[7] addrs_reg[6] addrs_reg[5] addrs_reg[4] addrs_reg[3]
+ addrs_reg[2] addrs_reg[1] addrs_reg[0] D_push_mbc[31] D_push_mbc[30] D_push_mbc[29]
+ D_push_mbc[28] D_push_mbc[27] D_push_mbc[26] D_push_mbc[25] D_push_mbc[24] D_push_mbc[23]
+ D_push_mbc[22] D_push_mbc[21] D_push_mbc[20] D_push_mbc[19] D_push_mbc[18] D_push_mbc[17]
+ D_push_mbc[16] D_push_mbc[15] D_push_mbc[14] D_push_mbc[13] D_push_mbc[12] D_push_mbc[11]
+ D_push_mbc[10] D_push_mbc[9] D_push_mbc[8] D_push_mbc[7] D_push_mbc[6] D_push_mbc[5]
+ D_push_mbc[4] D_push_mbc[3] D_push_mbc[2] D_push_mbc[1] D_push_mbc[0] VSS VSS
+ VSS VSS D_push_spi[60] D_push_spi[59] D_push_spi[58] D_push_spi[57] D_push_spi[56]
+ D_push_spi[55] D_push_spi[54] D_push_spi[53] D_push_spi[52] D_push_spi[51] D_push_spi[50]
+ D_push_spi[49] D_push_spi[48] D_push_spi[47] D_push_spi[46] D_push_spi[45] D_push_spi[44]
+ D_push_spi[43] D_push_spi[42] D_push_spi[41] D_push_spi[40] D_push_spi[39] D_push_spi[38]
+ D_push_spi[37] D_push_spi[36] D_push_spi[35] D_push_spi[34] D_push_spi[33] D_push_spi[32]
+ D_push_spi[31] D_push_spi[30] D_push_spi[29] D_push_spi[28] D_push_spi[27] D_push_spi[26]
+ D_push_spi[25] D_push_spi[24] D_push_spi[23] D_push_spi[22] D_push_spi[21] D_push_spi[20]
+ D_push_spi[19] D_push_spi[18] D_push_spi[17] D_push_spi[16] D_push_spi[15] D_push_spi[14]
+ D_push_spi[13] D_push_spi[12] D_push_spi[11] D_push_spi[10] D_push_spi[9] D_push_spi[8]
+ D_push_spi[7] D_push_spi[6] D_push_spi[5] D_push_spi[4] D_push_spi[3] D_push_spi[2]
+ D_push_spi[1] D_push_spi[0] VSS D_push_uart[63] D_push_uart[62] D_push_uart[61]
+ D_push_uart[60] D_push_uart[59] D_push_uart[58] D_push_uart[57] D_push_uart[56]
+ D_push_uart[55] D_push_uart[54] D_push_uart[53] D_push_uart[52] D_push_uart[51]
+ D_push_uart[50] D_push_uart[49] D_push_uart[48] D_push_uart[47] D_push_uart[46]
+ D_push_uart[45] D_push_uart[44] D_push_uart[43] D_push_uart[42] D_push_uart[41]
+ D_push_uart[40] D_push_uart[39] D_push_uart[38] D_push_uart[37] D_push_uart[36]
+ D_push_uart[35] D_push_uart[34] D_push_uart[33] D_push_uart[32] D_push_uart[31]
+ D_push_uart[30] D_push_uart[29] D_push_uart[28] D_push_uart[27] D_push_uart[26]
+ D_push_uart[25] D_push_uart[24] D_push_uart[23] D_push_uart[22] D_push_uart[21]
+ D_push_uart[20] D_push_uart[19] D_push_uart[18] D_push_uart[17] D_push_uart[16]
+ D_push_uart[15] D_push_uart[14] D_push_uart[13] D_push_uart[12] D_push_uart[11]
+ D_push_uart[10] D_push_uart[9] D_push_uart[8] D_push_uart[7] D_push_uart[6] D_push_uart[5]
+ D_push_uart[4] D_push_uart[3] D_push_uart[2] D_push_uart[1] D_push_uart[0] VSS
+ VDD_1V8 n176 n176 n176 n176 n176 n176 n176 n176 n176 n176 n176 n176 n176 n176
+ n176 n176 n176 n176 n176 n176 n176 n176 n176 n176 n176 n176 n176 n176 n176 n176
+ n176 n176 n176 n176 n164 n159 n159 n159 n159 n159 n159 n159 n159 n159 n159 n159
+ n159 n159 n159 n159 n159 n159 n159 n159 n159 n159 n159 n159 n159 n159 n159 n159
+ n159 n159 n158 n158 n158 n54 n54 n54 n54 n54 n15 n15 n15 n15 n15 n15 n15 n15 n15
+ n15 n15 n15 n15 n15 n15 n15 n15 n15 n15 n15 n15 n15 n15 n15 n15 n15 n15 n15 n15
+ n15 n15 n15 n15 n15 n13 n13 n13 n10 n10 n10 n10 n10 n10 n10 n10 n10 n10 n10 n10
+ n10 n10 n10 n10 n10 n10 n10 n10 n10 n10 n10 n10 n10 n9 n8 n8 n8 n8 n8 n8 n8 n8
+ n8 n8 n8 n8 n8 n8 n8 n8 n8 n8 n8 n8 n8 n8 n8 n8 n8 n8 n8 n8 n8 n8 n8 n8 n8 n8
+ n7 n7 n7 n7 n7 n7 n7 n7 n7 n7 n7 n7 n7 n7 n7 n7 n7 n7 n7 n7 n7 n7 n7 n7 n7 n7
+ n7 n7 n7 n7 n7 n7 n7 n7 n7 n7 n7 n7 n7 n7 n7 n6 n6 n6 n6 n6 n6 n6 n6 n6 n6 n5
+ n5 n5 n4 n4 n4 CTS_0_G3B4I3 CTS_0_G3B4I1 CTS_0_G3B2I2 CTS_0_G3B2I1 tec_riscv_bus
XReg_file csr_id[3] csr_id[2] csr_id[1] csr_id[0] rs1[4] rs1[3] rs1[2] rs1[1] rs1[0]
+ rs2[4] rs2[3] rs2[2] rs2[1] rs2[0] rd[4] rd[3] rd[2] rd[1] rd[0] csr_write reg_write_data[31]
+ reg_write_data[30] reg_write_data[29] reg_write_data[28] reg_write_data[27] reg_write_data[26]
+ reg_write_data[25] reg_write_data[24] reg_write_data[23] reg_write_data[22] reg_write_data[21]
+ reg_write_data[20] reg_write_data[19] reg_write_data[18] reg_write_data[17] reg_write_data[16]
+ reg_write_data[15] reg_write_data[14] reg_write_data[13] reg_write_data[12] reg_write_data[11]
+ reg_write_data[10] reg_write_data[9] reg_write_data[8] reg_write_data[7] reg_write_data[6]
+ reg_write_data[5] reg_write_data[4] reg_write_data[3] reg_write_data[2] reg_write_data[1]
+ reg_write_data[0] write_reg_fl R1[31] R1[30] R1[29] R1[28] R1[27] R1[26] R1[25]
+ R1[24] R1[23] R1[22] R1[21] R1[20] R1[19] R1[18] R1[17] R1[16] R1[15] R1[14] R1[13]
+ R1[12] R1[11] R1[10] R1[9] R1[8] R1[7] R1[6] R1[5] R1[4] R1[3] R1[2] R1[1] R1[0]
+ d_write[31] d_write[30] d_write[29] d_write[28] d_write[27] d_write[26] d_write[25]
+ d_write[24] d_write[23] d_write[22] d_write[21] d_write[20] d_write[19] d_write[18]
+ d_write[17] d_write[16] d_write[15] d_write[14] d_write[13] d_write[12] d_write[11]
+ d_write[10] d_write[9] d_write[8] d_write[7] d_write[6] d_write[5] d_write[4]
+ d_write[3] d_write[2] d_write[1] d_write[0] CTS_0_G3B2I2 n176 meip mtip mtie meie
+ comparation[31] comparation[30] comparation[29] comparation[28] comparation[27]
+ comparation[26] comparation[25] comparation[24] comparation[23] comparation[22]
+ comparation[21] comparation[20] comparation[19] comparation[18] comparation[17]
+ comparation[16] comparation[15] comparation[14] comparation[13] comparation[12]
+ comparation[11] comparation[10] comparation[9] comparation[8] comparation[7] comparation[6]
+ comparation[5] comparation[4] comparation[3] comparation[2] comparation[1] comparation[0]
+ count_timer[31] count_timer[30] count_timer[29] count_timer[28] count_timer[27]
+ count_timer[26] count_timer[25] count_timer[24] count_timer[23] count_timer[22]
+ count_timer[21] count_timer[20] count_timer[19] count_timer[18] count_timer[17]
+ count_timer[16] count_timer[15] count_timer[14] count_timer[13] count_timer[12]
+ count_timer[11] count_timer[10] count_timer[9] count_timer[8] count_timer[7] count_timer[6]
+ count_timer[5] count_timer[4] count_timer[3] count_timer[2] count_timer[1] count_timer[0]
+ CSR[31] CSR[30] CSR[29] CSR[28] CSR[27] CSR[26] CSR[25] CSR[24] CSR[23] CSR[22]
+ CSR[21] CSR[20] CSR[19] CSR[18] CSR[17] CSR[16] CSR[15] CSR[14] CSR[13] CSR[12]
+ CSR[11] CSR[10] CSR[9] CSR[8] CSR[7] CSR[6] CSR[5] CSR[4] CSR[3] CSR[2] CSR[1]
+ CSR[0] full_range_level_shifter[7] full_range_level_shifter[6] full_range_level_shifter[5]
+ full_range_level_shifter[4] full_range_level_shifter[3] full_range_level_shifter[2]
+ full_range_level_shifter[1] full_range_level_shifter[0] IS_Val[31] IS_Val[30]
+ IS_Val[29] IS_Val[28] IS_Val[27] IS_Val[26] IS_Val[25] IS_Val[24] IS_Val[23] IS_Val[22]
+ IS_Val[21] IS_Val[20] IS_Val[19] IS_Val[18] IS_Val[17] IS_Val[16] IS_Val[15] IS_Val[14]
+ IS_Val[13] IS_Val[12] IS_Val[11] IS_Val[10] IS_Val[9] IS_Val[8] IS_Val[7] IS_Val[6]
+ IS_Val[5] IS_Val[4] IS_Val[3] IS_Val[2] IS_Val[1] IS_Val[0] SYNOPSYS_UNCONNECTED_9
+ SYNOPSYS_UNCONNECTED_10 SYNOPSYS_UNCONNECTED_11 SYNOPSYS_UNCONNECTED_12 SYNOPSYS_UNCONNECTED_13
+ SYNOPSYS_UNCONNECTED_14 SYNOPSYS_UNCONNECTED_15 SYNOPSYS_UNCONNECTED_16 SYNOPSYS_UNCONNECTED_17
+ SYNOPSYS_UNCONNECTED_18 SYNOPSYS_UNCONNECTED_19 SYNOPSYS_UNCONNECTED_20 SYNOPSYS_UNCONNECTED_21
+ SYNOPSYS_UNCONNECTED_22 SYNOPSYS_UNCONNECTED_23 SYNOPSYS_UNCONNECTED_24 SYNOPSYS_UNCONNECTED_25
+ SYNOPSYS_UNCONNECTED_26 SYNOPSYS_UNCONNECTED_27 SYNOPSYS_UNCONNECTED_28 SYNOPSYS_UNCONNECTED_29
+ SYNOPSYS_UNCONNECTED_30 SYNOPSYS_UNCONNECTED_31 SYNOPSYS_UNCONNECTED_32 SYNOPSYS_UNCONNECTED_33
+ SYNOPSYS_UNCONNECTED_34 SYNOPSYS_UNCONNECTED_35 SYNOPSYS_UNCONNECTED_36 SYNOPSYS_UNCONNECTED_37
+ SYNOPSYS_UNCONNECTED_38 SYNOPSYS_UNCONNECTED_39 SYNOPSYS_UNCONNECTED_40 IS_Trigger[3]
+ IS_Trigger[2] IS_Trigger[1] IS_Trigger[0] maie maip Reg_GPIO_en[7] Reg_GPIO_en[6]
+ Reg_GPIO_en[5] Reg_GPIO_en[4] Reg_GPIO_en[3] Reg_GPIO_en[2] Reg_GPIO_en[1] Reg_GPIO_en[0]
+ Reg_GPIO_int[7] Reg_GPIO_int[6] Reg_GPIO_int[5] Reg_GPIO_int[4] Reg_GPIO_int[3]
+ Reg_GPIO_int[2] Reg_GPIO_int[1] Reg_GPIO_int[0] Reg_GPIO_out[7] Reg_GPIO_out[6]
+ Reg_GPIO_out[5] Reg_GPIO_out[4] Reg_GPIO_out[3] Reg_GPIO_out[2] Reg_GPIO_out[1]
+ Reg_GPIO_out[0] VSS VDD_1V8 n164 n164 n164 n164 n164 n164 n164 n164 n164 n164
+ n164 n164 n164 n164 n164 n164 n164 n164 n164 n164 n164 n164 n164 n164 n164 n164
+ n164 n164 n164 n164 n164 n164 n164 n15 n15 n15 n15 n15 n15 n15 n15 n15 n15 n14
+ n14 n14 n14 n14 n14 n14 n14 n14 n14 n14 n14 n14 n14 n14 n14 n14 n14 n14 n14 n14
+ n14 n14 n14 n14 n14 n14 n14 n14 n14 n14 n14 n14 n14 n14 n14 n14 n14 n14 n14 n14
+ n14 n14 n14 n13 n13 n13 n13 n13 n13 n13 n13 n13 n13 n13 n13 n13 n13 n13 n13 n13
+ n13 n13 n13 n13 n13 n13 n13 n13 n13 n13 n13 n13 n12 n10 n10 n10 n10 n10 n10 n10
+ n10 n10 n10 n10 n10 n10 n10 n10 n10 n10 n9 n9 n9 n9 n9 n9 n9 n9 n9 n9 n9 n9 n9
+ n9 n9 n9 n9 n9 n9 n9 n9 n9 n9 n9 n9 n9 n9 n9 n9 n9 n9 n9 n9 n9 n9 n9 n9 n9 n9
+ n9 n9 n9 n6 n6 n6 n6 n6 n6 n6 n6 n6 n6 n6 n6 n6 n6 n6 n6 n6 n6 n6 n6 n6 n6 n6
+ n5 n4 n4 n448 Banco_registros_latches
XAlu alu_a[31] alu_a[30] alu_a[29] alu_a[28] alu_a[27] alu_a[26] alu_a[25] alu_a[24]
+ alu_a[23] alu_a[22] alu_a[21] alu_a[20] alu_a[19] alu_a[18] alu_a[17] alu_a[16]
+ alu_a[15] alu_a[14] alu_a[13] alu_a[12] alu_a[11] alu_a[10] alu_a[9] alu_a[8]
+ alu_a[7] alu_a[6] alu_a[5] alu_a[4] alu_a[3] alu_a[2] alu_a[1] alu_a[0] alu_b[31]
+ alu_b[30] alu_b[29] alu_b[28] alu_b[27] alu_b[26] alu_b[25] alu_b[24] alu_b[23]
+ alu_b[22] alu_b[21] alu_b[20] alu_b[19] alu_b[18] alu_b[17] alu_b[16] alu_b[15]
+ alu_b[14] alu_b[13] alu_b[12] alu_b[11] alu_b[10] alu_b[9] alu_b[8] alu_b[7] alu_b[6]
+ alu_b[5] alu_b[4] alu_b[3] alu_b[2] alu_b[1] alu_b[0] cntrl_alu[3] cntrl_alu[2]
+ cntrl_alu[1] cntrl_alu[0] VSS zero_alu SYNOPSYS_UNCONNECTED_71 SYNOPSYS_UNCONNECTED_72
+ SYNOPSYS_UNCONNECTED_73 alu_out[31] alu_out[30] alu_out[29] alu_out[28] alu_out[27]
+ alu_out[26] alu_out[25] alu_out[24] alu_out[23] alu_out[22] alu_out[21] alu_out[20]
+ alu_out[19] alu_out[18] alu_out[17] alu_out[16] alu_out[15] alu_out[14] alu_out[13]
+ alu_out[12] alu_out[11] alu_out[10] alu_out[9] alu_out[8] alu_out[7] alu_out[6]
+ alu_out[5] alu_out[4] alu_out[3] alu_out[2] alu_out[1] alu_out[0] VSS VDD_1V8 ALU_2_bits_size32_cntrl_size4
XDeco ld_id_instrl_deco d_read[31] d_read[30] d_read[29] d_read[28] d_read[27] d_read[26]
+ d_read[25] d_read[24] d_read[23] d_read[22] d_read[21] d_read[20] d_read[19] d_read[18]
+ d_read[17] d_read[16] d_read[15] d_read[14] d_read[13] d_read[12] d_read[11] d_read[10]
+ d_read[9] d_read[8] d_read[7] d_read[6] d_read[5] d_read[4] d_read[3] d_read[2]
+ d_read[1] d_read[0] n197 rs1[4] rs1[3] rs1[2] rs1[1] rs1[0] rs2[4] rs2[3] rs2[2]
+ rs2[1] rs2[0] rd[4] rd[3] rd[2] rd[1] rd[0] imm_out[31] imm_out[30] imm_out[29]
+ imm_out[28] imm_out[27] imm_out[26] imm_out[25] imm_out[24] imm_out[23] imm_out[22]
+ imm_out[21] imm_out[20] imm_out[19] imm_out[18] imm_out[17] imm_out[16] imm_out[15]
+ imm_out[14] imm_out[13] imm_out[12] imm_out[11] imm_out[10] imm_out[9] imm_out[8]
+ imm_out[7] imm_out[6] imm_out[5] imm_out[4] imm_out[3] imm_out[2] imm_out[1] imm_out[0]
+ codif_inst_deco[6] codif_inst_deco[5] codif_inst_deco[4] codif_inst_deco[3] codif_inst_deco[2]
+ codif_inst_deco[1] codif_inst_deco[0] csr[3] csr[2] csr[1] csr[0] VSS VDD_1V8
+ n165 DECO_INSTR
XMemory_controller CTS_0_G3B4I2 n159 addrs_reg[24] addrs_reg[23] addrs_reg[22] addrs_reg[21]
+ addrs_reg[20] addrs_reg[19] addrs_reg[18] addrs_reg[17] addrs_reg[16] addrs_reg[15]
+ addrs_reg[14] addrs_reg[13] addrs_reg[12] addrs_reg[11] addrs_reg[10] addrs_reg[9]
+ addrs_reg[8] addrs_reg[7] addrs_reg[6] addrs_reg[5] addrs_reg[4] addrs_reg[3]
+ addrs_reg[2] addrs_reg[1] addrs_reg[0] d_write[31] d_write[30] d_write[29] d_write[28]
+ d_write[27] d_write[26] d_write[25] d_write[24] d_write[23] d_write[22] d_write[21]
+ d_write[20] d_write[19] d_write[18] d_write[17] d_write[16] d_write[15] d_write[14]
+ d_write[13] d_write[12] d_write[11] d_write[10] d_write[9] d_write[8] d_write[7]
+ d_write[6] d_write[5] d_write[4] d_write[3] d_write[2] d_write[1] d_write[0] b_mbc
+ h_mbc enable_mbc r_1_w_0_mbc D_pop_mbc[61] D_pop_mbc[60] D_pop_mbc[59] D_pop_mbc[58]
+ D_pop_mbc[57] VSS VSS VSS VSS VSS VSS VSS VSS VSS VSS VSS VSS D_pop_mbc[44] D_pop_mbc[43]
+ D_pop_mbc[42] D_pop_mbc[41] D_pop_mbc[40] D_pop_mbc[39] D_pop_mbc[38] D_pop_mbc[37]
+ D_pop_mbc[36] D_pop_mbc[35] D_pop_mbc[34] VSS VSS D_pop_mbc[31] D_pop_mbc[30]
+ D_pop_mbc[29] D_pop_mbc[28] D_pop_mbc[27] D_pop_mbc[26] D_pop_mbc[25] D_pop_mbc[24]
+ D_pop_mbc[23] D_pop_mbc[22] D_pop_mbc[21] D_pop_mbc[20] D_pop_mbc[19] D_pop_mbc[18]
+ D_pop_mbc[17] D_pop_mbc[16] D_pop_mbc[15] D_pop_mbc[14] D_pop_mbc[13] D_pop_mbc[12]
+ D_pop_mbc[11] D_pop_mbc[10] D_pop_mbc[9] D_pop_mbc[8] D_pop_mbc[7] D_pop_mbc[6]
+ D_pop_mbc[5] D_pop_mbc[4] D_pop_mbc[3] D_pop_mbc[2] D_pop_mbc[1] D_pop_mbc[0]
+ meip Q[31] Q[30] Q[29] Q[28] Q[27] Q[26] Q[25] Q[24] Q[23] Q[22] Q[21] Q[20] Q[19]
+ Q[18] Q[17] Q[16] Q[15] Q[14] Q[13] Q[12] Q[11] Q[10] Q[9] Q[8] Q[7] Q[6] Q[5]
+ Q[4] Q[3] Q[2] Q[1] Q[0] sign_ext d_read[31] d_read[30] d_read[29] d_read[28]
+ d_read[27] d_read[26] d_read[25] d_read[24] d_read[23] d_read[22] d_read[21] d_read[20]
+ d_read[19] d_read[18] d_read[17] d_read[16] d_read[15] d_read[14] d_read[13] d_read[12]
+ d_read[11] d_read[10] d_read[9] d_read[8] d_read[7] d_read[6] d_read[5] d_read[4]
+ d_read[3] d_read[2] d_read[1] d_read[0] a[10] a[9] a[8] a[7] a[6] a[5] a[4] a[3]
+ a[2] a[1] a[0] d[31] d[30] d[29] d[28] d[27] d[26] d[25] d[24] d[23] d[22] d[21]
+ d[20] d[19] d[18] d[17] d[16] d[15] d[14] d[13] d[12] d[11] d[10] d[9] d[8] d[7]
+ d[6] d[5] d[4] d[3] d[2] d[1] d[0] SYNOPSYS_UNCONNECTED_41 D_push_mbc[63] D_push_mbc[62]
+ SYNOPSYS_UNCONNECTED_42 SYNOPSYS_UNCONNECTED_43 D_push_mbc[59] D_push_mbc[58]
+ D_push_mbc[57] SYNOPSYS_UNCONNECTED_44 SYNOPSYS_UNCONNECTED_45 D_push_mbc[31]
+ D_push_mbc[30] D_push_mbc[29] D_push_mbc[28] D_push_mbc[27] D_push_mbc[26] D_push_mbc[25]
+ D_push_mbc[24] D_push_mbc[23] D_push_mbc[22] D_push_mbc[21] D_push_mbc[20] D_push_mbc[19]
+ D_push_mbc[18] D_push_mbc[17] D_push_mbc[16] D_push_mbc[15] D_push_mbc[14] D_push_mbc[13]
+ D_push_mbc[12] D_push_mbc[11] D_push_mbc[10] D_push_mbc[9] D_push_mbc[8] D_push_mbc[7]
+ D_push_mbc[6] D_push_mbc[5] D_push_mbc[4] D_push_mbc[3] D_push_mbc[2] D_push_mbc[1]
+ D_push_mbc[0] push_mbc mem_rdy_mem_cntrlr pop_mbc error_drs_mem_cntrlr clk_mem
+ cen SYNOPSYS_UNCONNECTED_74 wen VSS VDD_1V8 n158 n54 n8 n7 CTS_0_G3B2I1 mbc_max13
Xcentral_control CTS_0_G3B4I3 n12 codif_inst_deco[6] codif_inst_deco[5] codif_inst_deco[4]
+ codif_inst_deco[3] codif_inst_deco[2] codif_inst_deco[1] codif_inst_deco[0] mem_rdy_mem_cntrlr
+ error_drs_mem_cntrlr zero_alu int_A int_T int_E r_1_w_0_mbc b_mbc h_mbc enable_mbc
+ pop_intrpt ld_id_instrl_deco ld_addrs ld_pc s_addrs s_pc1[1] s_pc1[0] s_pc2[1]
+ s_pc2[0] s_alu[2] s_alu[1] s_alu[0] s_reg_w[3] s_reg_w[2] s_reg_w[1] s_reg_w[0]
+ s_csr[2] s_csr[1] s_csr[0] write_reg_fl csr_write cntrl_alu[3] cntrl_alu[2] cntrl_alu[1]
+ cntrl_alu[0] sign_ext inv_r1 rst_tmr VSS VDD_1V8 n11 n4 CTS_0_G3B4I1 control
XU418 mtip CTS_0_G3B2I2 VSS VDD_1V8 clk_timer mtie NO3I2HDLLX1
XU412 VSS VDD_1V8 ld_pc_clk ld_pc CTS_CLK_CTO_delay151 NO2I1HDLLX2
XCTS_CLK_CTO_delay15 CTS_CLK_CTO_delay151 VSS VDD_1V8 CTS_0_G3B2I2 BUHDLLX3
XINHDLLX6_G3B2I1 CTS_0_G3B3I1 VSS VDD_1V8 CTS_CLK_CTO_delay151 INHDLLX2
XINHDLLX2_G3B2I2 CTS_0_G3B3I2 VSS VDD_1V8 CTS_CLK_CTO_delay151 INHDLLX2
XINHDLLX6_G3B1I3 VSS VDD_1V8 CTS_0_G3B3I2 CTS_0_G3B4I3 INHDLLX6
XINHDLLX4_G3B1I2 VSS VDD_1V8 CTS_0_G3B4I2 CTS_0_G3B3I1 INHDLLX4
XINHDLLX6_G3B1I1 VSS VDD_1V8 CTS_0_G3B3I2 CTS_0_G3B4I1 INHDLLX6
XINHDLLX4_G4B1I1 VSS VDD_1V8 ld_pc_clk_G4B2I1 ld_pc_clk_G4B1I1 INHDLLX4
XBUHDLLX4_GB VSS VDD_1V8 clk_mem n451 BUHDLLX6
XINHDLLX4_G3B3I1 CTS_0_G3B2I1 VSS CTS_0_G3B1I1 VDD_1V8 INHDLLX3
XINHDLLX6_G3B3I2 VDD_1V8 VSS CTS_0_G3B2I2 CTS_0_G3B1I1 INHDLLX12
XINHDLLX6_G3B4I1 VDD_1V8 VSS CTS_0_G3B1I1 n448 INHDLLX12
XINHDLLX2_G4B2I1 ld_pc_clk_G4B1I1 VSS VDD_1V8 ld_pc_clk INHDLLX2
XBUHDLLX12_GB_MV VSS VDD_1V8 n448 clk BUHDLLX12
Xaddrs_reg_reg_1_ n197 ld_addrs N42 addrs_reg[1] VSS VDD_1V8 DFRRQHDLLX0
Xmtip_reg n3 CTS_0_G3B4I3 N19 mtip VSS VDD_1V8 DFRRQHDLLX0
Xaddrs_reg_reg_0_ n197 ld_addrs N41 addrs_reg[0] VSS VDD_1V8 DFRRQHDLLX0
XMemoria_8K SYNOPSYS_UNCONNECTED_75 VSS VSS VDD_1V8SRAM wen a[10] a[9] a[8] a[7]
+ a[6] a[5] a[4] a[3] a[2] a[1] a[0] cen n451 d[31] d[30] d[29] d[28] d[27] d[26]
+ d[25] d[24] d[23] d[22] d[21] d[20] d[19] d[18] d[17] d[16] d[15] d[14] d[13]
+ d[12] d[11] d[10] d[9] d[8] d[7] d[6] d[5] d[4] d[3] d[2] d[1] d[0] Q[31] Q[30]
+ Q[29] Q[28] Q[27] Q[26] Q[25] Q[24] Q[23] Q[22] Q[21] Q[20] Q[19] Q[18] Q[17]
+ Q[16] Q[15] Q[14] Q[13] Q[12] Q[11] Q[10] Q[9] Q[8] Q[7] Q[6] Q[5] Q[4] Q[3] Q[2]
+ Q[1] Q[0] XSPRAMLP_2048X32_M8P
XU81 n45 VSS VDD_1V8 count_timer[2] INHDLLX0
XU80 n46 VSS VDD_1V8 count_timer[1] n43 n44 count_timer[0] ON22HDLLX0
XU79 VSS count_timer[1] n43 VDD_1V8 comparation[0] n44 NA22HDLLX0
XU78 n43 VSS VDD_1V8 comparation[1] INHDLLX0
XU77 n48 VSS VDD_1V8 count_timer[3] INHDLLX0
XU76 n50 VSS VDD_1V8 count_timer[4] INHDLLX0
XU75 n52 VSS VDD_1V8 count_timer[5] INHDLLX0
XU74 n56 VSS VDD_1V8 count_timer[6] INHDLLX0
XU73 VSS VDD_1V8 n39 n41 count_timer[10] n38 n40 n42 n67 AN321HDLLX0
XU72 VSS VDD_1V8 n38 count_timer[11] comparation[11] NO2I1HDLLX0
XU71 n39 VSS VDD_1V8 n68 INHDLLX0
XU70 n40 VSS VDD_1V8 comparation[8] n55 n37 comparation[9] ON22HDLLX0
XU69 n55 VSS VDD_1V8 count_timer[8] INHDLLX0
XU68 n42 VSS VDD_1V8 comparation[10] INHDLLX0
XU67 VSS n36 n41 VDD_1V8 n68 NA2HDLLX0
XU66 n41 VSS count_timer[11] VDD_1V8 comparation[11] NA2I1HDLLX0
XU65 VSS VDD_1V8 n36 comparation[10] n37 comparation[9] n35 AN22HDLLX0
XU64 n35 VSS VDD_1V8 count_timer[10] INHDLLX0
XU63 n37 VSS VDD_1V8 count_timer[9] INHDLLX0
XU62 n70 VSS VDD_1V8 comparation[15] n33 n34 comparation[14] ON22HDLLX0
XU61 VSS comparation[15] n33 VDD_1V8 count_timer[14] n34 NA22HDLLX0
XU60 n71 VSS VDD_1V8 comparation[13] n62 n32 comparation[12] ON22HDLLX0
XU59 VSS comparation[13] n62 VDD_1V8 count_timer[12] n32 NA22HDLLX0
XU58 n62 VSS VDD_1V8 count_timer[13] INHDLLX0
XU57 VSS VDD_1V8 n72 comparation[14] n33 comparation[15] n31 AN22HDLLX0
XU56 n31 VSS VDD_1V8 count_timer[14] INHDLLX0
XU55 n33 VSS VDD_1V8 count_timer[15] INHDLLX0
XU54 VSS n79 comparation[17] VDD_1V8 n74 NA2HDLLX0
XU53 n79 VSS VDD_1V8 count_timer[17] INHDLLX0
XU52 VSS n89 comparation[21] VDD_1V8 n75 NA2HDLLX0
XU51 n89 VSS VDD_1V8 count_timer[21] INHDLLX0
XU50 VSS VDD_1V8 n76 comparation[16] n77 comparation[20] n78 AN22HDLLX0
XU49 n78 VSS VDD_1V8 count_timer[16] INHDLLX0
XU48 n77 VSS VDD_1V8 count_timer[20] INHDLLX0
XU47 VSS VDD_1V8 n93 comparation[23] n30 comparation[22] n96 AN22HDLLX0
XU46 VSS VDD_1V8 n94 comparation[19] n84 comparation[18] n83 AN22HDLLX0
XU45 n83 VSS VDD_1V8 count_timer[19] INHDLLX0
XU44 n84 VSS VDD_1V8 count_timer[18] INHDLLX0
XU43 VSS VDD_1V8 n100 comparation[23] n96 comparation[22] n30 AN211HDLLX0
XU42 n30 VSS VDD_1V8 count_timer[22] INHDLLX0
XU41 n96 VSS VDD_1V8 count_timer[23] INHDLLX0
XU40 VSS n102 n113 count_timer[28] VDD_1V8 NO2HDLLX0
XU39 n113 VSS VDD_1V8 comparation[28] INHDLLX0
XU38 n103 VSS VDD_1V8 count_timer[24] INHDLLX0
XU37 VSS VDD_1V8 n118 comparation[31] n29 comparation[30] n123 AN22HDLLX0
XU36 n29 VSS VDD_1V8 count_timer[30] INHDLLX0
XU35 VSS VDD_1V8 n119 comparation[27] n109 comparation[26] n108 AN22HDLLX0
XU34 n108 VSS VDD_1V8 count_timer[27] INHDLLX0
XU33 n109 VSS VDD_1V8 count_timer[26] INHDLLX0
XU32 n123 VSS VDD_1V8 count_timer[31] INHDLLX0
XU31 VSS VDD_1V8 alu_a[16] n277 n28 n314 MU2IHDLLX0
XU30 VSS VDD_1V8 n156 n28 n155 R1[16] imm_out[16] pc[16] n154 AN222HDLLX0
XU25 VSS N37 VDD_1V8 n26 n27 N39 ON21HDLLX0
XU24 VSS n26 VDD_1V8 n24 n25 csr[1] ON21HDLLX0
XU23 s_csr[1] VSS s_csr[2] s_csr[0] VDD_1V8 n24 AN21HDLLX0
XU22 n27 VSS VDD_1V8 csr_id[1] INHDLLX0
XU21 VSS s_csr[2] n25 VDD_1V8 N39 NA2HDLLX0
XU20 n25 VSS VDD_1V8 n366 INHDLLX0
XU19 VSS n366 s_csr[0] s_csr[1] VDD_1V8 NO2HDLLX0
XU16 VSS VDD_1V8 n22 imm_out[2] n368 CSR[2] n166 AN22HDLLX0
XU14 VSS n23 VDD_1V8 n20 d_write[2] s_alu[0] ON21HDLLX0
XU13 VSS n20 s_alu[2] s_alu[1] VDD_1V8 NO2HDLLX0
XU9 VSS n16 s_alu[1] VDD_1V8 n21 NA2HDLLX0
XU8 n17 VSS VDD_1V8 s_alu[0] INHDLLX0
XU7 VSS VDD_1V8 n18 n375 n368 CSR[0] d_write[0] AN22HDLLX0
XU4 n16 VSS VDD_1V8 s_alu[2] INHDLLX0
XU3 n19 VSS VDD_1V8 imm_out[0] INHDLLX0
Xaddrs_reg_reg_24_ n8 ld_addrs N65 addrs_reg[24] VSS VDD_1V8 DFRRQHDLLX0
Xaddrs_reg_reg_23_ n8 ld_addrs N64 addrs_reg[23] VSS VDD_1V8 DFRRQHDLLX0
Xaddrs_reg_reg_22_ n8 ld_addrs N63 addrs_reg[22] VSS VDD_1V8 DFRRQHDLLX0
Xaddrs_reg_reg_21_ n197 ld_addrs N62 addrs_reg[21] VSS VDD_1V8 DFRRQHDLLX0
Xaddrs_reg_reg_20_ n8 ld_addrs N61 addrs_reg[20] VSS VDD_1V8 DFRRQHDLLX0
Xaddrs_reg_reg_19_ n8 ld_addrs N60 addrs_reg[19] VSS VDD_1V8 DFRRQHDLLX0
Xaddrs_reg_reg_18_ n197 ld_addrs N59 addrs_reg[18] VSS VDD_1V8 DFRRQHDLLX0
Xaddrs_reg_reg_17_ n197 ld_addrs N58 addrs_reg[17] VSS VDD_1V8 DFRRQHDLLX0
Xaddrs_reg_reg_16_ n8 ld_addrs N57 addrs_reg[16] VSS VDD_1V8 DFRRQHDLLX0
Xaddrs_reg_reg_15_ n8 ld_addrs N56 addrs_reg[15] VSS VDD_1V8 DFRRQHDLLX0
Xaddrs_reg_reg_14_ n8 ld_addrs N55 addrs_reg[14] VSS VDD_1V8 DFRRQHDLLX0
Xaddrs_reg_reg_13_ n8 ld_addrs N54 addrs_reg[13] VSS VDD_1V8 DFRRQHDLLX0
Xaddrs_reg_reg_12_ n54 ld_addrs N53 addrs_reg[12] VSS VDD_1V8 DFRRQHDLLX0
Xaddrs_reg_reg_11_ n54 ld_addrs N52 addrs_reg[11] VSS VDD_1V8 DFRRQHDLLX0
Xaddrs_reg_reg_10_ n54 ld_addrs N51 addrs_reg[10] VSS VDD_1V8 DFRRQHDLLX0
Xaddrs_reg_reg_9_ n54 ld_addrs N50 addrs_reg[9] VSS VDD_1V8 DFRRQHDLLX0
Xaddrs_reg_reg_8_ n8 ld_addrs N49 addrs_reg[8] VSS VDD_1V8 DFRRQHDLLX0
Xaddrs_reg_reg_7_ n54 ld_addrs N48 addrs_reg[7] VSS VDD_1V8 DFRRQHDLLX0
Xaddrs_reg_reg_6_ n54 ld_addrs N47 addrs_reg[6] VSS VDD_1V8 DFRRQHDLLX0
Xaddrs_reg_reg_5_ n54 ld_addrs N46 addrs_reg[5] VSS VDD_1V8 DFRRQHDLLX0
Xaddrs_reg_reg_4_ n54 ld_addrs N45 addrs_reg[4] VSS VDD_1V8 DFRRQHDLLX0
Xaddrs_reg_reg_3_ n54 ld_addrs N44 addrs_reg[3] VSS VDD_1V8 DFRRQHDLLX0
Xaddrs_reg_reg_2_ n8 ld_addrs N43 addrs_reg[2] VSS VDD_1V8 DFRRQHDLLX0
XU179 VSS VDD_1V8 alu_a[23] inv_r1 n146 n347 MU2IHDLLX0
XU178 VSS VDD_1V8 n156 n146 n155 R1[23] imm_out[23] pc[23] n154 AN222HDLLX0
XU177 VSS VDD_1V8 alu_a[22] n277 n145 n347 MU2IHDLLX0
XU176 VSS VDD_1V8 n156 n145 n155 R1[22] imm_out[22] pc[22] n154 AN222HDLLX0
XU175 VSS VDD_1V8 alu_a[21] inv_r1 n144 n347 MU2IHDLLX0
XU174 VSS VDD_1V8 n156 n144 n155 R1[21] imm_out[21] pc[21] n154 AN222HDLLX0
XU173 VSS VDD_1V8 alu_a[20] n277 n143 n347 MU2IHDLLX0
XU172 VSS VDD_1V8 n156 n143 n155 R1[20] imm_out[20] pc[20] n154 AN222HDLLX0
XU171 VSS VDD_1V8 alu_a[19] inv_r1 n142 n347 MU2IHDLLX0
XU170 VSS VDD_1V8 n156 n142 n155 R1[19] imm_out[19] pc[19] n154 AN222HDLLX0
XU169 VSS VDD_1V8 alu_a[18] n277 n141 n347 MU2IHDLLX0
XU168 VSS VDD_1V8 n156 n141 n155 R1[18] imm_out[18] pc[18] n154 AN222HDLLX0
XU167 VSS VDD_1V8 alu_a[17] inv_r1 n140 n347 MU2IHDLLX0
XU166 VSS VDD_1V8 n156 n140 n155 R1[17] imm_out[17] pc[17] n154 AN222HDLLX0
XU165 VSS VDD_1V8 alu_a[15] n277 n139 n314 MU2IHDLLX0
XU164 VSS VDD_1V8 n156 n139 n155 R1[15] imm_out[15] pc[15] n154 AN222HDLLX0
XU163 VSS VDD_1V8 alu_a[14] n277 n138 n314 MU2IHDLLX0
XU162 VSS VDD_1V8 n156 n138 n155 R1[14] imm_out[14] pc[14] n154 AN222HDLLX0
XU161 VSS VDD_1V8 alu_a[13] n277 n137 n314 MU2IHDLLX0
XU160 VSS VDD_1V8 n156 n137 n155 R1[13] imm_out[13] pc[13] n154 AN222HDLLX0
XU159 VSS VDD_1V8 alu_a[12] n277 n136 n314 MU2IHDLLX0
XU158 VSS VDD_1V8 n156 n136 n155 R1[12] imm_out[12] pc[12] n154 AN222HDLLX0
XU157 VSS VDD_1V8 alu_a[11] n277 n135 n314 MU2IHDLLX0
XU156 VSS VDD_1V8 n156 n135 n155 R1[11] imm_out[11] pc[11] n154 AN222HDLLX0
XU155 VSS VDD_1V8 alu_a[10] n277 n134 n314 MU2IHDLLX0
XU154 VSS VDD_1V8 n156 n134 n155 R1[10] imm_out[10] pc[10] n154 AN222HDLLX0
XU153 VSS VDD_1V8 alu_a[9] n277 n133 n314 MU2IHDLLX0
XU152 VSS VDD_1V8 n156 n133 n155 R1[9] imm_out[9] pc[9] n154 AN222HDLLX0
XU151 VSS VDD_1V8 alu_a[8] n277 n132 n314 MU2IHDLLX0
XU150 VSS VDD_1V8 n156 n132 n155 R1[8] imm_out[8] pc[8] n154 AN222HDLLX0
XU149 VSS VDD_1V8 alu_a[7] n277 n131 n314 MU2IHDLLX0
XU148 VSS VDD_1V8 n156 n131 n155 R1[7] imm_out[7] pc[7] n154 AN222HDLLX0
XU147 VSS VDD_1V8 alu_a[6] n277 n130 n314 MU2IHDLLX0
XU146 VSS VDD_1V8 n156 n130 n155 R1[6] imm_out[6] pc[6] n154 AN222HDLLX0
XU145 VSS VDD_1V8 alu_a[5] n277 n129 n314 MU2IHDLLX0
XU144 VSS VDD_1V8 n156 n129 n155 R1[5] imm_out[5] pc[5] n154 AN222HDLLX0
XU143 VSS VDD_1V8 alu_a[4] n277 n128 n314 MU2IHDLLX0
XU142 VSS VDD_1V8 n156 n128 n155 R1[4] imm_out[4] pc[4] n154 AN222HDLLX0
XU141 VSS VDD_1V8 alu_a[3] n277 n127 n314 MU2IHDLLX0
XU140 VSS VDD_1V8 n156 n127 n155 R1[3] imm_out[3] pc[3] n154 AN222HDLLX0
XU139 VSS VDD_1V8 alu_a[2] n277 n126 n314 MU2IHDLLX0
XU138 VSS VDD_1V8 n154 n126 n155 R1[2] pc[2] imm_out[2] n156 AN222HDLLX0
XU137 VSS VDD_1V8 alu_a[1] n277 n125 n314 MU2IHDLLX0
XU136 VSS VDD_1V8 n154 n125 n156 pc[1] R1[1] imm_out[1] n155 AN222HDLLX0
XU135 VSS VDD_1V8 alu_a[0] n277 n124 n314 MU2IHDLLX0
XU134 VSS VDD_1V8 n156 n124 n154 imm_out[0] R1[0] pc[0] n155 AN222HDLLX0
XU133 VSS meip meie VDD_1V8 int_E AND2HDLLX0
XU132 VSS mtip mtie VDD_1V8 int_T AND2HDLLX0
XU131 VSS maip maie VDD_1V8 int_A AND2HDLLX0
XU130 VSS VDD_1V8 pop pop_mbc pop_intrpt OR2HDLLX0
XU127 n121 VSS comparation[31] n123 n122 VDD_1V8 N19 ON211HDLLX0
XU126 VSS comparation[30] n120 VDD_1V8 n121 count_timer[30] NA3I2HDLLX0
XU125 VSS comparation[31] n123 VDD_1V8 n120 AND2HDLLX0
XU124 n122 VSS VDD_1V8 n116 n118 n118 n117 n119 AN32HDLLX0
XU123 VSS VDD_1V8 n114 n116 n115 comparation[29] comparation[29] n115 n114 AN222HDLLX0
XU122 VSS VDD_1V8 n115 n112 n113 count_timer[28] n111 AN22HDLLX0
XU121 VSS comparation[26] n108 VDD_1V8 n109 comparation[27] n107 n111 n110 ON321HDLLX0
XU120 n107 VSS VDD_1V8 n105 n119 n119 n106 count_timer[25] AN32HDLLX0
XU119 VSS VDD_1V8 n105 comparation[25] n104 comparation[24] n103 AN211HDLLX0
XU118 n106 VSS VDD_1V8 comparation[25] INHDLLX0
XU117 VSS comparation[27] n108 VDD_1V8 n110 AND2HDLLX0
XU116 n112 VSS VDD_1V8 n102 INHDLLX0
XU115 VSS VDD_1V8 n117 comparation[24] n103 n102 n101 AN211HDLLX0
XU114 n97 VSS n100 n99 n98 VDD_1V8 n101 ON211HDLLX0
XU113 VSS n114 comparation[29] VDD_1V8 n97 NA2HDLLX0
XU112 n114 VSS VDD_1V8 count_timer[29] INHDLLX0
XU111 VSS n104 comparation[25] VDD_1V8 n98 NA2HDLLX0
XU110 n104 VSS VDD_1V8 count_timer[25] INHDLLX0
XU109 VSS n99 VDD_1V8 n95 n96 comparation[23] ON21HDLLX0
XU108 n95 VSS VDD_1V8 n91 n93 n93 n92 n94 AN32HDLLX0
XU107 VSS VDD_1V8 n89 n91 n90 comparation[21] comparation[21] n90 n89 AN222HDLLX0
XU106 VSS VDD_1V8 n90 n87 n88 count_timer[20] n86 AN22HDLLX0
XU105 VSS comparation[18] n83 VDD_1V8 n84 comparation[19] n82 n86 n85 ON321HDLLX0
XU104 n82 VSS VDD_1V8 n80 n94 n94 n81 count_timer[17] AN32HDLLX0
XU103 VSS VDD_1V8 n80 comparation[17] n79 comparation[16] n78 AN211HDLLX0
XU102 n81 VSS VDD_1V8 comparation[17] INHDLLX0
XU101 VSS comparation[19] n83 VDD_1V8 n85 AND2HDLLX0
XU100 VSS n77 comparation[20] VDD_1V8 n87 NA2HDLLX0
XU99 n88 VSS VDD_1V8 comparation[20] INHDLLX0
XU97 VSS VDD_1V8 n73 n72 n71 n70 n69 AN211HDLLX0
XU96 n69 VSS n67 VDD_1V8 n68 n66 n65 n67 AN221HDLLX0
XU95 n63 VSS count_timer[12] n64 n72 VDD_1V8 n65 ON211HDLLX0
XU94 VSS n62 comparation[13] VDD_1V8 n63 NA2HDLLX0
XU93 n64 VSS VDD_1V8 comparation[12] INHDLLX0
XU92 n66 VSS VDD_1V8 n58 n60 n60 n59 n61 AN32HDLLX0
XU91 VSS n58 n57 comparation[7] VDD_1V8 NO2HDLLX0
XU90 VSS n56 comparation[6] VDD_1V8 n59 NA2HDLLX0
XU89 VSS VDD_1V8 n60 comparation[7] n55 comparation[8] n57 AN22HDLLX0
XU88 n57 VSS VDD_1V8 count_timer[7] INHDLLX0
XU87 VSS n61 VDD_1V8 n53 n56 comparation[6] ON21HDLLX0
XU276 VSS alu_b[19] n166 n368 d_write[19] CSR[19] VDD_1V8 imm_out[19] n375 AO222HDLLX0
XU275 VSS alu_b[18] n166 n368 d_write[18] CSR[18] VDD_1V8 imm_out[18] n375 AO222HDLLX0
XU274 VSS alu_b[17] n166 n368 d_write[17] CSR[17] VDD_1V8 imm_out[17] n375 AO222HDLLX0
XU273 VSS alu_b[16] n166 n368 d_write[16] CSR[16] VDD_1V8 imm_out[16] n375 AO222HDLLX0
XU272 VSS alu_b[15] n166 n368 d_write[15] CSR[15] VDD_1V8 imm_out[15] n375 AO222HDLLX0
XU271 VSS alu_b[14] n166 n368 d_write[14] CSR[14] VDD_1V8 imm_out[14] n375 AO222HDLLX0
XU270 VSS alu_b[13] n166 n368 d_write[13] CSR[13] VDD_1V8 imm_out[13] n375 AO222HDLLX0
XU269 VSS alu_b[12] n166 n368 d_write[12] CSR[12] VDD_1V8 imm_out[12] n375 AO222HDLLX0
XU268 VSS alu_b[11] n166 n368 d_write[11] CSR[11] VDD_1V8 imm_out[11] n375 AO222HDLLX0
XU267 VSS alu_b[10] n166 n368 d_write[10] CSR[10] VDD_1V8 imm_out[10] n375 AO222HDLLX0
XU266 VSS alu_b[9] n166 n368 d_write[9] CSR[9] VDD_1V8 imm_out[9] n375 AO222HDLLX0
XU265 VSS alu_b[8] n166 n368 d_write[8] CSR[8] VDD_1V8 imm_out[8] n375 AO222HDLLX0
XU264 VSS alu_b[7] n166 n368 d_write[7] CSR[7] VDD_1V8 imm_out[7] n375 AO222HDLLX0
XU263 VSS alu_b[6] n166 n368 d_write[6] CSR[6] VDD_1V8 imm_out[6] n375 AO222HDLLX0
XU262 VSS alu_b[5] n166 n368 d_write[5] CSR[5] VDD_1V8 imm_out[5] n375 AO222HDLLX0
XU261 VSS alu_b[4] n166 n368 d_write[4] CSR[4] VDD_1V8 imm_out[4] n375 AO222HDLLX0
XU260 VSS alu_b[3] n166 n368 d_write[3] CSR[3] VDD_1V8 imm_out[3] n375 AO222HDLLX0
XU259 VSS alu_b[1] n166 n368 d_write[1] CSR[1] VDD_1V8 imm_out[1] n375 AO222HDLLX0
XU258 VSS pc_pre[31] n163 imm_out[31] n162 n161 VDD_1V8 alu_out[31] CSR[31] AO222HDLLX0
XU257 VSS pc_pre[30] n163 imm_out[30] n162 n161 VDD_1V8 alu_out[30] CSR[30] AO222HDLLX0
XU256 VSS pc_pre[29] n163 imm_out[29] n162 n161 VDD_1V8 alu_out[29] CSR[29] AO222HDLLX0
XU255 VSS pc_pre[28] n163 imm_out[28] n162 n161 VDD_1V8 alu_out[28] CSR[28] AO222HDLLX0
XU254 VSS pc_pre[27] n163 imm_out[27] n162 n161 VDD_1V8 alu_out[27] CSR[27] AO222HDLLX0
XU253 VSS pc_pre[26] n163 imm_out[26] n162 n161 VDD_1V8 alu_out[26] CSR[26] AO222HDLLX0
XU252 VSS pc_pre[25] n163 imm_out[25] n162 n161 VDD_1V8 alu_out[25] CSR[25] AO222HDLLX0
XU251 VSS pc_pre[24] n163 imm_out[24] n162 n161 VDD_1V8 alu_out[24] CSR[24] AO222HDLLX0
XU250 VSS pc_pre[23] n163 imm_out[23] n162 n161 VDD_1V8 alu_out[23] CSR[23] AO222HDLLX0
XU249 VSS pc_pre[22] n163 imm_out[22] n162 n161 VDD_1V8 alu_out[22] CSR[22] AO222HDLLX0
XU248 VSS pc_pre[21] n163 imm_out[21] n162 n161 VDD_1V8 alu_out[21] CSR[21] AO222HDLLX0
XU247 VSS pc_pre[20] n163 imm_out[20] n162 n161 VDD_1V8 alu_out[20] CSR[20] AO222HDLLX0
XU246 VSS pc_pre[19] n163 imm_out[19] n162 n161 VDD_1V8 alu_out[19] CSR[19] AO222HDLLX0
XU245 VSS pc_pre[18] n163 imm_out[18] n162 n161 VDD_1V8 alu_out[18] CSR[18] AO222HDLLX0
XU244 VSS pc_pre[17] n163 imm_out[17] n162 n161 VDD_1V8 alu_out[17] CSR[17] AO222HDLLX0
XU243 VSS pc_pre[16] n163 imm_out[16] n162 n161 VDD_1V8 alu_out[16] CSR[16] AO222HDLLX0
XU242 VSS pc_pre[15] n163 imm_out[15] n162 n161 VDD_1V8 alu_out[15] CSR[15] AO222HDLLX0
XU241 VSS pc_pre[14] n163 imm_out[14] n162 n161 VDD_1V8 alu_out[14] CSR[14] AO222HDLLX0
XU240 VSS pc_pre[13] n163 imm_out[13] n162 n161 VDD_1V8 alu_out[13] CSR[13] AO222HDLLX0
XU239 VSS pc_pre[12] n163 imm_out[12] n162 n161 VDD_1V8 alu_out[12] CSR[12] AO222HDLLX0
XU238 VSS pc_pre[11] n163 imm_out[11] n162 n161 VDD_1V8 alu_out[11] CSR[11] AO222HDLLX0
XU237 VSS pc_pre[10] n163 imm_out[10] n162 n161 VDD_1V8 alu_out[10] CSR[10] AO222HDLLX0
XU236 VSS pc_pre[9] n163 imm_out[9] n162 n161 VDD_1V8 alu_out[9] CSR[9] AO222HDLLX0
XU235 VSS pc_pre[8] n163 imm_out[8] n162 n161 VDD_1V8 alu_out[8] CSR[8] AO222HDLLX0
XU234 VSS pc_pre[7] n163 imm_out[7] n162 n161 VDD_1V8 alu_out[7] CSR[7] AO222HDLLX0
XU233 VSS pc_pre[6] n163 imm_out[6] n162 n161 VDD_1V8 alu_out[6] CSR[6] AO222HDLLX0
XU232 VSS pc_pre[5] n163 imm_out[5] n162 n161 VDD_1V8 alu_out[5] CSR[5] AO222HDLLX0
XU231 VSS pc_pre[4] n163 imm_out[4] n162 n161 VDD_1V8 alu_out[4] CSR[4] AO222HDLLX0
XU230 VSS pc_pre[3] n163 imm_out[3] n162 n161 VDD_1V8 alu_out[3] CSR[3] AO222HDLLX0
XU229 VSS pc_pre[2] n163 CSR[2] n161 n162 VDD_1V8 alu_out[2] imm_out[2] AO222HDLLX0
XU228 VSS pc_pre[1] n163 imm_out[1] n162 n161 VDD_1V8 alu_out[1] CSR[1] AO222HDLLX0
XU227 VSS pc_pre[0] n162 n161 n163 imm_out[0] VDD_1V8 CSR[0] alu_out[0] AO222HDLLX0
XU223 VSS csr[2] n366 VDD_1V8 n160 N36 NA22HDLLX0
XU222 VSS n160 VDD_1V8 s_csr[2] csr_id[2] n366 ON21HDLLX0
XU221 VSS VDD_1V8 pc[24] alu_out[24] s_addrs n251 N65 OA22HDLLX0
XU220 VSS VDD_1V8 pc[23] alu_out[23] s_addrs n251 N64 OA22HDLLX0
XU219 VSS VDD_1V8 pc[22] alu_out[22] s_addrs n251 N63 OA22HDLLX0
XU218 VSS VDD_1V8 pc[21] alu_out[21] s_addrs n251 N62 OA22HDLLX0
XU217 VSS VDD_1V8 pc[20] alu_out[20] s_addrs n251 N61 OA22HDLLX0
XU216 VSS VDD_1V8 pc[19] alu_out[19] s_addrs n251 N60 OA22HDLLX0
XU215 VSS VDD_1V8 pc[18] alu_out[18] s_addrs n251 N59 OA22HDLLX0
XU214 VSS VDD_1V8 pc[17] alu_out[17] s_addrs n251 N58 OA22HDLLX0
XU213 VSS VDD_1V8 pc[16] alu_out[16] s_addrs n251 N57 OA22HDLLX0
XU212 VSS VDD_1V8 pc[15] alu_out[15] s_addrs n251 N56 OA22HDLLX0
XU211 VSS VDD_1V8 pc[14] alu_out[14] s_addrs n251 N55 OA22HDLLX0
XU210 VSS VDD_1V8 pc[13] alu_out[13] s_addrs n251 N54 OA22HDLLX0
XU209 VSS VDD_1V8 pc[12] alu_out[12] s_addrs n251 N53 OA22HDLLX0
XU208 VSS VDD_1V8 pc[11] alu_out[11] s_addrs n251 N52 OA22HDLLX0
XU207 VSS VDD_1V8 pc[10] alu_out[10] s_addrs n251 N51 OA22HDLLX0
XU206 VSS VDD_1V8 pc[9] alu_out[9] s_addrs n251 N50 OA22HDLLX0
XU205 VSS VDD_1V8 pc[8] alu_out[8] s_addrs n251 N49 OA22HDLLX0
XU204 VSS VDD_1V8 pc[7] alu_out[7] s_addrs n251 N48 OA22HDLLX0
XU203 VSS VDD_1V8 pc[6] alu_out[6] s_addrs n251 N47 OA22HDLLX0
XU202 VSS VDD_1V8 pc[5] alu_out[5] s_addrs n251 N46 OA22HDLLX0
XU201 VSS VDD_1V8 pc[4] alu_out[4] s_addrs n251 N45 OA22HDLLX0
XU200 VSS VDD_1V8 pc[3] alu_out[3] s_addrs n251 N44 OA22HDLLX0
XU199 VSS VDD_1V8 pc[2] alu_out[2] s_addrs n251 N43 OA22HDLLX0
XU198 VSS VDD_1V8 pc[1] alu_out[1] s_addrs n251 N42 OA22HDLLX0
XU197 VSS VDD_1V8 pc[0] alu_out[0] s_addrs n251 N41 OA22HDLLX0
XU195 VSS VDD_1V8 alu_a[31] n277 n157 n314 MU2IHDLLX0
XU194 VSS VDD_1V8 n154 n157 n156 pc[31] R1[31] imm_out[31] n155 AN222HDLLX0
XU193 VSS VDD_1V8 alu_a[30] n277 n153 n314 MU2IHDLLX0
XU192 VSS VDD_1V8 n156 n153 n155 R1[30] imm_out[30] pc[30] n154 AN222HDLLX0
XU191 VSS VDD_1V8 alu_a[29] n277 n152 n347 MU2IHDLLX0
XU190 VSS VDD_1V8 n156 n152 n155 R1[29] imm_out[29] pc[29] n154 AN222HDLLX0
XU189 VSS VDD_1V8 alu_a[28] inv_r1 n151 n347 MU2IHDLLX0
XU188 VSS VDD_1V8 n156 n151 n155 R1[28] imm_out[28] pc[28] n154 AN222HDLLX0
XU187 VSS VDD_1V8 alu_a[27] n277 n150 n347 MU2IHDLLX0
XU186 VSS VDD_1V8 n156 n150 n155 R1[27] imm_out[27] pc[27] n154 AN222HDLLX0
XU185 VSS VDD_1V8 alu_a[26] inv_r1 n149 n347 MU2IHDLLX0
XU184 VSS VDD_1V8 n156 n149 n155 R1[26] imm_out[26] pc[26] n154 AN222HDLLX0
XU183 VSS VDD_1V8 alu_a[25] inv_r1 n148 n347 MU2IHDLLX0
XU182 VSS VDD_1V8 n156 n148 n155 R1[25] imm_out[25] pc[25] n154 AN222HDLLX0
XU181 VSS VDD_1V8 alu_a[24] inv_r1 n147 n347 MU2IHDLLX0
XU180 VSS VDD_1V8 n156 n147 n155 R1[24] imm_out[24] pc[24] n154 AN222HDLLX0
XU383 n237 n236 VSS VDD_1V8 n238 reg_write_data[9] n239 NA4HDLLX0
XU382 pc[9] VSS n235 n354 VDD_1V8 n236 AN21HDLLX0
XU381 n360 VSS VDD_1V8 n353 CSR[9] codif_inst_deco[6] n235 AO22HDLLX1
XU380 VSS VDD_1V8 n237 n359 d_read[9] n240 D_pop_mbc[9] AN22HDLLX0
XU379 VSS VDD_1V8 n238 n358 R1[9] n355 imm_out[9] AN22HDLLX0
XU378 VSS VDD_1V8 n239 n283 alu_out[9] n320 D_pop_mbc[35] AN22HDLLX0
XU377 n231 n230 VSS VDD_1V8 n232 reg_write_data[8] n233 NA4HDLLX0
XU376 pc[8] VSS n229 n354 VDD_1V8 n230 AN21HDLLX0
XU375 n360 VSS VDD_1V8 n353 CSR[8] codif_inst_deco[5] n229 AO22HDLLX1
XU374 VSS VDD_1V8 n231 n359 d_read[8] n240 D_pop_mbc[8] AN22HDLLX0
XU373 VSS VDD_1V8 n232 n358 R1[8] n355 imm_out[8] AN22HDLLX0
XU372 VSS VDD_1V8 n233 n283 alu_out[8] n320 D_pop_mbc[34] AN22HDLLX0
XU371 n226 n225 VSS VDD_1V8 n227 reg_write_data[7] n228 NA4HDLLX0
XU370 pc[7] VSS n224 n354 VDD_1V8 n225 AN21HDLLX0
XU369 n360 VSS VDD_1V8 n353 CSR[7] codif_inst_deco[4] n224 AO22HDLLX1
XU368 VSS VDD_1V8 n226 n359 d_read[7] n240 D_pop_mbc[7] AN22HDLLX0
XU367 VSS VDD_1V8 n227 n358 R1[7] n355 imm_out[7] AN22HDLLX0
XU366 VSS VDD_1V8 n228 n283 alu_out[7] n320 D_pop_mbc[33] AN22HDLLX0
XU365 n221 n220 VSS VDD_1V8 n222 reg_write_data[6] n223 NA4HDLLX0
XU364 pc[6] VSS n219 n354 VDD_1V8 n220 AN21HDLLX0
XU363 n360 VSS VDD_1V8 n353 CSR[6] codif_inst_deco[3] n219 AO22HDLLX1
XU362 VSS VDD_1V8 n221 n359 d_read[6] n240 D_pop_mbc[6] AN22HDLLX0
XU361 VSS VDD_1V8 n222 n358 R1[6] n355 imm_out[6] AN22HDLLX0
XU360 VSS VDD_1V8 n223 n283 alu_out[6] n320 D_pop_mbc[32] AN22HDLLX0
XU359 n216 n215 VSS VDD_1V8 n217 reg_write_data[5] n218 NA4HDLLX0
XU358 pc[5] VSS n214 n354 VDD_1V8 n215 AN21HDLLX0
XU357 n360 VSS VDD_1V8 n353 CSR[5] codif_inst_deco[2] n214 AO22HDLLX1
XU356 VSS VDD_1V8 n216 n359 d_read[5] n240 D_pop_mbc[5] AN22HDLLX0
XU354 VSS VDD_1V8 n217 n358 R1[5] n355 imm_out[5] AN22HDLLX0
XU353 VSS VDD_1V8 n218 n283 alu_out[5] n320 D_pop_mbc[59] AN22HDLLX0
XU351 n211 n210 VSS VDD_1V8 n212 reg_write_data[4] n213 NA4HDLLX0
XU350 n210 rd[4] n208 VSS VDD_1V8 n209 n207 AN31HDLLX0
XU349 VSS D_pop_mbc[58] n283 VDD_1V8 n205 n207 NA22HDLLX0
XU348 VSS VDD_1V8 n205 n353 pc[4] n354 codif_inst_deco[1] AN22HDLLX0
XU347 VSS VDD_1V8 n211 n359 CSR[4] n360 D_pop_mbc[4] AN22HDLLX0
XU346 VSS VDD_1V8 n212 n240 imm_out[4] n358 d_read[4] AN22HDLLX0
XU345 VSS VDD_1V8 n213 n355 alu_out[4] n320 R1[4] AN22HDLLX0
XU344 n202 n201 VSS VDD_1V8 n203 reg_write_data[3] n204 NA4HDLLX0
XU343 n201 rd[3] n208 VSS VDD_1V8 n209 n200 AN31HDLLX0
XU342 VSS D_pop_mbc[57] n283 VDD_1V8 n199 n200 NA22HDLLX0
XU341 VSS VDD_1V8 n199 n353 pc[3] n354 codif_inst_deco[0] AN22HDLLX0
XU337 VSS VDD_1V8 n202 n359 CSR[3] n360 D_pop_mbc[3] AN22HDLLX0
XU336 VSS VDD_1V8 n203 n240 imm_out[3] n358 d_read[3] AN22HDLLX0
XU335 VSS VDD_1V8 n204 n355 alu_out[3] n320 R1[3] AN22HDLLX0
XU334 reg_write_data[2] VSS n193 n192 VDD_1V8 n194 NA3HDLLX0
XU333 VSS VDD_1V8 n192 n354 pc[2] n191 n190 AN211HDLLX0
XU332 VSS n190 VDD_1V8 s_reg_w[3] s_reg_w[0] rd[2] n209 OA211HDLLX0
XU331 n188 VSS n357 n189 VDD_1V8 n191 AN21HDLLX0
XU330 VSS VDD_1V8 n189 n209 D_pop_mbc[2] n187 R1[2] AN22HDLLX0
XU328 VSS VDD_1V8 n193 n240 imm_out[2] n358 d_read[2] AN22HDLLX0
XU327 VSS VDD_1V8 n194 n360 alu_out[2] n320 CSR[2] AN22HDLLX0
XU326 n183 n182 VSS VDD_1V8 n184 reg_write_data[1] n185 NA4HDLLX0
XU325 n182 VSS VDD_1V8 n181 n357 n357 D_pop_mbc[61] n187 AN32HDLLX0
XU324 n195 VSS n206 n180 VDD_1V8 n181 AN21HDLLX0
XU323 VSS VDD_1V8 n180 pc[1] n209 rd[1] n179 AN22HDLLX0
XU322 VSS VDD_1V8 n183 n359 d_read[1] n240 D_pop_mbc[1] AN22HDLLX0
XU318 VSS VDD_1V8 n184 n360 imm_out[1] n358 CSR[1] AN22HDLLX0
XU315 VSS VDD_1V8 n185 n355 alu_out[1] n320 R1[1] AN22HDLLX0
XU313 VSS s_reg_w[0] n206 VDD_1V8 n178 NA2HDLLX0
XU310 VSS reg_write_data[0] VDD_1V8 n174 n186 n175 ON21HDLLX0
XU309 n174 n172 n173 VSS VDD_1V8 n206 n171 AN31HDLLX0
XU308 n171 VSS VDD_1V8 n188 INHDLLX0
XU307 VSS s_reg_w[3] n187 VDD_1V8 n188 NA2HDLLX0
XU306 n187 VSS VDD_1V8 n195 INHDLLX0
XU305 VSS n172 VDD_1V8 n357 n169 n170 ON21HDLLX0
XU303 n169 VSS VDD_1V8 zero_alu n196 n177 d_read[0] ON22HDLLX0
XU302 n170 VSS VDD_1V8 alu_out[0] n373 n195 D_pop_mbc[60] ON22HDLLX0
XU301 VSS n173 VDD_1V8 s_reg_w[0] n167 n168 ON21HDLLX0
XU300 n167 VSS VDD_1V8 imm_out[0] n196 n177 CSR[0] ON22HDLLX0
XU299 n196 VSS s_reg_w[2] VDD_1V8 n179 NA2I1HDLLX0
XU298 VSS s_reg_w[2] s_reg_w[1] VDD_1V8 n177 NA2HDLLX0
XU297 n168 VSS VDD_1V8 R1[0] n373 n195 D_pop_mbc[0] ON22HDLLX0
XU295 VSS s_reg_w[2] n179 VDD_1V8 n195 NA2HDLLX0
XU294 n186 VSS VDD_1V8 n208 INHDLLX0
XU293 VSS n208 n206 s_reg_w[0] VDD_1V8 NO2HDLLX0
XU291 VSS VDD_1V8 n175 pc[0] n209 rd[0] n179 AN22HDLLX0
XU290 VSS n209 s_reg_w[2] n179 VDD_1V8 NO2HDLLX0
XU289 n179 VSS VDD_1V8 s_reg_w[1] INHDLLX0
XU288 VSS alu_b[31] n166 n368 d_write[31] CSR[31] VDD_1V8 imm_out[31] n375 AO222HDLLX0
XU287 VSS alu_b[30] n166 n368 d_write[30] CSR[30] VDD_1V8 imm_out[30] n375 AO222HDLLX0
XU286 VSS alu_b[29] n166 n368 d_write[29] CSR[29] VDD_1V8 imm_out[29] n375 AO222HDLLX0
XU285 VSS alu_b[28] n166 n368 d_write[28] CSR[28] VDD_1V8 imm_out[28] n375 AO222HDLLX0
XU284 VSS alu_b[27] n166 n368 d_write[27] CSR[27] VDD_1V8 imm_out[27] n375 AO222HDLLX0
XU283 VSS alu_b[26] n166 n368 d_write[26] CSR[26] VDD_1V8 imm_out[26] n375 AO222HDLLX0
XU282 VSS alu_b[25] n166 n368 d_write[25] CSR[25] VDD_1V8 imm_out[25] n375 AO222HDLLX0
XU281 VSS alu_b[24] n166 n368 d_write[24] CSR[24] VDD_1V8 imm_out[24] n375 AO222HDLLX0
XU280 VSS alu_b[23] n166 n368 d_write[23] CSR[23] VDD_1V8 imm_out[23] n375 AO222HDLLX0
XU279 VSS alu_b[22] n166 n368 d_write[22] CSR[22] VDD_1V8 imm_out[22] n375 AO222HDLLX0
XU278 VSS alu_b[21] n166 n368 d_write[21] CSR[21] VDD_1V8 imm_out[21] n375 AO222HDLLX0
XU277 VSS alu_b[20] n166 n368 d_write[20] CSR[20] VDD_1V8 imm_out[20] n375 AO222HDLLX0
XU482 VSS VDD_1V8 n324 n359 d_read[25] n240 D_pop_mbc[25] AN22HDLLX0
XU481 VSS VDD_1V8 n325 n358 R1[25] n355 imm_out[25] AN22HDLLX0
XU480 VSS VDD_1V8 n326 n283 alu_out[25] n320 D_pop_mbc[51] AN22HDLLX0
XU478 n317 n316 VSS VDD_1V8 n318 reg_write_data[24] n319 NA4HDLLX0
XU477 pc[24] VSS n315 n354 VDD_1V8 n316 AN21HDLLX0
XU476 n360 VSS VDD_1V8 n353 CSR[24] imm_out[4] n315 AO22HDLLX1
XU475 VSS VDD_1V8 n317 n359 d_read[24] n240 D_pop_mbc[24] AN22HDLLX0
XU474 VSS VDD_1V8 n318 n358 R1[24] n355 imm_out[24] AN22HDLLX0
XU473 VSS VDD_1V8 n319 n283 alu_out[24] n320 D_pop_mbc[50] AN22HDLLX0
XU472 n311 n310 VSS VDD_1V8 n312 reg_write_data[23] n313 NA4HDLLX0
XU471 pc[23] VSS n309 n354 VDD_1V8 n310 AN21HDLLX0
XU470 n360 VSS VDD_1V8 imm_out[3] CSR[23] n353 n309 AO22HDLLX1
XU469 VSS VDD_1V8 n311 n359 d_read[23] n240 D_pop_mbc[23] AN22HDLLX0
XU468 VSS VDD_1V8 n312 n358 R1[23] n355 imm_out[23] AN22HDLLX0
XU467 VSS VDD_1V8 n313 n283 alu_out[23] n320 D_pop_mbc[49] AN22HDLLX0
XU466 n306 n305 VSS VDD_1V8 n307 reg_write_data[22] n308 NA4HDLLX0
XU465 pc[22] VSS n304 n354 VDD_1V8 n305 AN21HDLLX0
XU464 n360 VSS VDD_1V8 imm_out[2] CSR[22] n353 n304 AO22HDLLX1
XU463 VSS VDD_1V8 n306 n359 d_read[22] n240 D_pop_mbc[22] AN22HDLLX0
XU462 VSS VDD_1V8 n307 n358 R1[22] n355 imm_out[22] AN22HDLLX0
XU461 VSS VDD_1V8 n308 n283 alu_out[22] n320 D_pop_mbc[48] AN22HDLLX0
XU460 n301 n300 VSS VDD_1V8 n302 reg_write_data[21] n303 NA4HDLLX0
XU459 pc[21] VSS n299 n354 VDD_1V8 n300 AN21HDLLX0
XU458 imm_out[1] VSS VDD_1V8 n360 n353 CSR[21] n299 AO22HDLLX1
XU457 VSS VDD_1V8 n301 n359 d_read[21] n240 D_pop_mbc[21] AN22HDLLX0
XU456 VSS VDD_1V8 n302 n358 R1[21] n355 imm_out[21] AN22HDLLX0
XU455 VSS VDD_1V8 n303 n283 alu_out[21] n320 D_pop_mbc[47] AN22HDLLX0
XU454 n296 n295 VSS VDD_1V8 n297 reg_write_data[20] n298 NA4HDLLX0
XU453 pc[20] VSS n294 n354 VDD_1V8 n295 AN21HDLLX0
XU452 imm_out[0] VSS VDD_1V8 n360 n353 CSR[20] n294 AO22HDLLX1
XU451 VSS VDD_1V8 n296 n359 d_read[20] n240 D_pop_mbc[20] AN22HDLLX0
XU450 VSS VDD_1V8 n297 n358 R1[20] n355 imm_out[20] AN22HDLLX0
XU449 VSS VDD_1V8 n298 n283 alu_out[20] n320 D_pop_mbc[46] AN22HDLLX0
XU448 n291 n290 VSS VDD_1V8 n292 reg_write_data[19] n293 NA4HDLLX0
XU447 pc[19] VSS n289 n354 VDD_1V8 n290 AN21HDLLX0
XU446 n360 VSS VDD_1V8 n353 CSR[19] rs2[4] n289 AO22HDLLX1
XU445 VSS VDD_1V8 n291 n359 d_read[19] n240 D_pop_mbc[19] AN22HDLLX0
XU444 VSS VDD_1V8 n292 n358 R1[19] n355 imm_out[19] AN22HDLLX0
XU443 VSS VDD_1V8 n293 n283 alu_out[19] n320 D_pop_mbc[45] AN22HDLLX0
XU442 n286 n285 VSS VDD_1V8 n287 reg_write_data[18] n288 NA4HDLLX0
XU441 pc[18] VSS n284 n354 VDD_1V8 n285 AN21HDLLX0
XU440 n360 VSS VDD_1V8 n353 CSR[18] rs2[3] n284 AO22HDLLX1
XU439 VSS VDD_1V8 n286 n359 d_read[18] n240 D_pop_mbc[18] AN22HDLLX0
XU438 VSS VDD_1V8 n287 n358 R1[18] n355 imm_out[18] AN22HDLLX0
XU437 VSS VDD_1V8 n288 n283 alu_out[18] n320 D_pop_mbc[44] AN22HDLLX0
XU435 n280 n279 VSS VDD_1V8 n281 reg_write_data[17] n282 NA4HDLLX0
XU434 pc[17] VSS n278 n354 VDD_1V8 n279 AN21HDLLX0
XU433 n360 VSS VDD_1V8 n353 CSR[17] rs2[2] n278 AO22HDLLX1
XU432 VSS VDD_1V8 n280 n359 d_read[17] n240 D_pop_mbc[17] AN22HDLLX0
XU431 VSS VDD_1V8 n281 n358 R1[17] n355 imm_out[17] AN22HDLLX0
XU430 VSS VDD_1V8 n282 n283 alu_out[17] n320 D_pop_mbc[43] AN22HDLLX0
XU429 n274 n273 VSS VDD_1V8 n275 reg_write_data[16] n276 NA4HDLLX0
XU428 pc[16] VSS n272 n354 VDD_1V8 n273 AN21HDLLX0
XU427 n360 VSS VDD_1V8 n353 CSR[16] rs2[1] n272 AO22HDLLX1
XU426 VSS VDD_1V8 n274 n359 d_read[16] n240 D_pop_mbc[16] AN22HDLLX0
XU425 VSS VDD_1V8 n275 n358 R1[16] n355 imm_out[16] AN22HDLLX0
XU424 VSS VDD_1V8 n276 n283 alu_out[16] n320 D_pop_mbc[42] AN22HDLLX0
XU423 n269 n268 VSS VDD_1V8 n270 reg_write_data[15] n271 NA4HDLLX0
XU422 pc[15] VSS n267 n354 VDD_1V8 n268 AN21HDLLX0
XU421 n360 VSS VDD_1V8 n353 CSR[15] rs2[0] n267 AO22HDLLX1
XU420 VSS VDD_1V8 n269 n359 d_read[15] n240 D_pop_mbc[15] AN22HDLLX0
XU419 VSS VDD_1V8 n270 n358 R1[15] n355 imm_out[15] AN22HDLLX0
XU417 VSS VDD_1V8 n271 n283 alu_out[15] n320 D_pop_mbc[41] AN22HDLLX0
XU416 n264 n263 VSS VDD_1V8 n265 reg_write_data[14] n266 NA4HDLLX0
XU415 pc[14] VSS n262 n354 VDD_1V8 n263 AN21HDLLX0
XU414 n360 VSS VDD_1V8 n353 CSR[14] rs1[4] n262 AO22HDLLX1
XU413 VSS VDD_1V8 n264 n359 d_read[14] n240 D_pop_mbc[14] AN22HDLLX0
XU411 VSS VDD_1V8 n265 n358 R1[14] n355 imm_out[14] AN22HDLLX0
XU410 VSS VDD_1V8 n266 n283 alu_out[14] n320 D_pop_mbc[40] AN22HDLLX0
XU409 n259 n258 VSS VDD_1V8 n260 reg_write_data[13] n261 NA4HDLLX0
XU408 pc[13] VSS n257 n354 VDD_1V8 n258 AN21HDLLX0
XU407 n360 VSS VDD_1V8 n353 CSR[13] rs1[3] n257 AO22HDLLX1
XU406 VSS VDD_1V8 n259 n359 d_read[13] n240 D_pop_mbc[13] AN22HDLLX0
XU405 VSS VDD_1V8 n260 n358 R1[13] n355 imm_out[13] AN22HDLLX0
XU404 VSS VDD_1V8 n261 n283 alu_out[13] n320 D_pop_mbc[39] AN22HDLLX0
XU402 n254 n253 VSS VDD_1V8 n255 reg_write_data[12] n256 NA4HDLLX0
XU401 pc[12] VSS n252 n354 VDD_1V8 n253 AN21HDLLX0
XU400 n360 VSS VDD_1V8 n353 CSR[12] rs1[2] n252 AO22HDLLX1
XU399 VSS VDD_1V8 n254 n359 d_read[12] n240 D_pop_mbc[12] AN22HDLLX0
XU398 VSS VDD_1V8 n255 n358 R1[12] n355 imm_out[12] AN22HDLLX0
XU397 VSS VDD_1V8 n256 n283 alu_out[12] n320 D_pop_mbc[38] AN22HDLLX0
XU396 n248 n247 VSS VDD_1V8 n249 reg_write_data[11] n250 NA4HDLLX0
XU395 pc[11] VSS n246 n354 VDD_1V8 n247 AN21HDLLX0
XU394 n360 VSS VDD_1V8 n353 CSR[11] rs1[1] n246 AO22HDLLX1
XU393 VSS VDD_1V8 n248 n359 d_read[11] n240 D_pop_mbc[11] AN22HDLLX0
XU392 VSS VDD_1V8 n249 n358 R1[11] n355 imm_out[11] AN22HDLLX0
XU391 VSS VDD_1V8 n250 n283 alu_out[11] n320 D_pop_mbc[37] AN22HDLLX0
XU390 n243 n242 VSS VDD_1V8 n244 reg_write_data[10] n245 NA4HDLLX0
XU389 pc[10] VSS n241 n354 VDD_1V8 n242 AN21HDLLX0
XU388 n360 VSS VDD_1V8 n353 CSR[10] rs1[0] n241 AO22HDLLX1
XU387 VSS VDD_1V8 n243 n359 d_read[10] n240 D_pop_mbc[10] AN22HDLLX0
XU385 VSS VDD_1V8 n244 n358 R1[10] n355 imm_out[10] AN22HDLLX0
XU384 VSS VDD_1V8 n245 n283 alu_out[10] n320 D_pop_mbc[36] AN22HDLLX0
XU129 VSS s_alu[1] s_alu[0] VDD_1V8 n389 s_alu[2] NA3I2HDLLX0
XU10 alu_b[0] VSS VDD_1V8 n21 n18 n18 n17 n19 AN32HDLLX0
XU17 VSS n23 n22 VDD_1V8 alu_b[2] NA2HDLLX0
XU98 n73 VSS n75 n74 VDD_1V8 n76 n92 NO4I3HDLLX0
XU225 VSS VDD_1V8 n161 s_pc1[0] s_pc1[1] NO2I1HDLLX1
XU224 VSS VDD_1V8 n162 s_pc1[1] s_pc1[0] NO2I1HDLLX1
XU15 VSS n166 s_alu[0] n21 VDD_1V8 NO2HDLLX1
XU29 VSS n156 s_pc2[1] s_pc2[0] VDD_1V8 NO2HDLLX2
XU338 n195 n283 VSS VDD_1V8 s_reg_w[0] s_reg_w[3] NO3HDLLX2
XU319 n177 n240 VSS VDD_1V8 s_reg_w[0] s_reg_w[3] NO3HDLLX2
XU311 n373 n320 VSS VDD_1V8 s_reg_w[0] s_reg_w[3] NO3HDLLX2
Xcsr_id_reg_0_ csr_id[0] VSS VDD_1V8 n2 N39 DLHQHDLLX0
Xcsr_id_reg_1_ csr_id[1] VSS VDD_1V8 N37 N39 DLHQHDLLX0
Xcsr_id_reg_2_ csr_id[2] VSS VDD_1V8 N36 N39 DLHQHDLLX0
Xcsr_id_reg_3_ csr_id[3] VSS VDD_1V8 n1 N39 DLHQHDLLX0
XU28 VSS VDD_1V8 n154 s_pc2[1] s_pc2[0] NO2I1HDLLX4
XU27 VSS VDD_1V8 n155 s_pc2[0] s_pc2[1] NO2I1HDLLX4
XU226 VSS n163 n161 n162 VDD_1V8 NO2HDLLX1
XU521 VSS n3 n11 rst_tmr VDD_1V8 NO2HDLLX1
XU340 n196 n353 VSS VDD_1V8 n357 n206 NO3HDLLX2
XU321 VSS n359 n195 n178 VDD_1V8 NO2HDLLX1
XU317 VSS n360 n177 n178 VDD_1V8 NO2HDLLX1
XU316 VSS n358 n196 n178 VDD_1V8 NO2HDLLX1
XU329 VSS n354 n196 n186 VDD_1V8 NO2HDLLX1
XU314 VSS n355 n373 n178 VDD_1V8 NO2HDLLX1
XU524 s_csr[2] n366 VSS VDD_1V8 n1 csr[3] NO3I2HDLLX0
XU523 s_csr[2] VSS s_csr[1] n365 VDD_1V8 csr[0] n2 AO211HDLLX0
XU522 n365 VSS VDD_1V8 s_csr[0] INHDLLX0
XU520 n362 n361 VSS VDD_1V8 n363 reg_write_data[31] n364 NA4HDLLX0
XU519 VSS VDD_1V8 n361 n359 CSR[31] n360 D_pop_mbc[31] AN22HDLLX0
XU518 VSS VDD_1V8 n362 n240 imm_out[31] n358 d_read[31] AN22HDLLX0
XU517 VSS VDD_1V8 n363 n355 alu_out[31] n320 R1[31] AN22HDLLX0
XU516 VSS VDD_1V8 n364 n353 pc[31] n354 imm_out[11] AN22HDLLX0
XU515 n350 n349 VSS VDD_1V8 n351 reg_write_data[30] n352 NA4HDLLX0
XU514 pc[30] VSS n348 n354 VDD_1V8 n349 AN21HDLLX0
XU513 n360 VSS VDD_1V8 n353 CSR[30] imm_out[10] n348 AO22HDLLX1
XU512 VSS VDD_1V8 n350 n359 d_read[30] n240 D_pop_mbc[30] AN22HDLLX0
XU511 VSS VDD_1V8 n351 n358 R1[30] n355 imm_out[30] AN22HDLLX0
XU510 VSS VDD_1V8 n352 n283 alu_out[30] n320 D_pop_mbc[56] AN22HDLLX0
XU509 n344 n343 VSS VDD_1V8 n345 reg_write_data[29] n346 NA4HDLLX0
XU508 pc[29] VSS n342 n354 VDD_1V8 n343 AN21HDLLX0
XU507 n360 VSS VDD_1V8 n353 CSR[29] imm_out[9] n342 AO22HDLLX1
XU506 VSS VDD_1V8 n344 n359 d_read[29] n240 D_pop_mbc[29] AN22HDLLX0
XU505 VSS VDD_1V8 n345 n358 R1[29] n355 imm_out[29] AN22HDLLX0
XU504 VSS VDD_1V8 n346 n283 alu_out[29] n320 D_pop_mbc[55] AN22HDLLX0
XU503 n339 n338 VSS VDD_1V8 n340 reg_write_data[28] n341 NA4HDLLX0
XU502 pc[28] VSS n337 n354 VDD_1V8 n338 AN21HDLLX0
XU501 n360 VSS VDD_1V8 n353 CSR[28] imm_out[8] n337 AO22HDLLX1
XU500 VSS VDD_1V8 n339 n359 d_read[28] n240 D_pop_mbc[28] AN22HDLLX0
XU499 VSS VDD_1V8 n340 n358 R1[28] n355 imm_out[28] AN22HDLLX0
XU498 VSS VDD_1V8 n341 n283 alu_out[28] n320 D_pop_mbc[54] AN22HDLLX0
XU497 n334 n333 VSS VDD_1V8 n335 reg_write_data[27] n336 NA4HDLLX0
XU496 pc[27] VSS n332 n354 VDD_1V8 n333 AN21HDLLX0
XU495 n360 VSS VDD_1V8 n353 CSR[27] imm_out[7] n332 AO22HDLLX1
XU494 VSS VDD_1V8 n334 n359 d_read[27] n240 D_pop_mbc[27] AN22HDLLX0
XU493 VSS VDD_1V8 n335 n358 R1[27] n355 imm_out[27] AN22HDLLX0
XU492 VSS VDD_1V8 n336 n283 alu_out[27] n320 D_pop_mbc[53] AN22HDLLX0
XU491 n329 n328 VSS VDD_1V8 n330 reg_write_data[26] n331 NA4HDLLX0
XU490 pc[26] VSS n327 n354 VDD_1V8 n328 AN21HDLLX0
XU489 n360 VSS VDD_1V8 n353 CSR[26] imm_out[6] n327 AO22HDLLX1
XU488 VSS VDD_1V8 n329 n359 d_read[26] n240 D_pop_mbc[26] AN22HDLLX0
XU487 VSS VDD_1V8 n330 n358 R1[26] n355 imm_out[26] AN22HDLLX0
XU486 VSS VDD_1V8 n331 n283 alu_out[26] n320 D_pop_mbc[52] AN22HDLLX0
XU485 n324 n323 VSS VDD_1V8 n325 reg_write_data[25] n326 NA4HDLLX0
XU484 pc[25] VSS n322 n354 VDD_1V8 n323 AN21HDLLX0
XU483 n360 VSS VDD_1V8 n353 CSR[25] imm_out[5] n322 AO22HDLLX1
Xplace4 VSS VDD_1V8 n5 reset BUHDLLX12
Xplace10 VSS VDD_1V8 n11 n4 BUHDLLX1
Xplace15 VSS VDD_1V8 n54 n5 INHDLLX4
Xplace19 VSS VDD_1V8 n4 n165 INHDLLX6
Xplace23 n206 VSS VDD_1V8 s_reg_w[3] INHDLLX0
Xplace26 n277 VSS VDD_1V8 inv_r1 BUHDLLX2
Xplace31 n357 VSS VDD_1V8 s_reg_w[0] INHDLLX0
Xplace37 n373 VSS VDD_1V8 n209 INHDLLX0
Xplace5 n6 VSS VDD_1V8 n5 INHDLLX1
Xplace21 n197 VSS VDD_1V8 n5 INHDLLX1
Xplace20 n176 VSS VDD_1V8 n5 INHDLLX1
Xplace18 n164 VSS VDD_1V8 n4 INHDLLX1
Xplace17 n159 VSS VDD_1V8 n5 INHDLLX1
Xplace16 n158 VSS VDD_1V8 n5 INHDLLX0
Xplace14 n15 VSS VDD_1V8 n5 INHDLLX1
Xplace13 n14 VSS VDD_1V8 n4 INHDLLX1
Xplace12 n13 VSS VDD_1V8 n4 INHDLLX1
Xplace9 n10 VSS VDD_1V8 n4 INHDLLX1
Xplace8 n9 VSS VDD_1V8 n5 INHDLLX1
Xplace7 n8 VSS VDD_1V8 n5 INHDLLX1
Xplace6 n7 VSS VDD_1V8 n5 INHDLLX1
Xplace11 n12 VSS VDD_1V8 n11 INHDLLX0
Xplace25 n251 VSS VDD_1V8 s_addrs INHDLLX0
Xplace3 VSS VDD_1V8 n4 reset BUHDLLX1
XU85 VSS n53 comparation[5] n51 n52 VDD_1V8 CAGHDLLX0
XU84 VSS n51 comparation[4] n49 n50 VDD_1V8 CAGHDLLX0
XU83 VSS n49 comparation[3] n47 n48 VDD_1V8 CAGHDLLX0
XU82 VSS n47 comparation[2] n45 n46 VDD_1V8 CAGHDLLX0
Xplace29 n347 VSS VDD_1V8 n277 INHDLLX0
Xplace33 n368 VSS VDD_1V8 n389 INHDLLX0
Xplace27 n314 VSS VDD_1V8 n277 INHDLLX0
Xplace24 n375 VSS VDD_1V8 s_alu[2] s_alu[1] s_alu[0] NO3HDLLX1
.ENDS

.SUBCKT topcore_tecriscv clk reset MISO RX_UART maip MOSI SCLK SCS TX_UART full_range_level_shifter[7]
+ full_range_level_shifter[6] full_range_level_shifter[5] full_range_level_shifter[4]
+ full_range_level_shifter[3] full_range_level_shifter[2] full_range_level_shifter[1]
+ full_range_level_shifter[0] IS_Val[31] IS_Val[30] IS_Val[29] IS_Val[28] IS_Val[27]
+ IS_Val[26] IS_Val[25] IS_Val[24] IS_Val[23] IS_Val[22] IS_Val[21] IS_Val[20] IS_Val[19]
+ IS_Val[18] IS_Val[17] IS_Val[16] IS_Val[15] IS_Val[14] IS_Val[13] IS_Val[12] IS_Val[11]
+ IS_Val[10] IS_Val[9] IS_Val[8] IS_Val[7] IS_Val[6] IS_Val[5] IS_Val[4] IS_Val[3]
+ IS_Val[2] IS_Val[1] IS_Val[0] IS_Config[31] IS_Config[30] IS_Config[29] IS_Config[28]
+ IS_Config[27] IS_Config[26] IS_Config[25] IS_Config[24] IS_Config[23] IS_Config[22]
+ IS_Config[21] IS_Config[20] IS_Config[19] IS_Config[18] IS_Config[17] IS_Config[16]
+ IS_Config[15] IS_Config[14] IS_Config[13] IS_Config[12] IS_Config[11] IS_Config[10]
+ IS_Config[9] IS_Config[8] IS_Config[7] IS_Config[6] IS_Config[5] IS_Config[4]
+ IS_Config[3] IS_Config[2] IS_Config[1] IS_Config[0] IS_Trigger[3] IS_Trigger[2]
+ IS_Trigger[1] IS_Trigger[0] Reg_GPIO_en[7] Reg_GPIO_en[6] Reg_GPIO_en[5] Reg_GPIO_en[4]
+ Reg_GPIO_en[3] Reg_GPIO_en[2] Reg_GPIO_en[1] Reg_GPIO_en[0] Reg_GPIO_int[7] Reg_GPIO_int[6]
+ Reg_GPIO_int[5] Reg_GPIO_int[4] Reg_GPIO_int[3] Reg_GPIO_int[2] Reg_GPIO_int[1]
+ Reg_GPIO_int[0] Reg_GPIO_out[7] Reg_GPIO_out[6] Reg_GPIO_out[5] Reg_GPIO_out[4]
+ Reg_GPIO_out[3] Reg_GPIO_out[2] Reg_GPIO_out[1] Reg_GPIO_out[0] VSS VDD_1V8SRAM
+ VDD_1V8
XDHC_PD_CORE clk n7 VSS VDD_1V8 DH_top_riscv_soc_PD_CORE
XTOP clk reset push_spi push_uart pop_spi pop_uart VSS VSS VSS VSS D_push_spi[60]
+ D_push_spi[59] D_push_spi[58] D_push_spi[57] D_push_spi[56] D_push_spi[55] D_push_spi[54]
+ D_push_spi[53] D_push_spi[52] D_push_spi[51] D_push_spi[50] D_push_spi[49] D_push_spi[48]
+ D_push_spi[47] D_push_spi[46] D_push_spi[45] D_push_spi[44] D_push_spi[43] D_push_spi[42]
+ D_push_spi[41] D_push_spi[40] D_push_spi[39] D_push_spi[38] D_push_spi[37] D_push_spi[36]
+ D_push_spi[35] D_push_spi[34] D_push_spi[33] D_push_spi[32] D_push_spi[31] D_push_spi[30]
+ D_push_spi[29] D_push_spi[28] D_push_spi[27] D_push_spi[26] D_push_spi[25] D_push_spi[24]
+ D_push_spi[23] D_push_spi[22] D_push_spi[21] D_push_spi[20] D_push_spi[19] D_push_spi[18]
+ D_push_spi[17] D_push_spi[16] D_push_spi[15] D_push_spi[14] D_push_spi[13] D_push_spi[12]
+ D_push_spi[11] D_push_spi[10] D_push_spi[9] D_push_spi[8] D_push_spi[7] D_push_spi[6]
+ D_push_spi[5] D_push_spi[4] D_push_spi[3] D_push_spi[2] D_push_spi[1] D_push_spi[0]
+ VSS D_push_uart[63] D_push_uart[62] D_push_uart[61] D_push_uart[60] D_push_uart[59]
+ D_push_uart[58] D_push_uart[57] D_push_uart[56] D_push_uart[55] D_push_uart[54]
+ D_push_uart[53] D_push_uart[52] D_push_uart[51] D_push_uart[50] D_push_uart[49]
+ D_push_uart[48] D_push_uart[47] D_push_uart[46] D_push_uart[45] D_push_uart[44]
+ D_push_uart[43] D_push_uart[42] D_push_uart[41] D_push_uart[40] D_push_uart[39]
+ D_push_uart[38] D_push_uart[37] D_push_uart[36] D_push_uart[35] D_push_uart[34]
+ D_push_uart[33] D_push_uart[32] D_push_uart[31] D_push_uart[30] D_push_uart[29]
+ D_push_uart[28] D_push_uart[27] D_push_uart[26] D_push_uart[25] D_push_uart[24]
+ D_push_uart[23] D_push_uart[22] D_push_uart[21] D_push_uart[20] D_push_uart[19]
+ D_push_uart[18] D_push_uart[17] D_push_uart[16] D_push_uart[15] D_push_uart[14]
+ D_push_uart[13] D_push_uart[12] D_push_uart[11] D_push_uart[10] D_push_uart[9]
+ D_push_uart[8] D_push_uart[7] D_push_uart[6] D_push_uart[5] D_push_uart[4] D_push_uart[3]
+ D_push_uart[2] D_push_uart[1] D_push_uart[0] maip D_pop_spi[64] D_pop_spi[63]
+ D_pop_spi[62] SYNOPSYS_UNCONNECTED_1 SYNOPSYS_UNCONNECTED_2 D_pop_spi[59] D_pop_spi[58]
+ D_pop_spi[57] SYNOPSYS_UNCONNECTED_3 SYNOPSYS_UNCONNECTED_4 D_pop_spi[54] D_pop_spi[53]
+ D_pop_spi[52] D_pop_spi[51] D_pop_spi[50] D_pop_spi[49] D_pop_spi[48] D_pop_spi[47]
+ D_pop_spi[46] D_pop_spi[45] D_pop_spi[44] D_pop_spi[43] D_pop_spi[42] D_pop_spi[41]
+ D_pop_spi[40] D_pop_spi[39] D_pop_spi[38] D_pop_spi[37] D_pop_spi[36] D_pop_spi[35]
+ D_pop_spi[34] D_pop_spi[33] D_pop_spi[32] D_pop_spi[31] D_pop_spi[30] D_pop_spi[29]
+ D_pop_spi[28] D_pop_spi[27] D_pop_spi[26] D_pop_spi[25] D_pop_spi[24] D_pop_spi[23]
+ D_pop_spi[22] D_pop_spi[21] D_pop_spi[20] D_pop_spi[19] D_pop_spi[18] D_pop_spi[17]
+ D_pop_spi[16] D_pop_spi[15] D_pop_spi[14] D_pop_spi[13] D_pop_spi[12] D_pop_spi[11]
+ D_pop_spi[10] D_pop_spi[9] D_pop_spi[8] D_pop_spi[7] D_pop_spi[6] D_pop_spi[5]
+ D_pop_spi[4] D_pop_spi[3] D_pop_spi[2] D_pop_spi[1] D_pop_spi[0] SYNOPSYS_UNCONNECTED_5
+ D_pop_uart[63] D_pop_uart[62] D_pop_uart[61] D_pop_uart[60] D_pop_uart[59] D_pop_uart[58]
+ D_pop_uart[57] D_pop_uart[56] D_pop_uart[55] D_pop_uart[54] D_pop_uart[53] D_pop_uart[52]
+ D_pop_uart[51] D_pop_uart[50] D_pop_uart[49] D_pop_uart[48] D_pop_uart[47] D_pop_uart[46]
+ D_pop_uart[45] D_pop_uart[44] D_pop_uart[43] D_pop_uart[42] D_pop_uart[41] D_pop_uart[40]
+ D_pop_uart[39] D_pop_uart[38] D_pop_uart[37] D_pop_uart[36] D_pop_uart[35] D_pop_uart[34]
+ D_pop_uart[33] D_pop_uart[32] D_pop_uart[31] D_pop_uart[30] D_pop_uart[29] D_pop_uart[28]
+ D_pop_uart[27] D_pop_uart[26] D_pop_uart[25] D_pop_uart[24] D_pop_uart[23] D_pop_uart[22]
+ D_pop_uart[21] D_pop_uart[20] D_pop_uart[19] D_pop_uart[18] D_pop_uart[17] D_pop_uart[16]
+ D_pop_uart[15] D_pop_uart[14] D_pop_uart[13] D_pop_uart[12] D_pop_uart[11] D_pop_uart[10]
+ D_pop_uart[9] D_pop_uart[8] D_pop_uart[7] D_pop_uart[6] D_pop_uart[5] D_pop_uart[4]
+ D_pop_uart[3] D_pop_uart[2] D_pop_uart[1] D_pop_uart[0] pndng_spi pndng_uart full_range_level_shifter[7]
+ full_range_level_shifter[6] full_range_level_shifter[5] full_range_level_shifter[4]
+ full_range_level_shifter[3] full_range_level_shifter[2] full_range_level_shifter[1]
+ full_range_level_shifter[0] IS_Val[31] IS_Val[30] IS_Val[29] IS_Val[28] IS_Val[27]
+ IS_Val[26] IS_Val[25] IS_Val[24] IS_Val[23] IS_Val[22] IS_Val[21] IS_Val[20] IS_Val[19]
+ IS_Val[18] IS_Val[17] IS_Val[16] IS_Val[15] IS_Val[14] IS_Val[13] IS_Val[12] IS_Val[11]
+ IS_Val[10] IS_Val[9] IS_Val[8] IS_Val[7] IS_Val[6] IS_Val[5] IS_Val[4] IS_Val[3]
+ IS_Val[2] IS_Val[1] IS_Val[0] SYNOPSYS_UNCONNECTED_6 SYNOPSYS_UNCONNECTED_7 SYNOPSYS_UNCONNECTED_8
+ SYNOPSYS_UNCONNECTED_9 SYNOPSYS_UNCONNECTED_10 SYNOPSYS_UNCONNECTED_11 SYNOPSYS_UNCONNECTED_12
+ SYNOPSYS_UNCONNECTED_13 SYNOPSYS_UNCONNECTED_14 SYNOPSYS_UNCONNECTED_15 SYNOPSYS_UNCONNECTED_16
+ SYNOPSYS_UNCONNECTED_17 SYNOPSYS_UNCONNECTED_18 SYNOPSYS_UNCONNECTED_19 SYNOPSYS_UNCONNECTED_20
+ SYNOPSYS_UNCONNECTED_21 SYNOPSYS_UNCONNECTED_22 SYNOPSYS_UNCONNECTED_23 SYNOPSYS_UNCONNECTED_24
+ SYNOPSYS_UNCONNECTED_25 SYNOPSYS_UNCONNECTED_26 SYNOPSYS_UNCONNECTED_27 SYNOPSYS_UNCONNECTED_28
+ SYNOPSYS_UNCONNECTED_29 SYNOPSYS_UNCONNECTED_30 SYNOPSYS_UNCONNECTED_31 SYNOPSYS_UNCONNECTED_32
+ SYNOPSYS_UNCONNECTED_33 SYNOPSYS_UNCONNECTED_34 SYNOPSYS_UNCONNECTED_35 SYNOPSYS_UNCONNECTED_36
+ SYNOPSYS_UNCONNECTED_37 IS_Trigger[3] IS_Trigger[2] IS_Trigger[1] IS_Trigger[0]
+ Reg_GPIO_en[7] Reg_GPIO_en[6] Reg_GPIO_en[5] Reg_GPIO_en[4] Reg_GPIO_en[3] Reg_GPIO_en[2]
+ Reg_GPIO_en[1] Reg_GPIO_en[0] Reg_GPIO_int[7] Reg_GPIO_int[6] Reg_GPIO_int[5]
+ Reg_GPIO_int[4] Reg_GPIO_int[3] Reg_GPIO_int[2] Reg_GPIO_int[1] Reg_GPIO_int[0]
+ Reg_GPIO_out[7] Reg_GPIO_out[6] Reg_GPIO_out[5] Reg_GPIO_out[4] Reg_GPIO_out[3]
+ Reg_GPIO_out[2] Reg_GPIO_out[1] Reg_GPIO_out[0] VSS VDD_1V8SRAM VDD_1V8 top_CPU_riscv
XSPI n7 reset pndng_spi D_pop_spi[64] D_pop_spi[63] D_pop_spi[62] VSS VSS D_pop_spi[59]
+ D_pop_spi[58] D_pop_spi[57] VSS VSS D_pop_spi[54] D_pop_spi[53] D_pop_spi[52]
+ D_pop_spi[51] D_pop_spi[50] D_pop_spi[49] D_pop_spi[48] D_pop_spi[47] D_pop_spi[46]
+ D_pop_spi[45] D_pop_spi[44] D_pop_spi[43] D_pop_spi[42] D_pop_spi[41] D_pop_spi[40]
+ D_pop_spi[39] D_pop_spi[38] D_pop_spi[37] D_pop_spi[36] D_pop_spi[35] D_pop_spi[34]
+ D_pop_spi[33] D_pop_spi[32] D_pop_spi[31] D_pop_spi[30] D_pop_spi[29] D_pop_spi[28]
+ D_pop_spi[27] D_pop_spi[26] D_pop_spi[25] D_pop_spi[24] D_pop_spi[23] D_pop_spi[22]
+ D_pop_spi[21] D_pop_spi[20] D_pop_spi[19] D_pop_spi[18] D_pop_spi[17] D_pop_spi[16]
+ D_pop_spi[15] D_pop_spi[14] D_pop_spi[13] D_pop_spi[12] D_pop_spi[11] D_pop_spi[10]
+ D_pop_spi[9] D_pop_spi[8] D_pop_spi[7] D_pop_spi[6] D_pop_spi[5] D_pop_spi[4]
+ D_pop_spi[3] D_pop_spi[2] D_pop_spi[1] D_pop_spi[0] MISO pop_spi SYNOPSYS_UNCONNECTED_38
+ SYNOPSYS_UNCONNECTED_39 SYNOPSYS_UNCONNECTED_40 SYNOPSYS_UNCONNECTED_41 D_push_spi[60]
+ D_push_spi[59] D_push_spi[58] D_push_spi[57] D_push_spi[56] D_push_spi[55] D_push_spi[54]
+ D_push_spi[53] D_push_spi[52] D_push_spi[51] D_push_spi[50] D_push_spi[49] D_push_spi[48]
+ D_push_spi[47] D_push_spi[46] D_push_spi[45] D_push_spi[44] D_push_spi[43] D_push_spi[42]
+ D_push_spi[41] D_push_spi[40] D_push_spi[39] D_push_spi[38] D_push_spi[37] D_push_spi[36]
+ D_push_spi[35] D_push_spi[34] D_push_spi[33] D_push_spi[32] D_push_spi[31] D_push_spi[30]
+ D_push_spi[29] D_push_spi[28] D_push_spi[27] D_push_spi[26] D_push_spi[25] D_push_spi[24]
+ D_push_spi[23] D_push_spi[22] D_push_spi[21] D_push_spi[20] D_push_spi[19] D_push_spi[18]
+ D_push_spi[17] D_push_spi[16] D_push_spi[15] D_push_spi[14] D_push_spi[13] D_push_spi[12]
+ D_push_spi[11] D_push_spi[10] D_push_spi[9] D_push_spi[8] D_push_spi[7] D_push_spi[6]
+ D_push_spi[5] D_push_spi[4] D_push_spi[3] D_push_spi[2] D_push_spi[1] D_push_spi[0]
+ push_spi MOSI SCLK SCS VSS VDD_1V8 top_spi
XUART n7 reset TX_UART RX_UART pndng_uart VSS D_pop_uart[63] D_pop_uart[62] D_pop_uart[61]
+ D_pop_uart[60] D_pop_uart[59] D_pop_uart[58] D_pop_uart[57] D_pop_uart[56] D_pop_uart[55]
+ D_pop_uart[54] D_pop_uart[53] D_pop_uart[52] D_pop_uart[51] D_pop_uart[50] D_pop_uart[49]
+ D_pop_uart[48] D_pop_uart[47] D_pop_uart[46] D_pop_uart[45] D_pop_uart[44] D_pop_uart[43]
+ D_pop_uart[42] D_pop_uart[41] D_pop_uart[40] D_pop_uart[39] D_pop_uart[38] D_pop_uart[37]
+ D_pop_uart[36] D_pop_uart[35] D_pop_uart[34] D_pop_uart[33] D_pop_uart[32] D_pop_uart[31]
+ D_pop_uart[30] D_pop_uart[29] D_pop_uart[28] D_pop_uart[27] D_pop_uart[26] D_pop_uart[25]
+ D_pop_uart[24] D_pop_uart[23] D_pop_uart[22] D_pop_uart[21] D_pop_uart[20] D_pop_uart[19]
+ D_pop_uart[18] D_pop_uart[17] D_pop_uart[16] D_pop_uart[15] D_pop_uart[14] D_pop_uart[13]
+ D_pop_uart[12] D_pop_uart[11] D_pop_uart[10] D_pop_uart[9] D_pop_uart[8] D_pop_uart[7]
+ D_pop_uart[6] D_pop_uart[5] D_pop_uart[4] D_pop_uart[3] D_pop_uart[2] D_pop_uart[1]
+ D_pop_uart[0] pop_uart SYNOPSYS_UNCONNECTED_42 D_push_uart[63] D_push_uart[62]
+ D_push_uart[61] D_push_uart[60] D_push_uart[59] D_push_uart[58] D_push_uart[57]
+ D_push_uart[56] D_push_uart[55] D_push_uart[54] D_push_uart[53] D_push_uart[52]
+ D_push_uart[51] D_push_uart[50] D_push_uart[49] D_push_uart[48] D_push_uart[47]
+ D_push_uart[46] D_push_uart[45] D_push_uart[44] D_push_uart[43] D_push_uart[42]
+ D_push_uart[41] D_push_uart[40] D_push_uart[39] D_push_uart[38] D_push_uart[37]
+ D_push_uart[36] D_push_uart[35] D_push_uart[34] D_push_uart[33] D_push_uart[32]
+ D_push_uart[31] D_push_uart[30] D_push_uart[29] D_push_uart[28] D_push_uart[27]
+ D_push_uart[26] D_push_uart[25] D_push_uart[24] D_push_uart[23] D_push_uart[22]
+ D_push_uart[21] D_push_uart[20] D_push_uart[19] D_push_uart[18] D_push_uart[17]
+ D_push_uart[16] D_push_uart[15] D_push_uart[14] D_push_uart[13] D_push_uart[12]
+ D_push_uart[11] D_push_uart[10] D_push_uart[9] D_push_uart[8] D_push_uart[7] D_push_uart[6]
+ D_push_uart[5] D_push_uart[4] D_push_uart[3] D_push_uart[2] D_push_uart[1] D_push_uart[0]
+ push_uart VSS VDD_1V8 uart
Xplace70 IS_Config[0] VSS VDD_1V8 LOGIC0HDLL
Xplace69 IS_Config[1] VSS VDD_1V8 LOGIC0HDLL
Xplace68 IS_Config[31] VSS VDD_1V8 LOGIC0HDLL
Xplace67 IS_Config[30] VSS VDD_1V8 LOGIC0HDLL
Xplace66 IS_Config[29] VSS VDD_1V8 LOGIC0HDLL
Xplace65 IS_Config[28] VSS VDD_1V8 LOGIC0HDLL
Xplace64 IS_Config[27] VSS VDD_1V8 LOGIC0HDLL
Xplace63 IS_Config[26] VSS VDD_1V8 LOGIC0HDLL
Xplace62 IS_Config[25] VSS VDD_1V8 LOGIC0HDLL
Xplace61 IS_Config[24] VSS VDD_1V8 LOGIC0HDLL
Xplace60 IS_Config[23] VSS VDD_1V8 LOGIC0HDLL
Xplace59 IS_Config[22] VSS VDD_1V8 LOGIC0HDLL
Xplace58 IS_Config[21] VSS VDD_1V8 LOGIC0HDLL
Xplace57 IS_Config[20] VSS VDD_1V8 LOGIC0HDLL
Xplace56 IS_Config[19] VSS VDD_1V8 LOGIC0HDLL
Xplace55 IS_Config[18] VSS VDD_1V8 LOGIC0HDLL
Xplace54 IS_Config[17] VSS VDD_1V8 LOGIC0HDLL
Xplace53 IS_Config[16] VSS VDD_1V8 LOGIC0HDLL
Xplace52 IS_Config[15] VSS VDD_1V8 LOGIC0HDLL
Xplace51 IS_Config[14] VSS VDD_1V8 LOGIC0HDLL
Xplace50 IS_Config[13] VSS VDD_1V8 LOGIC0HDLL
Xplace49 IS_Config[12] VSS VDD_1V8 LOGIC0HDLL
Xplace48 IS_Config[11] VSS VDD_1V8 LOGIC0HDLL
Xplace47 IS_Config[10] VSS VDD_1V8 LOGIC0HDLL
Xplace46 IS_Config[9] VSS VDD_1V8 LOGIC0HDLL
Xplace45 IS_Config[8] VSS VDD_1V8 LOGIC0HDLL
Xplace44 IS_Config[7] VSS VDD_1V8 LOGIC0HDLL
Xplace43 IS_Config[6] VSS VDD_1V8 LOGIC0HDLL
Xplace42 IS_Config[5] VSS VDD_1V8 LOGIC0HDLL
Xplace41 IS_Config[4] VSS VDD_1V8 LOGIC0HDLL
Xplace40 IS_Config[3] VSS VDD_1V8 LOGIC0HDLL
Xplace39 IS_Config[2] VSS VDD_1V8 LOGIC0HDLL
.ENDS

.SUBCKT top_riscv_tec_pads clk_pad reset_pad MISO_pad RX_UART_pad maip_pad MOSI_pad
+ SCLK_pad SCS_pad TX_UART_pad gpio_pad[7] gpio_pad[6] gpio_pad[5] gpio_pad[4] gpio_pad[3]
+ gpio_pad[2] gpio_pad[1] gpio_pad[0] full_range_level_shifter[7] full_range_level_shifter[6]
+ full_range_level_shifter[5] full_range_level_shifter[4] full_range_level_shifter[3]
+ full_range_level_shifter[2] full_range_level_shifter[1] full_range_level_shifter[0]
+ IS_Val[31] IS_Val[30] IS_Val[29] IS_Val[28] IS_Val[27] IS_Val[26] IS_Val[25] IS_Val[24]
+ IS_Val[23] IS_Val[22] IS_Val[21] IS_Val[20] IS_Val[19] IS_Val[18] IS_Val[17] IS_Val[16]
+ IS_Val[15] IS_Val[14] IS_Val[13] IS_Val[12] IS_Val[11] IS_Val[10] IS_Val[9] IS_Val[8]
+ IS_Val[7] IS_Val[6] IS_Val[5] IS_Val[4] IS_Val[3] IS_Val[2] IS_Val[1] IS_Val[0]
+ IS_Config[31] IS_Config[30] IS_Config[29] IS_Config[28] IS_Config[27] IS_Config[26]
+ IS_Config[25] IS_Config[24] IS_Config[23] IS_Config[22] IS_Config[21] IS_Config[20]
+ IS_Config[19] IS_Config[18] IS_Config[17] IS_Config[16] IS_Config[15] IS_Config[14]
+ IS_Config[13] IS_Config[12] IS_Config[11] IS_Config[10] IS_Config[9] IS_Config[8]
+ IS_Config[7] IS_Config[6] IS_Config[5] IS_Config[4] IS_Config[3] IS_Config[2]
+ IS_Config[1] IS_Config[0] IS_Trigger[3] IS_Trigger[2] IS_Trigger[1] IS_Trigger[0]
+ VDD_1V8 VDD_1V8SRAM VDD_3V3_PADS VDD_1V8_PADS VSS
Xpad_ring_inst clk_pad clk reset_pad reset MISO_pad MISO RX_UART_pad RX_UART maip_pad
+ maip MOSI_pad MOSI SCLK_pad SCLK SCS_pad SCS TX_UART_pad TX_UART gpio_pad[7] gpio_pad[6]
+ gpio_pad[5] gpio_pad[4] gpio_pad[3] gpio_pad[2] gpio_pad[1] gpio_pad[0] Reg_GPIO_en[7]
+ Reg_GPIO_en[6] Reg_GPIO_en[5] Reg_GPIO_en[4] Reg_GPIO_en[3] Reg_GPIO_en[2] Reg_GPIO_en[1]
+ Reg_GPIO_en[0] Reg_GPIO_int[7] Reg_GPIO_int[6] Reg_GPIO_int[5] Reg_GPIO_int[4]
+ Reg_GPIO_int[3] Reg_GPIO_int[2] Reg_GPIO_int[1] Reg_GPIO_int[0] Reg_GPIO_out[7]
+ Reg_GPIO_out[6] Reg_GPIO_out[5] Reg_GPIO_out[4] Reg_GPIO_out[3] Reg_GPIO_out[2]
+ Reg_GPIO_out[1] Reg_GPIO_out[0] VDD_1V8_PADS VDD_3V3_PADS VSS pad_ring
Xtop_riscv_soc clk reset MISO RX_UART maip MOSI SCLK SCS TX_UART full_range_level_shifter[7]
+ full_range_level_shifter[6] full_range_level_shifter[5] full_range_level_shifter[4]
+ full_range_level_shifter[3] full_range_level_shifter[2] full_range_level_shifter[1]
+ full_range_level_shifter[0] IS_Val[31] IS_Val[30] IS_Val[29] IS_Val[28] IS_Val[27]
+ IS_Val[26] IS_Val[25] IS_Val[24] IS_Val[23] IS_Val[22] IS_Val[21] IS_Val[20] IS_Val[19]
+ IS_Val[18] IS_Val[17] IS_Val[16] IS_Val[15] IS_Val[14] IS_Val[13] IS_Val[12] IS_Val[11]
+ IS_Val[10] IS_Val[9] IS_Val[8] IS_Val[7] IS_Val[6] IS_Val[5] IS_Val[4] IS_Val[3]
+ IS_Val[2] IS_Val[1] IS_Val[0] IS_Config[31] IS_Config[30] IS_Config[29] IS_Config[28]
+ IS_Config[27] IS_Config[26] IS_Config[25] IS_Config[24] IS_Config[23] IS_Config[22]
+ IS_Config[21] IS_Config[20] IS_Config[19] IS_Config[18] IS_Config[17] IS_Config[16]
+ IS_Config[15] IS_Config[14] IS_Config[13] IS_Config[12] IS_Config[11] IS_Config[10]
+ IS_Config[9] IS_Config[8] IS_Config[7] IS_Config[6] IS_Config[5] IS_Config[4]
+ IS_Config[3] IS_Config[2] IS_Config[1] IS_Config[0] IS_Trigger[3] IS_Trigger[2]
+ IS_Trigger[1] IS_Trigger[0] Reg_GPIO_en[7] Reg_GPIO_en[6] Reg_GPIO_en[5] Reg_GPIO_en[4]
+ Reg_GPIO_en[3] Reg_GPIO_en[2] Reg_GPIO_en[1] Reg_GPIO_en[0] Reg_GPIO_int[7] Reg_GPIO_int[6]
+ Reg_GPIO_int[5] Reg_GPIO_int[4] Reg_GPIO_int[3] Reg_GPIO_int[2] Reg_GPIO_int[1]
+ Reg_GPIO_int[0] Reg_GPIO_out[7] Reg_GPIO_out[6] Reg_GPIO_out[5] Reg_GPIO_out[4]
+ Reg_GPIO_out[3] Reg_GPIO_out[2] Reg_GPIO_out[1] Reg_GPIO_out[0] VSS VDD_1V8SRAM
+ VDD_1V8 topcore_tecriscv
.ENDS
